.hdl "/usr/local/share/xyce/verilog-a/psp103/psp103.va"
.include "/usr/local/src/kestrel/sim/models/sg13g2_psp103_tt.lib"
.include "/usr/local/src/stat-sim/qal/sg13lv_compat.sp"
.OPTIONS TIMEINT METHOD=GEAR RELTOL=1e-6 ABSTOL=1e-15 CHGTOL=1e-17
VHI vhi 0 1.5
VMG1 gn1 0 0
VI1_0 in1_0 0 1.2
VI1_1 in1_1 0 1.2
VI1_2 in1_2 0 1.2
VI1_3 in1_3 0 0
VI1_4 in1_4 0 1.2
VI1_5 in1_5 0 0
VI1_6 in1_6 0 0
VI1_7 in1_7 0 1.2
XP1_0 o1_0 in1_0 rail1 rail1 sg13_lv_pmos w=1.12u l=0.13u
XN1_0 o1_0 in1_0 gn1 gn1 sg13_lv_nmos w=0.74u l=0.13u
CL1_0 o1_0 gn1 2f
XP1_1 o1_1 in1_1 rail1 rail1 sg13_lv_pmos w=1.12u l=0.13u
XN1_1 o1_1 in1_1 gn1 gn1 sg13_lv_nmos w=0.74u l=0.13u
CL1_1 o1_1 gn1 2f
XP1_2 o1_2 in1_2 rail1 rail1 sg13_lv_pmos w=1.12u l=0.13u
XN1_2 o1_2 in1_2 gn1 gn1 sg13_lv_nmos w=0.74u l=0.13u
CL1_2 o1_2 gn1 2f
XP1_3 o1_3 in1_3 rail1 rail1 sg13_lv_pmos w=1.12u l=0.13u
XN1_3 o1_3 in1_3 gn1 gn1 sg13_lv_nmos w=0.74u l=0.13u
CL1_3 o1_3 gn1 2f
XP1_4 o1_4 in1_4 rail1 rail1 sg13_lv_pmos w=1.12u l=0.13u
XN1_4 o1_4 in1_4 gn1 gn1 sg13_lv_nmos w=0.74u l=0.13u
CL1_4 o1_4 gn1 2f
XP1_5 o1_5 in1_5 rail1 rail1 sg13_lv_pmos w=1.12u l=0.13u
XN1_5 o1_5 in1_5 gn1 gn1 sg13_lv_nmos w=0.74u l=0.13u
CL1_5 o1_5 gn1 2f
XP1_6 o1_6 in1_6 rail1 rail1 sg13_lv_pmos w=1.12u l=0.13u
XN1_6 o1_6 in1_6 gn1 gn1 sg13_lv_nmos w=0.74u l=0.13u
CL1_6 o1_6 gn1 2f
XP1_7 o1_7 in1_7 rail1 rail1 sg13_lv_pmos w=1.12u l=0.13u
XN1_7 o1_7 in1_7 gn1 gn1 sg13_lv_nmos w=0.74u l=0.13u
CL1_7 o1_7 gn1 2f
VMG2 gn2 0 0
VSEL2_0 sel_2_0 0 0
XPIS2_0 sb_2_0 sel_2_0 rail2 rail2 sg13_lv_pmos w=1.12u l=0.13u
XNIS2_0 sb_2_0 sel_2_0 gn2 gn2 sg13_lv_nmos w=0.74u l=0.13u
XTN02_0 o1_0 sb_2_0 o2_0 gn2 sg13_lv_nmos w=0.74u l=0.13u
XTP02_0 o1_0 sel_2_0 o2_0 vhi sg13_lv_pmos w=1.12u l=0.13u
XTN12_0 o1_4 sel_2_0 o2_0 gn2 sg13_lv_nmos w=0.74u l=0.13u
XTP12_0 o1_4 sb_2_0 o2_0 vhi sg13_lv_pmos w=1.12u l=0.13u
CL2_0 o2_0 gn2 2f
CSB2_0 sb_2_0 gn2 0.1f
VSEL2_1 sel_2_1 0 0
XPIS2_1 sb_2_1 sel_2_1 rail2 rail2 sg13_lv_pmos w=1.12u l=0.13u
XNIS2_1 sb_2_1 sel_2_1 gn2 gn2 sg13_lv_nmos w=0.74u l=0.13u
XTN02_1 o1_1 sb_2_1 o2_1 gn2 sg13_lv_nmos w=0.74u l=0.13u
XTP02_1 o1_1 sel_2_1 o2_1 vhi sg13_lv_pmos w=1.12u l=0.13u
XTN12_1 o1_5 sel_2_1 o2_1 gn2 sg13_lv_nmos w=0.74u l=0.13u
XTP12_1 o1_5 sb_2_1 o2_1 vhi sg13_lv_pmos w=1.12u l=0.13u
CL2_1 o2_1 gn2 2f
CSB2_1 sb_2_1 gn2 0.1f
VSEL2_2 sel_2_2 0 0
XPIS2_2 sb_2_2 sel_2_2 rail2 rail2 sg13_lv_pmos w=1.12u l=0.13u
XNIS2_2 sb_2_2 sel_2_2 gn2 gn2 sg13_lv_nmos w=0.74u l=0.13u
XTN02_2 o1_2 sb_2_2 o2_2 gn2 sg13_lv_nmos w=0.74u l=0.13u
XTP02_2 o1_2 sel_2_2 o2_2 vhi sg13_lv_pmos w=1.12u l=0.13u
XTN12_2 o1_6 sel_2_2 o2_2 gn2 sg13_lv_nmos w=0.74u l=0.13u
XTP12_2 o1_6 sb_2_2 o2_2 vhi sg13_lv_pmos w=1.12u l=0.13u
CL2_2 o2_2 gn2 2f
CSB2_2 sb_2_2 gn2 0.1f
VSEL2_3 sel_2_3 0 0
XPIS2_3 sb_2_3 sel_2_3 rail2 rail2 sg13_lv_pmos w=1.12u l=0.13u
XNIS2_3 sb_2_3 sel_2_3 gn2 gn2 sg13_lv_nmos w=0.74u l=0.13u
XTN02_3 o1_3 sb_2_3 o2_3 gn2 sg13_lv_nmos w=0.74u l=0.13u
XTP02_3 o1_3 sel_2_3 o2_3 vhi sg13_lv_pmos w=1.12u l=0.13u
XTN12_3 o1_7 sel_2_3 o2_3 gn2 sg13_lv_nmos w=0.74u l=0.13u
XTP12_3 o1_7 sb_2_3 o2_3 vhi sg13_lv_pmos w=1.12u l=0.13u
CL2_3 o2_3 gn2 2f
CSB2_3 sb_2_3 gn2 0.1f
VSEL2_4 sel_2_4 0 0
XPIS2_4 sb_2_4 sel_2_4 rail2 rail2 sg13_lv_pmos w=1.12u l=0.13u
XNIS2_4 sb_2_4 sel_2_4 gn2 gn2 sg13_lv_nmos w=0.74u l=0.13u
XTN02_4 o1_4 sb_2_4 o2_4 gn2 sg13_lv_nmos w=0.74u l=0.13u
XTP02_4 o1_4 sel_2_4 o2_4 vhi sg13_lv_pmos w=1.12u l=0.13u
XTN12_4 o1_0 sel_2_4 o2_4 gn2 sg13_lv_nmos w=0.74u l=0.13u
XTP12_4 o1_0 sb_2_4 o2_4 vhi sg13_lv_pmos w=1.12u l=0.13u
CL2_4 o2_4 gn2 2f
CSB2_4 sb_2_4 gn2 0.1f
VSEL2_5 sel_2_5 0 0
XPIS2_5 sb_2_5 sel_2_5 rail2 rail2 sg13_lv_pmos w=1.12u l=0.13u
XNIS2_5 sb_2_5 sel_2_5 gn2 gn2 sg13_lv_nmos w=0.74u l=0.13u
XTN02_5 o1_5 sb_2_5 o2_5 gn2 sg13_lv_nmos w=0.74u l=0.13u
XTP02_5 o1_5 sel_2_5 o2_5 vhi sg13_lv_pmos w=1.12u l=0.13u
XTN12_5 o1_1 sel_2_5 o2_5 gn2 sg13_lv_nmos w=0.74u l=0.13u
XTP12_5 o1_1 sb_2_5 o2_5 vhi sg13_lv_pmos w=1.12u l=0.13u
CL2_5 o2_5 gn2 2f
CSB2_5 sb_2_5 gn2 0.1f
VSEL2_6 sel_2_6 0 0
XPIS2_6 sb_2_6 sel_2_6 rail2 rail2 sg13_lv_pmos w=1.12u l=0.13u
XNIS2_6 sb_2_6 sel_2_6 gn2 gn2 sg13_lv_nmos w=0.74u l=0.13u
XTN02_6 o1_6 sb_2_6 o2_6 gn2 sg13_lv_nmos w=0.74u l=0.13u
XTP02_6 o1_6 sel_2_6 o2_6 vhi sg13_lv_pmos w=1.12u l=0.13u
XTN12_6 o1_2 sel_2_6 o2_6 gn2 sg13_lv_nmos w=0.74u l=0.13u
XTP12_6 o1_2 sb_2_6 o2_6 vhi sg13_lv_pmos w=1.12u l=0.13u
CL2_6 o2_6 gn2 2f
CSB2_6 sb_2_6 gn2 0.1f
VSEL2_7 sel_2_7 0 0
XPIS2_7 sb_2_7 sel_2_7 rail2 rail2 sg13_lv_pmos w=1.12u l=0.13u
XNIS2_7 sb_2_7 sel_2_7 gn2 gn2 sg13_lv_nmos w=0.74u l=0.13u
XTN02_7 o1_7 sb_2_7 o2_7 gn2 sg13_lv_nmos w=0.74u l=0.13u
XTP02_7 o1_7 sel_2_7 o2_7 vhi sg13_lv_pmos w=1.12u l=0.13u
XTN12_7 o1_3 sel_2_7 o2_7 gn2 sg13_lv_nmos w=0.74u l=0.13u
XTP12_7 o1_3 sb_2_7 o2_7 vhi sg13_lv_pmos w=1.12u l=0.13u
CL2_7 o2_7 gn2 2f
CSB2_7 sb_2_7 gn2 0.1f
VMG3 gn3 0 0
XP3_0 o3_0 o2_0 rail3 rail3 sg13_lv_pmos w=1.12u l=0.13u
XN3_0 o3_0 o2_0 gn3 gn3 sg13_lv_nmos w=0.74u l=0.13u
CL3_0 o3_0 gn3 2f
XP3_1 o3_1 o2_1 rail3 rail3 sg13_lv_pmos w=1.12u l=0.13u
XN3_1 o3_1 o2_1 gn3 gn3 sg13_lv_nmos w=0.74u l=0.13u
CL3_1 o3_1 gn3 2f
XP3_2 o3_2 o2_2 rail3 rail3 sg13_lv_pmos w=1.12u l=0.13u
XN3_2 o3_2 o2_2 gn3 gn3 sg13_lv_nmos w=0.74u l=0.13u
CL3_2 o3_2 gn3 2f
XP3_3 o3_3 o2_3 rail3 rail3 sg13_lv_pmos w=1.12u l=0.13u
XN3_3 o3_3 o2_3 gn3 gn3 sg13_lv_nmos w=0.74u l=0.13u
CL3_3 o3_3 gn3 2f
XP3_4 o3_4 o2_4 rail3 rail3 sg13_lv_pmos w=1.12u l=0.13u
XN3_4 o3_4 o2_4 gn3 gn3 sg13_lv_nmos w=0.74u l=0.13u
CL3_4 o3_4 gn3 2f
XP3_5 o3_5 o2_5 rail3 rail3 sg13_lv_pmos w=1.12u l=0.13u
XN3_5 o3_5 o2_5 gn3 gn3 sg13_lv_nmos w=0.74u l=0.13u
CL3_5 o3_5 gn3 2f
XP3_6 o3_6 o2_6 rail3 rail3 sg13_lv_pmos w=1.12u l=0.13u
XN3_6 o3_6 o2_6 gn3 gn3 sg13_lv_nmos w=0.74u l=0.13u
CL3_6 o3_6 gn3 2f
XP3_7 o3_7 o2_7 rail3 rail3 sg13_lv_pmos w=1.12u l=0.13u
XN3_7 o3_7 o2_7 gn3 gn3 sg13_lv_nmos w=0.74u l=0.13u
CL3_7 o3_7 gn3 2f
VMG4 gn4 0 0
VSEL4_0 sel_4_0 0 0
XPIS4_0 sb_4_0 sel_4_0 rail4 rail4 sg13_lv_pmos w=1.12u l=0.13u
XNIS4_0 sb_4_0 sel_4_0 gn4 gn4 sg13_lv_nmos w=0.74u l=0.13u
XTN04_0 o3_0 sb_4_0 o4_0 gn4 sg13_lv_nmos w=0.74u l=0.13u
XTP04_0 o3_0 sel_4_0 o4_0 vhi sg13_lv_pmos w=1.12u l=0.13u
XTN14_0 o3_4 sel_4_0 o4_0 gn4 sg13_lv_nmos w=0.74u l=0.13u
XTP14_0 o3_4 sb_4_0 o4_0 vhi sg13_lv_pmos w=1.12u l=0.13u
CL4_0 o4_0 gn4 2f
CSB4_0 sb_4_0 gn4 0.1f
VSEL4_1 sel_4_1 0 0
XPIS4_1 sb_4_1 sel_4_1 rail4 rail4 sg13_lv_pmos w=1.12u l=0.13u
XNIS4_1 sb_4_1 sel_4_1 gn4 gn4 sg13_lv_nmos w=0.74u l=0.13u
XTN04_1 o3_1 sb_4_1 o4_1 gn4 sg13_lv_nmos w=0.74u l=0.13u
XTP04_1 o3_1 sel_4_1 o4_1 vhi sg13_lv_pmos w=1.12u l=0.13u
XTN14_1 o3_5 sel_4_1 o4_1 gn4 sg13_lv_nmos w=0.74u l=0.13u
XTP14_1 o3_5 sb_4_1 o4_1 vhi sg13_lv_pmos w=1.12u l=0.13u
CL4_1 o4_1 gn4 2f
CSB4_1 sb_4_1 gn4 0.1f
VSEL4_2 sel_4_2 0 0
XPIS4_2 sb_4_2 sel_4_2 rail4 rail4 sg13_lv_pmos w=1.12u l=0.13u
XNIS4_2 sb_4_2 sel_4_2 gn4 gn4 sg13_lv_nmos w=0.74u l=0.13u
XTN04_2 o3_2 sb_4_2 o4_2 gn4 sg13_lv_nmos w=0.74u l=0.13u
XTP04_2 o3_2 sel_4_2 o4_2 vhi sg13_lv_pmos w=1.12u l=0.13u
XTN14_2 o3_6 sel_4_2 o4_2 gn4 sg13_lv_nmos w=0.74u l=0.13u
XTP14_2 o3_6 sb_4_2 o4_2 vhi sg13_lv_pmos w=1.12u l=0.13u
CL4_2 o4_2 gn4 2f
CSB4_2 sb_4_2 gn4 0.1f
VSEL4_3 sel_4_3 0 0
XPIS4_3 sb_4_3 sel_4_3 rail4 rail4 sg13_lv_pmos w=1.12u l=0.13u
XNIS4_3 sb_4_3 sel_4_3 gn4 gn4 sg13_lv_nmos w=0.74u l=0.13u
XTN04_3 o3_3 sb_4_3 o4_3 gn4 sg13_lv_nmos w=0.74u l=0.13u
XTP04_3 o3_3 sel_4_3 o4_3 vhi sg13_lv_pmos w=1.12u l=0.13u
XTN14_3 o3_7 sel_4_3 o4_3 gn4 sg13_lv_nmos w=0.74u l=0.13u
XTP14_3 o3_7 sb_4_3 o4_3 vhi sg13_lv_pmos w=1.12u l=0.13u
CL4_3 o4_3 gn4 2f
CSB4_3 sb_4_3 gn4 0.1f
VSEL4_4 sel_4_4 0 0
XPIS4_4 sb_4_4 sel_4_4 rail4 rail4 sg13_lv_pmos w=1.12u l=0.13u
XNIS4_4 sb_4_4 sel_4_4 gn4 gn4 sg13_lv_nmos w=0.74u l=0.13u
XTN04_4 o3_4 sb_4_4 o4_4 gn4 sg13_lv_nmos w=0.74u l=0.13u
XTP04_4 o3_4 sel_4_4 o4_4 vhi sg13_lv_pmos w=1.12u l=0.13u
XTN14_4 o3_0 sel_4_4 o4_4 gn4 sg13_lv_nmos w=0.74u l=0.13u
XTP14_4 o3_0 sb_4_4 o4_4 vhi sg13_lv_pmos w=1.12u l=0.13u
CL4_4 o4_4 gn4 2f
CSB4_4 sb_4_4 gn4 0.1f
VSEL4_5 sel_4_5 0 0
XPIS4_5 sb_4_5 sel_4_5 rail4 rail4 sg13_lv_pmos w=1.12u l=0.13u
XNIS4_5 sb_4_5 sel_4_5 gn4 gn4 sg13_lv_nmos w=0.74u l=0.13u
XTN04_5 o3_5 sb_4_5 o4_5 gn4 sg13_lv_nmos w=0.74u l=0.13u
XTP04_5 o3_5 sel_4_5 o4_5 vhi sg13_lv_pmos w=1.12u l=0.13u
XTN14_5 o3_1 sel_4_5 o4_5 gn4 sg13_lv_nmos w=0.74u l=0.13u
XTP14_5 o3_1 sb_4_5 o4_5 vhi sg13_lv_pmos w=1.12u l=0.13u
CL4_5 o4_5 gn4 2f
CSB4_5 sb_4_5 gn4 0.1f
VSEL4_6 sel_4_6 0 0
XPIS4_6 sb_4_6 sel_4_6 rail4 rail4 sg13_lv_pmos w=1.12u l=0.13u
XNIS4_6 sb_4_6 sel_4_6 gn4 gn4 sg13_lv_nmos w=0.74u l=0.13u
XTN04_6 o3_6 sb_4_6 o4_6 gn4 sg13_lv_nmos w=0.74u l=0.13u
XTP04_6 o3_6 sel_4_6 o4_6 vhi sg13_lv_pmos w=1.12u l=0.13u
XTN14_6 o3_2 sel_4_6 o4_6 gn4 sg13_lv_nmos w=0.74u l=0.13u
XTP14_6 o3_2 sb_4_6 o4_6 vhi sg13_lv_pmos w=1.12u l=0.13u
CL4_6 o4_6 gn4 2f
CSB4_6 sb_4_6 gn4 0.1f
VSEL4_7 sel_4_7 0 0
XPIS4_7 sb_4_7 sel_4_7 rail4 rail4 sg13_lv_pmos w=1.12u l=0.13u
XNIS4_7 sb_4_7 sel_4_7 gn4 gn4 sg13_lv_nmos w=0.74u l=0.13u
XTN04_7 o3_7 sb_4_7 o4_7 gn4 sg13_lv_nmos w=0.74u l=0.13u
XTP04_7 o3_7 sel_4_7 o4_7 vhi sg13_lv_pmos w=1.12u l=0.13u
XTN14_7 o3_3 sel_4_7 o4_7 gn4 sg13_lv_nmos w=0.74u l=0.13u
XTP14_7 o3_3 sb_4_7 o4_7 vhi sg13_lv_pmos w=1.12u l=0.13u
CL4_7 o4_7 gn4 2f
CSB4_7 sb_4_7 gn4 0.1f
CT1 tnk1 0 215.874f
L1 tnk1 mid1 15n
R1 mid1 sw1 10
XSWN1 sw1 gt1 rail1 0 sg13_lv_nmos w=10u l=0.13u
XSWP1 sw1 gtp1 rail1 vhi sg13_lv_pmos w=20u l=0.13u
XPK1 sw1 pk1 tnk1 tnk1 sg13_lv_nmos w=2u l=0.13u
CT2 tnk2 0 215.874f
L2 tnk2 mid2 15n
R2 mid2 sw2 10
XSWN2 sw2 gt2 rail2 0 sg13_lv_nmos w=10u l=0.13u
XSWP2 sw2 gtp2 rail2 vhi sg13_lv_pmos w=20u l=0.13u
XPK2 sw2 pk2 tnk2 tnk2 sg13_lv_nmos w=2u l=0.13u
CT3 tnk3 0 215.874f
L3 tnk3 mid3 15n
R3 mid3 sw3 10
XSWN3 sw3 gt3 rail3 0 sg13_lv_nmos w=10u l=0.13u
XSWP3 sw3 gtp3 rail3 vhi sg13_lv_pmos w=20u l=0.13u
XPK3 sw3 pk3 tnk3 tnk3 sg13_lv_nmos w=2u l=0.13u
CT4 tnk4 0 215.874f
L4 tnk4 mid4 15n
R4 mid4 sw4 10
XSWN4 sw4 gt4 rail4 0 sg13_lv_nmos w=10u l=0.13u
XSWP4 sw4 gtp4 rail4 vhi sg13_lv_pmos w=20u l=0.13u
XPK4 sw4 pk4 tnk4 tnk4 sg13_lv_nmos w=2u l=0.13u
VGT1 gt1 0 PWL(0 0 198p 0 200p 1.5 309.588p 1.5 311.588p 0 998p 0 1000p 1.5 8661.98p 1.5)
VGTP1 gtp1 0 PWL(0 1.5 198p 1.5 200p 0 309.588p 0 311.588p 1.5 998p 1.5 1000p 0 8661.98p 0)
VPK1 pk1 0 PWL(0 1.5 198p 1.5 200p 0 309.588p 0 311.588p 1.5 998p 1.5 1000p 0 8661.98p 0)
VGT2 gt2 0 PWL(0 0 398p 0 400p 1.5 510.104p 1.5 512.104p 0)
VGTP2 gtp2 0 PWL(0 1.5 398p 1.5 400p 0 510.104p 0 512.104p 1.5)
VPK2 pk2 0 PWL(0 1.5 398p 1.5 400p 0 510.104p 0 512.104p 1.5)
VGT3 gt3 0 PWL(0 0 598p 0 600p 1.5 709.018p 1.5 711.018p 0)
VGTP3 gtp3 0 PWL(0 1.5 598p 1.5 600p 0 709.018p 0 711.018p 1.5)
VPK3 pk3 0 PWL(0 1.5 598p 1.5 600p 0 709.018p 0 711.018p 1.5)
VGT4 gt4 0 PWL(0 0 798p 0 800p 1.5 910.108p 1.5 912.108p 0)
VGTP4 gtp4 0 PWL(0 1.5 798p 1.5 800p 0 910.108p 0 912.108p 1.5)
VPK4 pk4 0 PWL(0 1.5 798p 1.5 800p 0 910.108p 0 912.108p 1.5)
.ic V(tnk1)=0.7 V(rail1)=0 V(sw1)=0.7 V(tnk2)=0.7 V(rail2)=0 V(sw2)=0.7 V(tnk3)=0.7 V(rail3)=0 V(sw3)=0.7 V(tnk4)=0.7 V(rail4)=0 V(sw4)=0.7
.tran 0.1p 1510.87p 0 0.25p
.print tran I(L1) I(L2) I(L3) I(L4) V(rail1) V(rail2) V(rail3) V(rail4) V(tnk1) V(tnk2) V(tnk3) V(tnk4)
.end
