* SKEPT leak deck, junction arm = def
* junction instance params appended to every M-card: '<PSP103 DEFAULTS>'
.hdl "/usr/local/share/xyce/verilog-a/psp103/psp103.va"
.include "/usr/local/src/kestrel/sim/models/sg13g2_psp103_tt.lib"
.OPTIONS TIMEINT METHOD=GEAR RELTOL=1e-6 ABSTOL=1e-17 CHGTOL=1e-19
* ---- rail 0.5217 V
VRAILr0p5217 railr0p5217 0 0.521700
VBNr0p5217 qnr0p5217 0 0.521700
CNr0p5217 qnr0p5217 0 2f
MNr0p5217 qnr0p5217 0 0 0 sg13g2_nmos W=0.74u L=0.13u
VBPr0p5217 qpr0p5217 0 0.521700
CPr0p5217 qpr0p5217 0 2f
MPr0p5217 qpr0p5217 railr0p5217 railr0p5217 railr0p5217 sg13g2_pmos W=1.12u L=0.13u
VBLr0p5217 qlr0p5217 0 0.0
CLOr0p5217 qlr0p5217 0 2f
MLPr0p5217 qlr0p5217 railr0p5217 railr0p5217 railr0p5217 sg13g2_pmos W=1.12u L=0.13u
MLNr0p5217 qlr0p5217 0 0 0 sg13g2_nmos W=0.74u L=0.13u
VBBr0p5217 qbr0p5217 0 0.521700
CBr0p5217 qbr0p5217 0 2f
MBNr0p5217 qbr0p5217 0 0 0 sg13g2_nmos W=0.74u L=0.13u
MBPr0p5217 qbr0p5217 railr0p5217 railr0p5217 railr0p5217 sg13g2_pmos W=1.12u L=0.13u
VBZr0p5217 qzr0p5217 0 0.521700
CZr0p5217 qzr0p5217 0 2f
VBRr0p5217 qrr0p5217 0 0.521700
CRr0p5217 qrr0p5217 0 2f
RRr0p5217 qrr0p5217 0 1e12
VNEGr0p5217 vnegr0p5217 0 -0.3
VBHr0p5217 qhr0p5217 0 0.521700
CHr0p5217 qhr0p5217 0 2f
MHr0p5217 qhr0p5217 vnegr0p5217 0 0 sg13g2_nmos W=0.74u L=0.13u
VBKr0p5217 qkr0p5217 0 0.521700
CKr0p5217 qkr0p5217 0 2f
MKNr0p5217 qkr0p5217 0 0 0 sg13g2_nmos W=0.74u L=0.13u
MKPr0p5217 qkr0p5217 railr0p5217 railr0p5217 railr0p5217 sg13g2_pmos W=1.12u L=0.13u
MSIPr0p5217 kbr0p5217 qkr0p5217 railr0p5217 railr0p5217 sg13g2_pmos W=1.12u L=0.13u
MSINr0p5217 kbr0p5217 qkr0p5217 0 0 sg13g2_nmos W=0.74u L=0.13u
CKBr0p5217 kbr0p5217 0 2f
MSKPr0p5217 qkr0p5217 kbr0p5217 railr0p5217 railr0p5217 sg13g2_pmos W=1.12u L=0.13u
* ---- rail 0.5594 V
VRAILr0p5594 railr0p5594 0 0.559400
VBNr0p5594 qnr0p5594 0 0.559400
CNr0p5594 qnr0p5594 0 2f
MNr0p5594 qnr0p5594 0 0 0 sg13g2_nmos W=0.74u L=0.13u
VBPr0p5594 qpr0p5594 0 0.559400
CPr0p5594 qpr0p5594 0 2f
MPr0p5594 qpr0p5594 railr0p5594 railr0p5594 railr0p5594 sg13g2_pmos W=1.12u L=0.13u
VBLr0p5594 qlr0p5594 0 0.0
CLOr0p5594 qlr0p5594 0 2f
MLPr0p5594 qlr0p5594 railr0p5594 railr0p5594 railr0p5594 sg13g2_pmos W=1.12u L=0.13u
MLNr0p5594 qlr0p5594 0 0 0 sg13g2_nmos W=0.74u L=0.13u
VBBr0p5594 qbr0p5594 0 0.559400
CBr0p5594 qbr0p5594 0 2f
MBNr0p5594 qbr0p5594 0 0 0 sg13g2_nmos W=0.74u L=0.13u
MBPr0p5594 qbr0p5594 railr0p5594 railr0p5594 railr0p5594 sg13g2_pmos W=1.12u L=0.13u
VBZr0p5594 qzr0p5594 0 0.559400
CZr0p5594 qzr0p5594 0 2f
VBRr0p5594 qrr0p5594 0 0.559400
CRr0p5594 qrr0p5594 0 2f
RRr0p5594 qrr0p5594 0 1e12
VNEGr0p5594 vnegr0p5594 0 -0.3
VBHr0p5594 qhr0p5594 0 0.559400
CHr0p5594 qhr0p5594 0 2f
MHr0p5594 qhr0p5594 vnegr0p5594 0 0 sg13g2_nmos W=0.74u L=0.13u
VBKr0p5594 qkr0p5594 0 0.559400
CKr0p5594 qkr0p5594 0 2f
MKNr0p5594 qkr0p5594 0 0 0 sg13g2_nmos W=0.74u L=0.13u
MKPr0p5594 qkr0p5594 railr0p5594 railr0p5594 railr0p5594 sg13g2_pmos W=1.12u L=0.13u
MSIPr0p5594 kbr0p5594 qkr0p5594 railr0p5594 railr0p5594 sg13g2_pmos W=1.12u L=0.13u
MSINr0p5594 kbr0p5594 qkr0p5594 0 0 sg13g2_nmos W=0.74u L=0.13u
CKBr0p5594 kbr0p5594 0 2f
MSKPr0p5594 qkr0p5594 kbr0p5594 railr0p5594 railr0p5594 sg13g2_pmos W=1.12u L=0.13u
* ---- rail 0.6077 V
VRAILr0p6077 railr0p6077 0 0.607700
VBNr0p6077 qnr0p6077 0 0.607700
CNr0p6077 qnr0p6077 0 2f
MNr0p6077 qnr0p6077 0 0 0 sg13g2_nmos W=0.74u L=0.13u
VBPr0p6077 qpr0p6077 0 0.607700
CPr0p6077 qpr0p6077 0 2f
MPr0p6077 qpr0p6077 railr0p6077 railr0p6077 railr0p6077 sg13g2_pmos W=1.12u L=0.13u
VBLr0p6077 qlr0p6077 0 0.0
CLOr0p6077 qlr0p6077 0 2f
MLPr0p6077 qlr0p6077 railr0p6077 railr0p6077 railr0p6077 sg13g2_pmos W=1.12u L=0.13u
MLNr0p6077 qlr0p6077 0 0 0 sg13g2_nmos W=0.74u L=0.13u
VBBr0p6077 qbr0p6077 0 0.607700
CBr0p6077 qbr0p6077 0 2f
MBNr0p6077 qbr0p6077 0 0 0 sg13g2_nmos W=0.74u L=0.13u
MBPr0p6077 qbr0p6077 railr0p6077 railr0p6077 railr0p6077 sg13g2_pmos W=1.12u L=0.13u
VBZr0p6077 qzr0p6077 0 0.607700
CZr0p6077 qzr0p6077 0 2f
VBRr0p6077 qrr0p6077 0 0.607700
CRr0p6077 qrr0p6077 0 2f
RRr0p6077 qrr0p6077 0 1e12
VNEGr0p6077 vnegr0p6077 0 -0.3
VBHr0p6077 qhr0p6077 0 0.607700
CHr0p6077 qhr0p6077 0 2f
MHr0p6077 qhr0p6077 vnegr0p6077 0 0 sg13g2_nmos W=0.74u L=0.13u
VBKr0p6077 qkr0p6077 0 0.607700
CKr0p6077 qkr0p6077 0 2f
MKNr0p6077 qkr0p6077 0 0 0 sg13g2_nmos W=0.74u L=0.13u
MKPr0p6077 qkr0p6077 railr0p6077 railr0p6077 railr0p6077 sg13g2_pmos W=1.12u L=0.13u
MSIPr0p6077 kbr0p6077 qkr0p6077 railr0p6077 railr0p6077 sg13g2_pmos W=1.12u L=0.13u
MSINr0p6077 kbr0p6077 qkr0p6077 0 0 sg13g2_nmos W=0.74u L=0.13u
CKBr0p6077 kbr0p6077 0 2f
MSKPr0p6077 qkr0p6077 kbr0p6077 railr0p6077 railr0p6077 sg13g2_pmos W=1.12u L=0.13u
* ---- rail 0.7000 V
VRAILr0p7000 railr0p7000 0 0.700000
VBNr0p7000 qnr0p7000 0 0.700000
CNr0p7000 qnr0p7000 0 2f
MNr0p7000 qnr0p7000 0 0 0 sg13g2_nmos W=0.74u L=0.13u
VBPr0p7000 qpr0p7000 0 0.700000
CPr0p7000 qpr0p7000 0 2f
MPr0p7000 qpr0p7000 railr0p7000 railr0p7000 railr0p7000 sg13g2_pmos W=1.12u L=0.13u
VBLr0p7000 qlr0p7000 0 0.0
CLOr0p7000 qlr0p7000 0 2f
MLPr0p7000 qlr0p7000 railr0p7000 railr0p7000 railr0p7000 sg13g2_pmos W=1.12u L=0.13u
MLNr0p7000 qlr0p7000 0 0 0 sg13g2_nmos W=0.74u L=0.13u
VBBr0p7000 qbr0p7000 0 0.700000
CBr0p7000 qbr0p7000 0 2f
MBNr0p7000 qbr0p7000 0 0 0 sg13g2_nmos W=0.74u L=0.13u
MBPr0p7000 qbr0p7000 railr0p7000 railr0p7000 railr0p7000 sg13g2_pmos W=1.12u L=0.13u
VBZr0p7000 qzr0p7000 0 0.700000
CZr0p7000 qzr0p7000 0 2f
VBRr0p7000 qrr0p7000 0 0.700000
CRr0p7000 qrr0p7000 0 2f
RRr0p7000 qrr0p7000 0 1e12
VNEGr0p7000 vnegr0p7000 0 -0.3
VBHr0p7000 qhr0p7000 0 0.700000
CHr0p7000 qhr0p7000 0 2f
MHr0p7000 qhr0p7000 vnegr0p7000 0 0 sg13g2_nmos W=0.74u L=0.13u
VBKr0p7000 qkr0p7000 0 0.700000
CKr0p7000 qkr0p7000 0 2f
MKNr0p7000 qkr0p7000 0 0 0 sg13g2_nmos W=0.74u L=0.13u
MKPr0p7000 qkr0p7000 railr0p7000 railr0p7000 railr0p7000 sg13g2_pmos W=1.12u L=0.13u
MSIPr0p7000 kbr0p7000 qkr0p7000 railr0p7000 railr0p7000 sg13g2_pmos W=1.12u L=0.13u
MSINr0p7000 kbr0p7000 qkr0p7000 0 0 sg13g2_nmos W=0.74u L=0.13u
CKBr0p7000 kbr0p7000 0 2f
MSKPr0p7000 qkr0p7000 kbr0p7000 railr0p7000 railr0p7000 sg13g2_pmos W=1.12u L=0.13u
* ---- rail 1.0000 V
VRAILr1p0000 railr1p0000 0 1.000000
VBNr1p0000 qnr1p0000 0 1.000000
CNr1p0000 qnr1p0000 0 2f
MNr1p0000 qnr1p0000 0 0 0 sg13g2_nmos W=0.74u L=0.13u
VBPr1p0000 qpr1p0000 0 1.000000
CPr1p0000 qpr1p0000 0 2f
MPr1p0000 qpr1p0000 railr1p0000 railr1p0000 railr1p0000 sg13g2_pmos W=1.12u L=0.13u
VBLr1p0000 qlr1p0000 0 0.0
CLOr1p0000 qlr1p0000 0 2f
MLPr1p0000 qlr1p0000 railr1p0000 railr1p0000 railr1p0000 sg13g2_pmos W=1.12u L=0.13u
MLNr1p0000 qlr1p0000 0 0 0 sg13g2_nmos W=0.74u L=0.13u
VBBr1p0000 qbr1p0000 0 1.000000
CBr1p0000 qbr1p0000 0 2f
MBNr1p0000 qbr1p0000 0 0 0 sg13g2_nmos W=0.74u L=0.13u
MBPr1p0000 qbr1p0000 railr1p0000 railr1p0000 railr1p0000 sg13g2_pmos W=1.12u L=0.13u
VBZr1p0000 qzr1p0000 0 1.000000
CZr1p0000 qzr1p0000 0 2f
VBRr1p0000 qrr1p0000 0 1.000000
CRr1p0000 qrr1p0000 0 2f
RRr1p0000 qrr1p0000 0 1e12
VNEGr1p0000 vnegr1p0000 0 -0.3
VBHr1p0000 qhr1p0000 0 1.000000
CHr1p0000 qhr1p0000 0 2f
MHr1p0000 qhr1p0000 vnegr1p0000 0 0 sg13g2_nmos W=0.74u L=0.13u
VBKr1p0000 qkr1p0000 0 1.000000
CKr1p0000 qkr1p0000 0 2f
MKNr1p0000 qkr1p0000 0 0 0 sg13g2_nmos W=0.74u L=0.13u
MKPr1p0000 qkr1p0000 railr1p0000 railr1p0000 railr1p0000 sg13g2_pmos W=1.12u L=0.13u
MSIPr1p0000 kbr1p0000 qkr1p0000 railr1p0000 railr1p0000 sg13g2_pmos W=1.12u L=0.13u
MSINr1p0000 kbr1p0000 qkr1p0000 0 0 sg13g2_nmos W=0.74u L=0.13u
CKBr1p0000 kbr1p0000 0 2f
MSKPr1p0000 qkr1p0000 kbr1p0000 railr1p0000 railr1p0000 sg13g2_pmos W=1.12u L=0.13u
.tran 0.2n 60n 0 2n
.print tran format=noindex I(VBNr0p5217) I(VBPr0p5217) I(VBLr0p5217) I(VBBr0p5217) I(VBZr0p5217) I(VBRr0p5217) I(VBHr0p5217) I(VBKr0p5217) V(kbr0p5217) I(VBNr0p5594) I(VBPr0p5594) I(VBLr0p5594) I(VBBr0p5594) I(VBZr0p5594) I(VBRr0p5594) I(VBHr0p5594) I(VBKr0p5594) V(kbr0p5594) I(VBNr0p6077) I(VBPr0p6077) I(VBLr0p6077) I(VBBr0p6077) I(VBZr0p6077) I(VBRr0p6077) I(VBHr0p6077) I(VBKr0p6077) V(kbr0p6077) I(VBNr0p7000) I(VBPr0p7000) I(VBLr0p7000) I(VBBr0p7000) I(VBZr0p7000) I(VBRr0p7000) I(VBHr0p7000) I(VBKr0p7000) V(kbr0p7000) I(VBNr1p0000) I(VBPr1p0000) I(VBLr1p0000) I(VBBr1p0000) I(VBZr1p0000) I(VBRr1p0000) I(VBHr1p0000) I(VBKr1p0000) V(kbr1p0000)
.end
