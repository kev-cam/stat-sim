* SKEPT junction-term isolation, pMOS 1.12u LOW node
.hdl "/usr/local/share/xyce/verilog-a/psp103/psp103.va"
.include "/usr/local/src/kestrel/sim/models/sg13g2_psp103_tt.lib"
.OPTIONS TIMEINT METHOD=GEAR RELTOL=1e-6 ABSTOL=1e-17 CHGTOL=1e-19
* ---- rail 0.5217
VRAILr0p5217 railr0p5217 0 0.521700
VBRr0p5217 qrr0p5217 0 0.521700
RRr0p5217 qrr0p5217 0 1e12
VBar0p5217 qar0p5217 0 0.0
Car0p5217 qar0p5217 0 2f
Mar0p5217 qar0p5217 railr0p5217 railr0p5217 railr0p5217 sg13g2_pmos W=1.12u L=0.13u AD=1e-12 AS=1e-12 PD=2.16e-6 PS=2.16e-6
VBbr0p5217 qbr0p5217 0 0.0
Cbr0p5217 qbr0p5217 0 2f
Mbr0p5217 qbr0p5217 railr0p5217 railr0p5217 railr0p5217 sg13g2_pmos W=1.12u L=0.13u AD=0.2516e-12 AS=0.2516e-12 PD=1e-6 PS=1e-6
VBcr0p5217 qcr0p5217 0 0.0
Ccr0p5217 qcr0p5217 0 2f
Mcr0p5217 qcr0p5217 railr0p5217 railr0p5217 railr0p5217 sg13g2_pmos W=1.12u L=0.13u AD=0.3808e-12 AS=0.3808e-12 PD=2.92e-6 PS=2.92e-6
* ---- rail 0.5594
VRAILr0p5594 railr0p5594 0 0.559400
VBRr0p5594 qrr0p5594 0 0.559400
RRr0p5594 qrr0p5594 0 1e12
VBar0p5594 qar0p5594 0 0.0
Car0p5594 qar0p5594 0 2f
Mar0p5594 qar0p5594 railr0p5594 railr0p5594 railr0p5594 sg13g2_pmos W=1.12u L=0.13u AD=1e-12 AS=1e-12 PD=2.16e-6 PS=2.16e-6
VBbr0p5594 qbr0p5594 0 0.0
Cbr0p5594 qbr0p5594 0 2f
Mbr0p5594 qbr0p5594 railr0p5594 railr0p5594 railr0p5594 sg13g2_pmos W=1.12u L=0.13u AD=0.2516e-12 AS=0.2516e-12 PD=1e-6 PS=1e-6
VBcr0p5594 qcr0p5594 0 0.0
Ccr0p5594 qcr0p5594 0 2f
Mcr0p5594 qcr0p5594 railr0p5594 railr0p5594 railr0p5594 sg13g2_pmos W=1.12u L=0.13u AD=0.3808e-12 AS=0.3808e-12 PD=2.92e-6 PS=2.92e-6
* ---- rail 0.6077
VRAILr0p6077 railr0p6077 0 0.607700
VBRr0p6077 qrr0p6077 0 0.607700
RRr0p6077 qrr0p6077 0 1e12
VBar0p6077 qar0p6077 0 0.0
Car0p6077 qar0p6077 0 2f
Mar0p6077 qar0p6077 railr0p6077 railr0p6077 railr0p6077 sg13g2_pmos W=1.12u L=0.13u AD=1e-12 AS=1e-12 PD=2.16e-6 PS=2.16e-6
VBbr0p6077 qbr0p6077 0 0.0
Cbr0p6077 qbr0p6077 0 2f
Mbr0p6077 qbr0p6077 railr0p6077 railr0p6077 railr0p6077 sg13g2_pmos W=1.12u L=0.13u AD=0.2516e-12 AS=0.2516e-12 PD=1e-6 PS=1e-6
VBcr0p6077 qcr0p6077 0 0.0
Ccr0p6077 qcr0p6077 0 2f
Mcr0p6077 qcr0p6077 railr0p6077 railr0p6077 railr0p6077 sg13g2_pmos W=1.12u L=0.13u AD=0.3808e-12 AS=0.3808e-12 PD=2.92e-6 PS=2.92e-6
* ---- rail 0.7000
VRAILr0p7000 railr0p7000 0 0.700000
VBRr0p7000 qrr0p7000 0 0.700000
RRr0p7000 qrr0p7000 0 1e12
VBar0p7000 qar0p7000 0 0.0
Car0p7000 qar0p7000 0 2f
Mar0p7000 qar0p7000 railr0p7000 railr0p7000 railr0p7000 sg13g2_pmos W=1.12u L=0.13u AD=1e-12 AS=1e-12 PD=2.16e-6 PS=2.16e-6
VBbr0p7000 qbr0p7000 0 0.0
Cbr0p7000 qbr0p7000 0 2f
Mbr0p7000 qbr0p7000 railr0p7000 railr0p7000 railr0p7000 sg13g2_pmos W=1.12u L=0.13u AD=0.2516e-12 AS=0.2516e-12 PD=1e-6 PS=1e-6
VBcr0p7000 qcr0p7000 0 0.0
Ccr0p7000 qcr0p7000 0 2f
Mcr0p7000 qcr0p7000 railr0p7000 railr0p7000 railr0p7000 sg13g2_pmos W=1.12u L=0.13u AD=0.3808e-12 AS=0.3808e-12 PD=2.92e-6 PS=2.92e-6
* ---- rail 1.0000
VRAILr1p0000 railr1p0000 0 1.000000
VBRr1p0000 qrr1p0000 0 1.000000
RRr1p0000 qrr1p0000 0 1e12
VBar1p0000 qar1p0000 0 0.0
Car1p0000 qar1p0000 0 2f
Mar1p0000 qar1p0000 railr1p0000 railr1p0000 railr1p0000 sg13g2_pmos W=1.12u L=0.13u AD=1e-12 AS=1e-12 PD=2.16e-6 PS=2.16e-6
VBbr1p0000 qbr1p0000 0 0.0
Cbr1p0000 qbr1p0000 0 2f
Mbr1p0000 qbr1p0000 railr1p0000 railr1p0000 railr1p0000 sg13g2_pmos W=1.12u L=0.13u AD=0.2516e-12 AS=0.2516e-12 PD=1e-6 PS=1e-6
VBcr1p0000 qcr1p0000 0 0.0
Ccr1p0000 qcr1p0000 0 2f
Mcr1p0000 qcr1p0000 railr1p0000 railr1p0000 railr1p0000 sg13g2_pmos W=1.12u L=0.13u AD=0.3808e-12 AS=0.3808e-12 PD=2.92e-6 PS=2.92e-6
.tran 0.2n 60n 0 2n
.print tran format=noindex I(VBRr0p5217) I(VBar0p5217) I(VBbr0p5217) I(VBcr0p5217) I(VBRr0p5594) I(VBar0p5594) I(VBbr0p5594) I(VBcr0p5594) I(VBRr0p6077) I(VBar0p6077) I(VBbr0p6077) I(VBcr0p6077) I(VBRr0p7000) I(VBar0p7000) I(VBbr0p7000) I(VBcr0p7000) I(VBRr1p0000) I(VBar1p0000) I(VBbr1p0000) I(VBcr1p0000)
.end
