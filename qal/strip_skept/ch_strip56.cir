* SKEPT cascade, topo=strip rail=0.6077 wxc=0.56u
* ideal stiff rail: DECLARED, and deliberately generous to both arms
.hdl "/usr/local/share/xyce/verilog-a/psp103/psp103.va"
.include "/usr/local/src/kestrel/sim/models/sg13g2_psp103_tt.lib"
.include "/usr/local/src/stat-sim/qal/sg13lv_compat.sp"
.OPTIONS TIMEINT METHOD=GEAR RELTOL=1e-6 ABSTOL=1e-15 CHGTOL=1e-17
VRAIL rail 0 0.607700
RHI hi rail 0.001
* stripped o21ai inst=xk1c0 wxc=0.56u
Xxk1c0F1 qxk1c0 B1xk1c0 xk1c0Fi0_0 0 sg13_lv_nmos w=0.74u l=0.13u
Xxk1c0F2 xk1c0Fi0_0 A1xk1c0 0 0 sg13_lv_nmos w=0.74u l=0.13u
Xxk1c0F3 xk1c0Fi0_0 A2xk1c0 0 0 sg13_lv_nmos w=0.74u l=0.13u
Xxk1c0G1 nxk1c0 A1xk1c0_B xk1c0Gi0_0 0 sg13_lv_nmos w=0.74u l=0.13u
Xxk1c0G2 xk1c0Gi0_0 A2xk1c0_B 0 0 sg13_lv_nmos w=0.74u l=0.13u
Xxk1c0G3 nxk1c0 B1xk1c0_B 0 0 sg13_lv_nmos w=0.74u l=0.13u
XXAxk1c0 qxk1c0 nxk1c0 rail rail sg13_lv_pmos w=0.56u l=0.13u
XXBxk1c0 nxk1c0 qxk1c0 rail rail sg13_lv_pmos w=0.56u l=0.13u
Cqxk1c0 qxk1c0 0 2f
Cnxk1c0 nxk1c0 0 2f
RA1xk1c0 A1xk1c0 0 0.001
RA1Bxk1c0 A1xk1c0_B hi 0.001
RA2xk1c0 A2xk1c0 hi 0.001
RA2Bxk1c0 A2xk1c0_B 0 0.001
RB1xk1c0 B1xk1c0 0 0.001
RB1Bxk1c0 B1xk1c0_B hi 0.001
* stripped o21ai inst=xk1c1 wxc=0.56u
Xxk1c1F1 qxk1c1 B1xk1c1 xk1c1Fi0_0 0 sg13_lv_nmos w=0.74u l=0.13u
Xxk1c1F2 xk1c1Fi0_0 A1xk1c1 0 0 sg13_lv_nmos w=0.74u l=0.13u
Xxk1c1F3 xk1c1Fi0_0 A2xk1c1 0 0 sg13_lv_nmos w=0.74u l=0.13u
Xxk1c1G1 nxk1c1 A1xk1c1_B xk1c1Gi0_0 0 sg13_lv_nmos w=0.74u l=0.13u
Xxk1c1G2 xk1c1Gi0_0 A2xk1c1_B 0 0 sg13_lv_nmos w=0.74u l=0.13u
Xxk1c1G3 nxk1c1 B1xk1c1_B 0 0 sg13_lv_nmos w=0.74u l=0.13u
XXAxk1c1 qxk1c1 nxk1c1 rail rail sg13_lv_pmos w=0.56u l=0.13u
XXBxk1c1 nxk1c1 qxk1c1 rail rail sg13_lv_pmos w=0.56u l=0.13u
Cqxk1c1 qxk1c1 0 2f
Cnxk1c1 nxk1c1 0 2f
RA1xk1c1 A1xk1c1 0 0.001
RA1Bxk1c1 A1xk1c1_B hi 0.001
RA2xk1c1 A2xk1c1 hi 0.001
RA2Bxk1c1 A2xk1c1_B 0 0.001
RB1xk1c1 B1xk1c1 hi 0.001
RB1Bxk1c1 B1xk1c1_B 0 0.001
* stripped o21ai inst=xk1c2 wxc=0.56u
Xxk1c2F1 qxk1c2 B1xk1c2 xk1c2Fi0_0 0 sg13_lv_nmos w=0.74u l=0.13u
Xxk1c2F2 xk1c2Fi0_0 A1xk1c2 0 0 sg13_lv_nmos w=0.74u l=0.13u
Xxk1c2F3 xk1c2Fi0_0 A2xk1c2 0 0 sg13_lv_nmos w=0.74u l=0.13u
Xxk1c2G1 nxk1c2 A1xk1c2_B xk1c2Gi0_0 0 sg13_lv_nmos w=0.74u l=0.13u
Xxk1c2G2 xk1c2Gi0_0 A2xk1c2_B 0 0 sg13_lv_nmos w=0.74u l=0.13u
Xxk1c2G3 nxk1c2 B1xk1c2_B 0 0 sg13_lv_nmos w=0.74u l=0.13u
XXAxk1c2 qxk1c2 nxk1c2 rail rail sg13_lv_pmos w=0.56u l=0.13u
XXBxk1c2 nxk1c2 qxk1c2 rail rail sg13_lv_pmos w=0.56u l=0.13u
Cqxk1c2 qxk1c2 0 2f
Cnxk1c2 nxk1c2 0 2f
RA1xk1c2 A1xk1c2 hi 0.001
RA1Bxk1c2 A1xk1c2_B 0 0.001
RA2xk1c2 A2xk1c2 0 0.001
RA2Bxk1c2 A2xk1c2_B hi 0.001
RB1xk1c2 B1xk1c2 hi 0.001
RB1Bxk1c2 B1xk1c2_B 0 0.001
* stripped o21ai inst=xk1c3 wxc=0.56u
Xxk1c3F1 qxk1c3 B1xk1c3 xk1c3Fi0_0 0 sg13_lv_nmos w=0.74u l=0.13u
Xxk1c3F2 xk1c3Fi0_0 A1xk1c3 0 0 sg13_lv_nmos w=0.74u l=0.13u
Xxk1c3F3 xk1c3Fi0_0 A2xk1c3 0 0 sg13_lv_nmos w=0.74u l=0.13u
Xxk1c3G1 nxk1c3 A1xk1c3_B xk1c3Gi0_0 0 sg13_lv_nmos w=0.74u l=0.13u
Xxk1c3G2 xk1c3Gi0_0 A2xk1c3_B 0 0 sg13_lv_nmos w=0.74u l=0.13u
Xxk1c3G3 nxk1c3 B1xk1c3_B 0 0 sg13_lv_nmos w=0.74u l=0.13u
XXAxk1c3 qxk1c3 nxk1c3 rail rail sg13_lv_pmos w=0.56u l=0.13u
XXBxk1c3 nxk1c3 qxk1c3 rail rail sg13_lv_pmos w=0.56u l=0.13u
Cqxk1c3 qxk1c3 0 2f
Cnxk1c3 nxk1c3 0 2f
RA1xk1c3 A1xk1c3 hi 0.001
RA1Bxk1c3 A1xk1c3_B 0 0.001
RA2xk1c3 A2xk1c3 0 0.001
RA2Bxk1c3 A2xk1c3_B hi 0.001
RB1xk1c3 B1xk1c3 0 0.001
RB1Bxk1c3 B1xk1c3_B hi 0.001
* stripped o21ai inst=xk2c0 wxc=0.56u
Xxk2c0F1 qxk2c0 B1xk2c0 xk2c0Fi0_0 0 sg13_lv_nmos w=0.74u l=0.13u
Xxk2c0F2 xk2c0Fi0_0 A1xk2c0 0 0 sg13_lv_nmos w=0.74u l=0.13u
Xxk2c0F3 xk2c0Fi0_0 A2xk2c0 0 0 sg13_lv_nmos w=0.74u l=0.13u
Xxk2c0G1 nxk2c0 A1xk2c0_B xk2c0Gi0_0 0 sg13_lv_nmos w=0.74u l=0.13u
Xxk2c0G2 xk2c0Gi0_0 A2xk2c0_B 0 0 sg13_lv_nmos w=0.74u l=0.13u
Xxk2c0G3 nxk2c0 B1xk2c0_B 0 0 sg13_lv_nmos w=0.74u l=0.13u
XXAxk2c0 qxk2c0 nxk2c0 rail rail sg13_lv_pmos w=0.56u l=0.13u
XXBxk2c0 nxk2c0 qxk2c0 rail rail sg13_lv_pmos w=0.56u l=0.13u
Cqxk2c0 qxk2c0 0 2f
Cnxk2c0 nxk2c0 0 2f
RA1xk2c0 A1xk2c0 qxk1c0 0.001
RA1Bxk2c0 A1xk2c0_B nxk1c0 0.001
RA2xk2c0 A2xk2c0 qxk1c2 0.001
RA2Bxk2c0 A2xk2c0_B nxk1c2 0.001
RB1xk2c0 B1xk2c0 qxk1c1 0.001
RB1Bxk2c0 B1xk2c0_B nxk1c1 0.001
* stripped o21ai inst=xk2c1 wxc=0.56u
Xxk2c1F1 qxk2c1 B1xk2c1 xk2c1Fi0_0 0 sg13_lv_nmos w=0.74u l=0.13u
Xxk2c1F2 xk2c1Fi0_0 A1xk2c1 0 0 sg13_lv_nmos w=0.74u l=0.13u
Xxk2c1F3 xk2c1Fi0_0 A2xk2c1 0 0 sg13_lv_nmos w=0.74u l=0.13u
Xxk2c1G1 nxk2c1 A1xk2c1_B xk2c1Gi0_0 0 sg13_lv_nmos w=0.74u l=0.13u
Xxk2c1G2 xk2c1Gi0_0 A2xk2c1_B 0 0 sg13_lv_nmos w=0.74u l=0.13u
Xxk2c1G3 nxk2c1 B1xk2c1_B 0 0 sg13_lv_nmos w=0.74u l=0.13u
XXAxk2c1 qxk2c1 nxk2c1 rail rail sg13_lv_pmos w=0.56u l=0.13u
XXBxk2c1 nxk2c1 qxk2c1 rail rail sg13_lv_pmos w=0.56u l=0.13u
Cqxk2c1 qxk2c1 0 2f
Cnxk2c1 nxk2c1 0 2f
RA1xk2c1 A1xk2c1 qxk1c1 0.001
RA1Bxk2c1 A1xk2c1_B nxk1c1 0.001
RA2xk2c1 A2xk2c1 qxk1c3 0.001
RA2Bxk2c1 A2xk2c1_B nxk1c3 0.001
RB1xk2c1 B1xk2c1 qxk1c2 0.001
RB1Bxk2c1 B1xk2c1_B nxk1c2 0.001
* stripped o21ai inst=xk2c2 wxc=0.56u
Xxk2c2F1 qxk2c2 B1xk2c2 xk2c2Fi0_0 0 sg13_lv_nmos w=0.74u l=0.13u
Xxk2c2F2 xk2c2Fi0_0 A1xk2c2 0 0 sg13_lv_nmos w=0.74u l=0.13u
Xxk2c2F3 xk2c2Fi0_0 A2xk2c2 0 0 sg13_lv_nmos w=0.74u l=0.13u
Xxk2c2G1 nxk2c2 A1xk2c2_B xk2c2Gi0_0 0 sg13_lv_nmos w=0.74u l=0.13u
Xxk2c2G2 xk2c2Gi0_0 A2xk2c2_B 0 0 sg13_lv_nmos w=0.74u l=0.13u
Xxk2c2G3 nxk2c2 B1xk2c2_B 0 0 sg13_lv_nmos w=0.74u l=0.13u
XXAxk2c2 qxk2c2 nxk2c2 rail rail sg13_lv_pmos w=0.56u l=0.13u
XXBxk2c2 nxk2c2 qxk2c2 rail rail sg13_lv_pmos w=0.56u l=0.13u
Cqxk2c2 qxk2c2 0 2f
Cnxk2c2 nxk2c2 0 2f
RA1xk2c2 A1xk2c2 qxk1c2 0.001
RA1Bxk2c2 A1xk2c2_B nxk1c2 0.001
RA2xk2c2 A2xk2c2 qxk1c0 0.001
RA2Bxk2c2 A2xk2c2_B nxk1c0 0.001
RB1xk2c2 B1xk2c2 qxk1c3 0.001
RB1Bxk2c2 B1xk2c2_B nxk1c3 0.001
* stripped o21ai inst=xk2c3 wxc=0.56u
Xxk2c3F1 qxk2c3 B1xk2c3 xk2c3Fi0_0 0 sg13_lv_nmos w=0.74u l=0.13u
Xxk2c3F2 xk2c3Fi0_0 A1xk2c3 0 0 sg13_lv_nmos w=0.74u l=0.13u
Xxk2c3F3 xk2c3Fi0_0 A2xk2c3 0 0 sg13_lv_nmos w=0.74u l=0.13u
Xxk2c3G1 nxk2c3 A1xk2c3_B xk2c3Gi0_0 0 sg13_lv_nmos w=0.74u l=0.13u
Xxk2c3G2 xk2c3Gi0_0 A2xk2c3_B 0 0 sg13_lv_nmos w=0.74u l=0.13u
Xxk2c3G3 nxk2c3 B1xk2c3_B 0 0 sg13_lv_nmos w=0.74u l=0.13u
XXAxk2c3 qxk2c3 nxk2c3 rail rail sg13_lv_pmos w=0.56u l=0.13u
XXBxk2c3 nxk2c3 qxk2c3 rail rail sg13_lv_pmos w=0.56u l=0.13u
Cqxk2c3 qxk2c3 0 2f
Cnxk2c3 nxk2c3 0 2f
RA1xk2c3 A1xk2c3 qxk1c3 0.001
RA1Bxk2c3 A1xk2c3_B nxk1c3 0.001
RA2xk2c3 A2xk2c3 qxk1c1 0.001
RA2Bxk2c3 A2xk2c3_B nxk1c1 0.001
RB1xk2c3 B1xk2c3 qxk1c0 0.001
RB1Bxk2c3 B1xk2c3_B nxk1c0 0.001
* stripped o21ai inst=xk3c0 wxc=0.56u
Xxk3c0F1 qxk3c0 B1xk3c0 xk3c0Fi0_0 0 sg13_lv_nmos w=0.74u l=0.13u
Xxk3c0F2 xk3c0Fi0_0 A1xk3c0 0 0 sg13_lv_nmos w=0.74u l=0.13u
Xxk3c0F3 xk3c0Fi0_0 A2xk3c0 0 0 sg13_lv_nmos w=0.74u l=0.13u
Xxk3c0G1 nxk3c0 A1xk3c0_B xk3c0Gi0_0 0 sg13_lv_nmos w=0.74u l=0.13u
Xxk3c0G2 xk3c0Gi0_0 A2xk3c0_B 0 0 sg13_lv_nmos w=0.74u l=0.13u
Xxk3c0G3 nxk3c0 B1xk3c0_B 0 0 sg13_lv_nmos w=0.74u l=0.13u
XXAxk3c0 qxk3c0 nxk3c0 rail rail sg13_lv_pmos w=0.56u l=0.13u
XXBxk3c0 nxk3c0 qxk3c0 rail rail sg13_lv_pmos w=0.56u l=0.13u
Cqxk3c0 qxk3c0 0 2f
Cnxk3c0 nxk3c0 0 2f
RA1xk3c0 A1xk3c0 qxk2c0 0.001
RA1Bxk3c0 A1xk3c0_B nxk2c0 0.001
RA2xk3c0 A2xk3c0 qxk2c2 0.001
RA2Bxk3c0 A2xk3c0_B nxk2c2 0.001
RB1xk3c0 B1xk3c0 qxk2c1 0.001
RB1Bxk3c0 B1xk3c0_B nxk2c1 0.001
* stripped o21ai inst=xk3c1 wxc=0.56u
Xxk3c1F1 qxk3c1 B1xk3c1 xk3c1Fi0_0 0 sg13_lv_nmos w=0.74u l=0.13u
Xxk3c1F2 xk3c1Fi0_0 A1xk3c1 0 0 sg13_lv_nmos w=0.74u l=0.13u
Xxk3c1F3 xk3c1Fi0_0 A2xk3c1 0 0 sg13_lv_nmos w=0.74u l=0.13u
Xxk3c1G1 nxk3c1 A1xk3c1_B xk3c1Gi0_0 0 sg13_lv_nmos w=0.74u l=0.13u
Xxk3c1G2 xk3c1Gi0_0 A2xk3c1_B 0 0 sg13_lv_nmos w=0.74u l=0.13u
Xxk3c1G3 nxk3c1 B1xk3c1_B 0 0 sg13_lv_nmos w=0.74u l=0.13u
XXAxk3c1 qxk3c1 nxk3c1 rail rail sg13_lv_pmos w=0.56u l=0.13u
XXBxk3c1 nxk3c1 qxk3c1 rail rail sg13_lv_pmos w=0.56u l=0.13u
Cqxk3c1 qxk3c1 0 2f
Cnxk3c1 nxk3c1 0 2f
RA1xk3c1 A1xk3c1 qxk2c1 0.001
RA1Bxk3c1 A1xk3c1_B nxk2c1 0.001
RA2xk3c1 A2xk3c1 qxk2c3 0.001
RA2Bxk3c1 A2xk3c1_B nxk2c3 0.001
RB1xk3c1 B1xk3c1 qxk2c2 0.001
RB1Bxk3c1 B1xk3c1_B nxk2c2 0.001
* stripped o21ai inst=xk3c2 wxc=0.56u
Xxk3c2F1 qxk3c2 B1xk3c2 xk3c2Fi0_0 0 sg13_lv_nmos w=0.74u l=0.13u
Xxk3c2F2 xk3c2Fi0_0 A1xk3c2 0 0 sg13_lv_nmos w=0.74u l=0.13u
Xxk3c2F3 xk3c2Fi0_0 A2xk3c2 0 0 sg13_lv_nmos w=0.74u l=0.13u
Xxk3c2G1 nxk3c2 A1xk3c2_B xk3c2Gi0_0 0 sg13_lv_nmos w=0.74u l=0.13u
Xxk3c2G2 xk3c2Gi0_0 A2xk3c2_B 0 0 sg13_lv_nmos w=0.74u l=0.13u
Xxk3c2G3 nxk3c2 B1xk3c2_B 0 0 sg13_lv_nmos w=0.74u l=0.13u
XXAxk3c2 qxk3c2 nxk3c2 rail rail sg13_lv_pmos w=0.56u l=0.13u
XXBxk3c2 nxk3c2 qxk3c2 rail rail sg13_lv_pmos w=0.56u l=0.13u
Cqxk3c2 qxk3c2 0 2f
Cnxk3c2 nxk3c2 0 2f
RA1xk3c2 A1xk3c2 qxk2c2 0.001
RA1Bxk3c2 A1xk3c2_B nxk2c2 0.001
RA2xk3c2 A2xk3c2 qxk2c0 0.001
RA2Bxk3c2 A2xk3c2_B nxk2c0 0.001
RB1xk3c2 B1xk3c2 qxk2c3 0.001
RB1Bxk3c2 B1xk3c2_B nxk2c3 0.001
* stripped o21ai inst=xk3c3 wxc=0.56u
Xxk3c3F1 qxk3c3 B1xk3c3 xk3c3Fi0_0 0 sg13_lv_nmos w=0.74u l=0.13u
Xxk3c3F2 xk3c3Fi0_0 A1xk3c3 0 0 sg13_lv_nmos w=0.74u l=0.13u
Xxk3c3F3 xk3c3Fi0_0 A2xk3c3 0 0 sg13_lv_nmos w=0.74u l=0.13u
Xxk3c3G1 nxk3c3 A1xk3c3_B xk3c3Gi0_0 0 sg13_lv_nmos w=0.74u l=0.13u
Xxk3c3G2 xk3c3Gi0_0 A2xk3c3_B 0 0 sg13_lv_nmos w=0.74u l=0.13u
Xxk3c3G3 nxk3c3 B1xk3c3_B 0 0 sg13_lv_nmos w=0.74u l=0.13u
XXAxk3c3 qxk3c3 nxk3c3 rail rail sg13_lv_pmos w=0.56u l=0.13u
XXBxk3c3 nxk3c3 qxk3c3 rail rail sg13_lv_pmos w=0.56u l=0.13u
Cqxk3c3 qxk3c3 0 2f
Cnxk3c3 nxk3c3 0 2f
RA1xk3c3 A1xk3c3 qxk2c3 0.001
RA1Bxk3c3 A1xk3c3_B nxk2c3 0.001
RA2xk3c3 A2xk3c3 qxk2c1 0.001
RA2Bxk3c3 A2xk3c3_B nxk2c1 0.001
RB1xk3c3 B1xk3c3 qxk2c0 0.001
RB1Bxk3c3 B1xk3c3_B nxk2c0 0.001
* stripped o21ai inst=xk4c0 wxc=0.56u
Xxk4c0F1 qxk4c0 B1xk4c0 xk4c0Fi0_0 0 sg13_lv_nmos w=0.74u l=0.13u
Xxk4c0F2 xk4c0Fi0_0 A1xk4c0 0 0 sg13_lv_nmos w=0.74u l=0.13u
Xxk4c0F3 xk4c0Fi0_0 A2xk4c0 0 0 sg13_lv_nmos w=0.74u l=0.13u
Xxk4c0G1 nxk4c0 A1xk4c0_B xk4c0Gi0_0 0 sg13_lv_nmos w=0.74u l=0.13u
Xxk4c0G2 xk4c0Gi0_0 A2xk4c0_B 0 0 sg13_lv_nmos w=0.74u l=0.13u
Xxk4c0G3 nxk4c0 B1xk4c0_B 0 0 sg13_lv_nmos w=0.74u l=0.13u
XXAxk4c0 qxk4c0 nxk4c0 rail rail sg13_lv_pmos w=0.56u l=0.13u
XXBxk4c0 nxk4c0 qxk4c0 rail rail sg13_lv_pmos w=0.56u l=0.13u
Cqxk4c0 qxk4c0 0 2f
Cnxk4c0 nxk4c0 0 2f
RA1xk4c0 A1xk4c0 qxk3c0 0.001
RA1Bxk4c0 A1xk4c0_B nxk3c0 0.001
RA2xk4c0 A2xk4c0 qxk3c2 0.001
RA2Bxk4c0 A2xk4c0_B nxk3c2 0.001
RB1xk4c0 B1xk4c0 qxk3c1 0.001
RB1Bxk4c0 B1xk4c0_B nxk3c1 0.001
* stripped o21ai inst=xk4c1 wxc=0.56u
Xxk4c1F1 qxk4c1 B1xk4c1 xk4c1Fi0_0 0 sg13_lv_nmos w=0.74u l=0.13u
Xxk4c1F2 xk4c1Fi0_0 A1xk4c1 0 0 sg13_lv_nmos w=0.74u l=0.13u
Xxk4c1F3 xk4c1Fi0_0 A2xk4c1 0 0 sg13_lv_nmos w=0.74u l=0.13u
Xxk4c1G1 nxk4c1 A1xk4c1_B xk4c1Gi0_0 0 sg13_lv_nmos w=0.74u l=0.13u
Xxk4c1G2 xk4c1Gi0_0 A2xk4c1_B 0 0 sg13_lv_nmos w=0.74u l=0.13u
Xxk4c1G3 nxk4c1 B1xk4c1_B 0 0 sg13_lv_nmos w=0.74u l=0.13u
XXAxk4c1 qxk4c1 nxk4c1 rail rail sg13_lv_pmos w=0.56u l=0.13u
XXBxk4c1 nxk4c1 qxk4c1 rail rail sg13_lv_pmos w=0.56u l=0.13u
Cqxk4c1 qxk4c1 0 2f
Cnxk4c1 nxk4c1 0 2f
RA1xk4c1 A1xk4c1 qxk3c1 0.001
RA1Bxk4c1 A1xk4c1_B nxk3c1 0.001
RA2xk4c1 A2xk4c1 qxk3c3 0.001
RA2Bxk4c1 A2xk4c1_B nxk3c3 0.001
RB1xk4c1 B1xk4c1 qxk3c2 0.001
RB1Bxk4c1 B1xk4c1_B nxk3c2 0.001
* stripped o21ai inst=xk4c2 wxc=0.56u
Xxk4c2F1 qxk4c2 B1xk4c2 xk4c2Fi0_0 0 sg13_lv_nmos w=0.74u l=0.13u
Xxk4c2F2 xk4c2Fi0_0 A1xk4c2 0 0 sg13_lv_nmos w=0.74u l=0.13u
Xxk4c2F3 xk4c2Fi0_0 A2xk4c2 0 0 sg13_lv_nmos w=0.74u l=0.13u
Xxk4c2G1 nxk4c2 A1xk4c2_B xk4c2Gi0_0 0 sg13_lv_nmos w=0.74u l=0.13u
Xxk4c2G2 xk4c2Gi0_0 A2xk4c2_B 0 0 sg13_lv_nmos w=0.74u l=0.13u
Xxk4c2G3 nxk4c2 B1xk4c2_B 0 0 sg13_lv_nmos w=0.74u l=0.13u
XXAxk4c2 qxk4c2 nxk4c2 rail rail sg13_lv_pmos w=0.56u l=0.13u
XXBxk4c2 nxk4c2 qxk4c2 rail rail sg13_lv_pmos w=0.56u l=0.13u
Cqxk4c2 qxk4c2 0 2f
Cnxk4c2 nxk4c2 0 2f
RA1xk4c2 A1xk4c2 qxk3c2 0.001
RA1Bxk4c2 A1xk4c2_B nxk3c2 0.001
RA2xk4c2 A2xk4c2 qxk3c0 0.001
RA2Bxk4c2 A2xk4c2_B nxk3c0 0.001
RB1xk4c2 B1xk4c2 qxk3c3 0.001
RB1Bxk4c2 B1xk4c2_B nxk3c3 0.001
* stripped o21ai inst=xk4c3 wxc=0.56u
Xxk4c3F1 qxk4c3 B1xk4c3 xk4c3Fi0_0 0 sg13_lv_nmos w=0.74u l=0.13u
Xxk4c3F2 xk4c3Fi0_0 A1xk4c3 0 0 sg13_lv_nmos w=0.74u l=0.13u
Xxk4c3F3 xk4c3Fi0_0 A2xk4c3 0 0 sg13_lv_nmos w=0.74u l=0.13u
Xxk4c3G1 nxk4c3 A1xk4c3_B xk4c3Gi0_0 0 sg13_lv_nmos w=0.74u l=0.13u
Xxk4c3G2 xk4c3Gi0_0 A2xk4c3_B 0 0 sg13_lv_nmos w=0.74u l=0.13u
Xxk4c3G3 nxk4c3 B1xk4c3_B 0 0 sg13_lv_nmos w=0.74u l=0.13u
XXAxk4c3 qxk4c3 nxk4c3 rail rail sg13_lv_pmos w=0.56u l=0.13u
XXBxk4c3 nxk4c3 qxk4c3 rail rail sg13_lv_pmos w=0.56u l=0.13u
Cqxk4c3 qxk4c3 0 2f
Cnxk4c3 nxk4c3 0 2f
RA1xk4c3 A1xk4c3 qxk3c3 0.001
RA1Bxk4c3 A1xk4c3_B nxk3c3 0.001
RA2xk4c3 A2xk4c3 qxk3c1 0.001
RA2Bxk4c3 A2xk4c3_B nxk3c1 0.001
RB1xk4c3 B1xk4c3 qxk3c0 0.001
RB1Bxk4c3 B1xk4c3_B nxk3c0 0.001
* stripped o21ai inst=xk5c0 wxc=0.56u
Xxk5c0F1 qxk5c0 B1xk5c0 xk5c0Fi0_0 0 sg13_lv_nmos w=0.74u l=0.13u
Xxk5c0F2 xk5c0Fi0_0 A1xk5c0 0 0 sg13_lv_nmos w=0.74u l=0.13u
Xxk5c0F3 xk5c0Fi0_0 A2xk5c0 0 0 sg13_lv_nmos w=0.74u l=0.13u
Xxk5c0G1 nxk5c0 A1xk5c0_B xk5c0Gi0_0 0 sg13_lv_nmos w=0.74u l=0.13u
Xxk5c0G2 xk5c0Gi0_0 A2xk5c0_B 0 0 sg13_lv_nmos w=0.74u l=0.13u
Xxk5c0G3 nxk5c0 B1xk5c0_B 0 0 sg13_lv_nmos w=0.74u l=0.13u
XXAxk5c0 qxk5c0 nxk5c0 rail rail sg13_lv_pmos w=0.56u l=0.13u
XXBxk5c0 nxk5c0 qxk5c0 rail rail sg13_lv_pmos w=0.56u l=0.13u
Cqxk5c0 qxk5c0 0 2f
Cnxk5c0 nxk5c0 0 2f
RA1xk5c0 A1xk5c0 qxk4c0 0.001
RA1Bxk5c0 A1xk5c0_B nxk4c0 0.001
RA2xk5c0 A2xk5c0 qxk4c2 0.001
RA2Bxk5c0 A2xk5c0_B nxk4c2 0.001
RB1xk5c0 B1xk5c0 qxk4c1 0.001
RB1Bxk5c0 B1xk5c0_B nxk4c1 0.001
* stripped o21ai inst=xk5c1 wxc=0.56u
Xxk5c1F1 qxk5c1 B1xk5c1 xk5c1Fi0_0 0 sg13_lv_nmos w=0.74u l=0.13u
Xxk5c1F2 xk5c1Fi0_0 A1xk5c1 0 0 sg13_lv_nmos w=0.74u l=0.13u
Xxk5c1F3 xk5c1Fi0_0 A2xk5c1 0 0 sg13_lv_nmos w=0.74u l=0.13u
Xxk5c1G1 nxk5c1 A1xk5c1_B xk5c1Gi0_0 0 sg13_lv_nmos w=0.74u l=0.13u
Xxk5c1G2 xk5c1Gi0_0 A2xk5c1_B 0 0 sg13_lv_nmos w=0.74u l=0.13u
Xxk5c1G3 nxk5c1 B1xk5c1_B 0 0 sg13_lv_nmos w=0.74u l=0.13u
XXAxk5c1 qxk5c1 nxk5c1 rail rail sg13_lv_pmos w=0.56u l=0.13u
XXBxk5c1 nxk5c1 qxk5c1 rail rail sg13_lv_pmos w=0.56u l=0.13u
Cqxk5c1 qxk5c1 0 2f
Cnxk5c1 nxk5c1 0 2f
RA1xk5c1 A1xk5c1 qxk4c1 0.001
RA1Bxk5c1 A1xk5c1_B nxk4c1 0.001
RA2xk5c1 A2xk5c1 qxk4c3 0.001
RA2Bxk5c1 A2xk5c1_B nxk4c3 0.001
RB1xk5c1 B1xk5c1 qxk4c2 0.001
RB1Bxk5c1 B1xk5c1_B nxk4c2 0.001
* stripped o21ai inst=xk5c2 wxc=0.56u
Xxk5c2F1 qxk5c2 B1xk5c2 xk5c2Fi0_0 0 sg13_lv_nmos w=0.74u l=0.13u
Xxk5c2F2 xk5c2Fi0_0 A1xk5c2 0 0 sg13_lv_nmos w=0.74u l=0.13u
Xxk5c2F3 xk5c2Fi0_0 A2xk5c2 0 0 sg13_lv_nmos w=0.74u l=0.13u
Xxk5c2G1 nxk5c2 A1xk5c2_B xk5c2Gi0_0 0 sg13_lv_nmos w=0.74u l=0.13u
Xxk5c2G2 xk5c2Gi0_0 A2xk5c2_B 0 0 sg13_lv_nmos w=0.74u l=0.13u
Xxk5c2G3 nxk5c2 B1xk5c2_B 0 0 sg13_lv_nmos w=0.74u l=0.13u
XXAxk5c2 qxk5c2 nxk5c2 rail rail sg13_lv_pmos w=0.56u l=0.13u
XXBxk5c2 nxk5c2 qxk5c2 rail rail sg13_lv_pmos w=0.56u l=0.13u
Cqxk5c2 qxk5c2 0 2f
Cnxk5c2 nxk5c2 0 2f
RA1xk5c2 A1xk5c2 qxk4c2 0.001
RA1Bxk5c2 A1xk5c2_B nxk4c2 0.001
RA2xk5c2 A2xk5c2 qxk4c0 0.001
RA2Bxk5c2 A2xk5c2_B nxk4c0 0.001
RB1xk5c2 B1xk5c2 qxk4c3 0.001
RB1Bxk5c2 B1xk5c2_B nxk4c3 0.001
* stripped o21ai inst=xk5c3 wxc=0.56u
Xxk5c3F1 qxk5c3 B1xk5c3 xk5c3Fi0_0 0 sg13_lv_nmos w=0.74u l=0.13u
Xxk5c3F2 xk5c3Fi0_0 A1xk5c3 0 0 sg13_lv_nmos w=0.74u l=0.13u
Xxk5c3F3 xk5c3Fi0_0 A2xk5c3 0 0 sg13_lv_nmos w=0.74u l=0.13u
Xxk5c3G1 nxk5c3 A1xk5c3_B xk5c3Gi0_0 0 sg13_lv_nmos w=0.74u l=0.13u
Xxk5c3G2 xk5c3Gi0_0 A2xk5c3_B 0 0 sg13_lv_nmos w=0.74u l=0.13u
Xxk5c3G3 nxk5c3 B1xk5c3_B 0 0 sg13_lv_nmos w=0.74u l=0.13u
XXAxk5c3 qxk5c3 nxk5c3 rail rail sg13_lv_pmos w=0.56u l=0.13u
XXBxk5c3 nxk5c3 qxk5c3 rail rail sg13_lv_pmos w=0.56u l=0.13u
Cqxk5c3 qxk5c3 0 2f
Cnxk5c3 nxk5c3 0 2f
RA1xk5c3 A1xk5c3 qxk4c3 0.001
RA1Bxk5c3 A1xk5c3_B nxk4c3 0.001
RA2xk5c3 A2xk5c3 qxk4c1 0.001
RA2Bxk5c3 A2xk5c3_B nxk4c1 0.001
RB1xk5c3 B1xk5c3 qxk4c0 0.001
RB1Bxk5c3 B1xk5c3_B nxk4c0 0.001
* stripped o21ai inst=xk6c0 wxc=0.56u
Xxk6c0F1 qxk6c0 B1xk6c0 xk6c0Fi0_0 0 sg13_lv_nmos w=0.74u l=0.13u
Xxk6c0F2 xk6c0Fi0_0 A1xk6c0 0 0 sg13_lv_nmos w=0.74u l=0.13u
Xxk6c0F3 xk6c0Fi0_0 A2xk6c0 0 0 sg13_lv_nmos w=0.74u l=0.13u
Xxk6c0G1 nxk6c0 A1xk6c0_B xk6c0Gi0_0 0 sg13_lv_nmos w=0.74u l=0.13u
Xxk6c0G2 xk6c0Gi0_0 A2xk6c0_B 0 0 sg13_lv_nmos w=0.74u l=0.13u
Xxk6c0G3 nxk6c0 B1xk6c0_B 0 0 sg13_lv_nmos w=0.74u l=0.13u
XXAxk6c0 qxk6c0 nxk6c0 rail rail sg13_lv_pmos w=0.56u l=0.13u
XXBxk6c0 nxk6c0 qxk6c0 rail rail sg13_lv_pmos w=0.56u l=0.13u
Cqxk6c0 qxk6c0 0 2f
Cnxk6c0 nxk6c0 0 2f
RA1xk6c0 A1xk6c0 qxk5c0 0.001
RA1Bxk6c0 A1xk6c0_B nxk5c0 0.001
RA2xk6c0 A2xk6c0 qxk5c2 0.001
RA2Bxk6c0 A2xk6c0_B nxk5c2 0.001
RB1xk6c0 B1xk6c0 qxk5c1 0.001
RB1Bxk6c0 B1xk6c0_B nxk5c1 0.001
* stripped o21ai inst=xk6c1 wxc=0.56u
Xxk6c1F1 qxk6c1 B1xk6c1 xk6c1Fi0_0 0 sg13_lv_nmos w=0.74u l=0.13u
Xxk6c1F2 xk6c1Fi0_0 A1xk6c1 0 0 sg13_lv_nmos w=0.74u l=0.13u
Xxk6c1F3 xk6c1Fi0_0 A2xk6c1 0 0 sg13_lv_nmos w=0.74u l=0.13u
Xxk6c1G1 nxk6c1 A1xk6c1_B xk6c1Gi0_0 0 sg13_lv_nmos w=0.74u l=0.13u
Xxk6c1G2 xk6c1Gi0_0 A2xk6c1_B 0 0 sg13_lv_nmos w=0.74u l=0.13u
Xxk6c1G3 nxk6c1 B1xk6c1_B 0 0 sg13_lv_nmos w=0.74u l=0.13u
XXAxk6c1 qxk6c1 nxk6c1 rail rail sg13_lv_pmos w=0.56u l=0.13u
XXBxk6c1 nxk6c1 qxk6c1 rail rail sg13_lv_pmos w=0.56u l=0.13u
Cqxk6c1 qxk6c1 0 2f
Cnxk6c1 nxk6c1 0 2f
RA1xk6c1 A1xk6c1 qxk5c1 0.001
RA1Bxk6c1 A1xk6c1_B nxk5c1 0.001
RA2xk6c1 A2xk6c1 qxk5c3 0.001
RA2Bxk6c1 A2xk6c1_B nxk5c3 0.001
RB1xk6c1 B1xk6c1 qxk5c2 0.001
RB1Bxk6c1 B1xk6c1_B nxk5c2 0.001
* stripped o21ai inst=xk6c2 wxc=0.56u
Xxk6c2F1 qxk6c2 B1xk6c2 xk6c2Fi0_0 0 sg13_lv_nmos w=0.74u l=0.13u
Xxk6c2F2 xk6c2Fi0_0 A1xk6c2 0 0 sg13_lv_nmos w=0.74u l=0.13u
Xxk6c2F3 xk6c2Fi0_0 A2xk6c2 0 0 sg13_lv_nmos w=0.74u l=0.13u
Xxk6c2G1 nxk6c2 A1xk6c2_B xk6c2Gi0_0 0 sg13_lv_nmos w=0.74u l=0.13u
Xxk6c2G2 xk6c2Gi0_0 A2xk6c2_B 0 0 sg13_lv_nmos w=0.74u l=0.13u
Xxk6c2G3 nxk6c2 B1xk6c2_B 0 0 sg13_lv_nmos w=0.74u l=0.13u
XXAxk6c2 qxk6c2 nxk6c2 rail rail sg13_lv_pmos w=0.56u l=0.13u
XXBxk6c2 nxk6c2 qxk6c2 rail rail sg13_lv_pmos w=0.56u l=0.13u
Cqxk6c2 qxk6c2 0 2f
Cnxk6c2 nxk6c2 0 2f
RA1xk6c2 A1xk6c2 qxk5c2 0.001
RA1Bxk6c2 A1xk6c2_B nxk5c2 0.001
RA2xk6c2 A2xk6c2 qxk5c0 0.001
RA2Bxk6c2 A2xk6c2_B nxk5c0 0.001
RB1xk6c2 B1xk6c2 qxk5c3 0.001
RB1Bxk6c2 B1xk6c2_B nxk5c3 0.001
* stripped o21ai inst=xk6c3 wxc=0.56u
Xxk6c3F1 qxk6c3 B1xk6c3 xk6c3Fi0_0 0 sg13_lv_nmos w=0.74u l=0.13u
Xxk6c3F2 xk6c3Fi0_0 A1xk6c3 0 0 sg13_lv_nmos w=0.74u l=0.13u
Xxk6c3F3 xk6c3Fi0_0 A2xk6c3 0 0 sg13_lv_nmos w=0.74u l=0.13u
Xxk6c3G1 nxk6c3 A1xk6c3_B xk6c3Gi0_0 0 sg13_lv_nmos w=0.74u l=0.13u
Xxk6c3G2 xk6c3Gi0_0 A2xk6c3_B 0 0 sg13_lv_nmos w=0.74u l=0.13u
Xxk6c3G3 nxk6c3 B1xk6c3_B 0 0 sg13_lv_nmos w=0.74u l=0.13u
XXAxk6c3 qxk6c3 nxk6c3 rail rail sg13_lv_pmos w=0.56u l=0.13u
XXBxk6c3 nxk6c3 qxk6c3 rail rail sg13_lv_pmos w=0.56u l=0.13u
Cqxk6c3 qxk6c3 0 2f
Cnxk6c3 nxk6c3 0 2f
RA1xk6c3 A1xk6c3 qxk5c3 0.001
RA1Bxk6c3 A1xk6c3_B nxk5c3 0.001
RA2xk6c3 A2xk6c3 qxk5c1 0.001
RA2Bxk6c3 A2xk6c3_B nxk5c1 0.001
RB1xk6c3 B1xk6c3 qxk5c0 0.001
RB1Bxk6c3 B1xk6c3_B nxk5c0 0.001
.ic V(qxk1c0)=0 V(nxk1c0)=0 V(qxk1c1)=0 V(nxk1c1)=0 V(qxk1c2)=0 V(nxk1c2)=0 V(qxk1c3)=0 V(nxk1c3)=0 V(qxk2c0)=0 V(nxk2c0)=0 V(qxk2c1)=0 V(nxk2c1)=0 V(qxk2c2)=0 V(nxk2c2)=0 V(qxk2c3)=0 V(nxk2c3)=0 V(qxk3c0)=0 V(nxk3c0)=0 V(qxk3c1)=0 V(nxk3c1)=0 V(qxk3c2)=0 V(nxk3c2)=0 V(qxk3c3)=0 V(nxk3c3)=0 V(qxk4c0)=0 V(nxk4c0)=0 V(qxk4c1)=0 V(nxk4c1)=0 V(qxk4c2)=0 V(nxk4c2)=0 V(qxk4c3)=0 V(nxk4c3)=0 V(qxk5c0)=0 V(nxk5c0)=0 V(qxk5c1)=0 V(nxk5c1)=0 V(qxk5c2)=0 V(nxk5c2)=0 V(qxk5c3)=0 V(nxk5c3)=0 V(qxk6c0)=0 V(nxk6c0)=0 V(qxk6c1)=0 V(nxk6c1)=0 V(qxk6c2)=0 V(nxk6c2)=0 V(qxk6c3)=0 V(nxk6c3)=0
.tran 2p 8n 0 4p
.print tran format=noindex V(qxk1c0) V(nxk1c0) V(qxk1c1) V(nxk1c1) V(qxk1c2) V(nxk1c2) V(qxk1c3) V(nxk1c3) V(qxk2c0) V(nxk2c0) V(qxk2c1) V(nxk2c1) V(qxk2c2) V(nxk2c2) V(qxk2c3) V(nxk2c3) V(qxk3c0) V(nxk3c0) V(qxk3c1) V(nxk3c1) V(qxk3c2) V(nxk3c2) V(qxk3c3) V(nxk3c3) V(qxk4c0) V(nxk4c0) V(qxk4c1) V(nxk4c1) V(qxk4c2) V(nxk4c2) V(qxk4c3) V(nxk4c3) V(qxk5c0) V(nxk5c0) V(qxk5c1) V(nxk5c1) V(qxk5c2) V(nxk5c2) V(qxk5c3) V(nxk5c3) V(qxk6c0) V(nxk6c0) V(qxk6c1) V(nxk6c1) V(qxk6c2) V(nxk6c2) V(qxk6c3) V(nxk6c3)
.end
