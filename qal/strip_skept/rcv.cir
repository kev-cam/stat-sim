* SKEPT receiver deck: static campaign-standard inverter (1.12u/0.74u)
* on its OWN rail, N independent copies at constant input, 50 ns steady state
.hdl "/usr/local/share/xyce/verilog-a/psp103/psp103.va"
.include "/usr/local/src/kestrel/sim/models/sg13g2_psp103_tt.lib"
.include "/usr/local/src/stat-sim/qal/sg13lv_compat.sp"
.OPTIONS TIMEINT METHOD=GEAR RELTOL=1e-6 ABSTOL=1e-16 CHGTOL=1e-18
VRr0 railr0 0 0.450000
VIr0_001 ir0_001 0 0.00000
XPr0_001 or0_001 ir0_001 railr0 railr0 sg13_lv_pmos w=1.12u l=0.13u
XNr0_001 or0_001 ir0_001 0 0 sg13_lv_nmos w=0.74u l=0.13u
COr0_001 or0_001 0 2f
VIr0_002 ir0_002 0 0.00500
XPr0_002 or0_002 ir0_002 railr0 railr0 sg13_lv_pmos w=1.12u l=0.13u
XNr0_002 or0_002 ir0_002 0 0 sg13_lv_nmos w=0.74u l=0.13u
COr0_002 or0_002 0 2f
VIr0_003 ir0_003 0 0.01000
XPr0_003 or0_003 ir0_003 railr0 railr0 sg13_lv_pmos w=1.12u l=0.13u
XNr0_003 or0_003 ir0_003 0 0 sg13_lv_nmos w=0.74u l=0.13u
COr0_003 or0_003 0 2f
VIr0_004 ir0_004 0 0.01500
XPr0_004 or0_004 ir0_004 railr0 railr0 sg13_lv_pmos w=1.12u l=0.13u
XNr0_004 or0_004 ir0_004 0 0 sg13_lv_nmos w=0.74u l=0.13u
COr0_004 or0_004 0 2f
VIr0_005 ir0_005 0 0.02000
XPr0_005 or0_005 ir0_005 railr0 railr0 sg13_lv_pmos w=1.12u l=0.13u
XNr0_005 or0_005 ir0_005 0 0 sg13_lv_nmos w=0.74u l=0.13u
COr0_005 or0_005 0 2f
VIr0_006 ir0_006 0 0.02500
XPr0_006 or0_006 ir0_006 railr0 railr0 sg13_lv_pmos w=1.12u l=0.13u
XNr0_006 or0_006 ir0_006 0 0 sg13_lv_nmos w=0.74u l=0.13u
COr0_006 or0_006 0 2f
VIr0_007 ir0_007 0 0.03000
XPr0_007 or0_007 ir0_007 railr0 railr0 sg13_lv_pmos w=1.12u l=0.13u
XNr0_007 or0_007 ir0_007 0 0 sg13_lv_nmos w=0.74u l=0.13u
COr0_007 or0_007 0 2f
VIr0_008 ir0_008 0 0.03500
XPr0_008 or0_008 ir0_008 railr0 railr0 sg13_lv_pmos w=1.12u l=0.13u
XNr0_008 or0_008 ir0_008 0 0 sg13_lv_nmos w=0.74u l=0.13u
COr0_008 or0_008 0 2f
VIr0_009 ir0_009 0 0.04000
XPr0_009 or0_009 ir0_009 railr0 railr0 sg13_lv_pmos w=1.12u l=0.13u
XNr0_009 or0_009 ir0_009 0 0 sg13_lv_nmos w=0.74u l=0.13u
COr0_009 or0_009 0 2f
VIr0_010 ir0_010 0 0.04500
XPr0_010 or0_010 ir0_010 railr0 railr0 sg13_lv_pmos w=1.12u l=0.13u
XNr0_010 or0_010 ir0_010 0 0 sg13_lv_nmos w=0.74u l=0.13u
COr0_010 or0_010 0 2f
VIr0_011 ir0_011 0 0.05000
XPr0_011 or0_011 ir0_011 railr0 railr0 sg13_lv_pmos w=1.12u l=0.13u
XNr0_011 or0_011 ir0_011 0 0 sg13_lv_nmos w=0.74u l=0.13u
COr0_011 or0_011 0 2f
VIr0_012 ir0_012 0 0.05500
XPr0_012 or0_012 ir0_012 railr0 railr0 sg13_lv_pmos w=1.12u l=0.13u
XNr0_012 or0_012 ir0_012 0 0 sg13_lv_nmos w=0.74u l=0.13u
COr0_012 or0_012 0 2f
VIr0_013 ir0_013 0 0.06000
XPr0_013 or0_013 ir0_013 railr0 railr0 sg13_lv_pmos w=1.12u l=0.13u
XNr0_013 or0_013 ir0_013 0 0 sg13_lv_nmos w=0.74u l=0.13u
COr0_013 or0_013 0 2f
VIr0_014 ir0_014 0 0.06500
XPr0_014 or0_014 ir0_014 railr0 railr0 sg13_lv_pmos w=1.12u l=0.13u
XNr0_014 or0_014 ir0_014 0 0 sg13_lv_nmos w=0.74u l=0.13u
COr0_014 or0_014 0 2f
VIr0_015 ir0_015 0 0.07000
XPr0_015 or0_015 ir0_015 railr0 railr0 sg13_lv_pmos w=1.12u l=0.13u
XNr0_015 or0_015 ir0_015 0 0 sg13_lv_nmos w=0.74u l=0.13u
COr0_015 or0_015 0 2f
VIr0_016 ir0_016 0 0.07500
XPr0_016 or0_016 ir0_016 railr0 railr0 sg13_lv_pmos w=1.12u l=0.13u
XNr0_016 or0_016 ir0_016 0 0 sg13_lv_nmos w=0.74u l=0.13u
COr0_016 or0_016 0 2f
VIr0_017 ir0_017 0 0.08000
XPr0_017 or0_017 ir0_017 railr0 railr0 sg13_lv_pmos w=1.12u l=0.13u
XNr0_017 or0_017 ir0_017 0 0 sg13_lv_nmos w=0.74u l=0.13u
COr0_017 or0_017 0 2f
VIr0_018 ir0_018 0 0.08500
XPr0_018 or0_018 ir0_018 railr0 railr0 sg13_lv_pmos w=1.12u l=0.13u
XNr0_018 or0_018 ir0_018 0 0 sg13_lv_nmos w=0.74u l=0.13u
COr0_018 or0_018 0 2f
VIr0_019 ir0_019 0 0.09000
XPr0_019 or0_019 ir0_019 railr0 railr0 sg13_lv_pmos w=1.12u l=0.13u
XNr0_019 or0_019 ir0_019 0 0 sg13_lv_nmos w=0.74u l=0.13u
COr0_019 or0_019 0 2f
VIr0_020 ir0_020 0 0.09500
XPr0_020 or0_020 ir0_020 railr0 railr0 sg13_lv_pmos w=1.12u l=0.13u
XNr0_020 or0_020 ir0_020 0 0 sg13_lv_nmos w=0.74u l=0.13u
COr0_020 or0_020 0 2f
VIr0_021 ir0_021 0 0.10000
XPr0_021 or0_021 ir0_021 railr0 railr0 sg13_lv_pmos w=1.12u l=0.13u
XNr0_021 or0_021 ir0_021 0 0 sg13_lv_nmos w=0.74u l=0.13u
COr0_021 or0_021 0 2f
VIr0_022 ir0_022 0 0.10500
XPr0_022 or0_022 ir0_022 railr0 railr0 sg13_lv_pmos w=1.12u l=0.13u
XNr0_022 or0_022 ir0_022 0 0 sg13_lv_nmos w=0.74u l=0.13u
COr0_022 or0_022 0 2f
VIr0_023 ir0_023 0 0.11000
XPr0_023 or0_023 ir0_023 railr0 railr0 sg13_lv_pmos w=1.12u l=0.13u
XNr0_023 or0_023 ir0_023 0 0 sg13_lv_nmos w=0.74u l=0.13u
COr0_023 or0_023 0 2f
VIr0_024 ir0_024 0 0.11500
XPr0_024 or0_024 ir0_024 railr0 railr0 sg13_lv_pmos w=1.12u l=0.13u
XNr0_024 or0_024 ir0_024 0 0 sg13_lv_nmos w=0.74u l=0.13u
COr0_024 or0_024 0 2f
VIr0_025 ir0_025 0 0.12000
XPr0_025 or0_025 ir0_025 railr0 railr0 sg13_lv_pmos w=1.12u l=0.13u
XNr0_025 or0_025 ir0_025 0 0 sg13_lv_nmos w=0.74u l=0.13u
COr0_025 or0_025 0 2f
VIr0_026 ir0_026 0 0.12500
XPr0_026 or0_026 ir0_026 railr0 railr0 sg13_lv_pmos w=1.12u l=0.13u
XNr0_026 or0_026 ir0_026 0 0 sg13_lv_nmos w=0.74u l=0.13u
COr0_026 or0_026 0 2f
VIr0_027 ir0_027 0 0.13000
XPr0_027 or0_027 ir0_027 railr0 railr0 sg13_lv_pmos w=1.12u l=0.13u
XNr0_027 or0_027 ir0_027 0 0 sg13_lv_nmos w=0.74u l=0.13u
COr0_027 or0_027 0 2f
VIr0_028 ir0_028 0 0.13500
XPr0_028 or0_028 ir0_028 railr0 railr0 sg13_lv_pmos w=1.12u l=0.13u
XNr0_028 or0_028 ir0_028 0 0 sg13_lv_nmos w=0.74u l=0.13u
COr0_028 or0_028 0 2f
VIr0_029 ir0_029 0 0.14000
XPr0_029 or0_029 ir0_029 railr0 railr0 sg13_lv_pmos w=1.12u l=0.13u
XNr0_029 or0_029 ir0_029 0 0 sg13_lv_nmos w=0.74u l=0.13u
COr0_029 or0_029 0 2f
VIr0_030 ir0_030 0 0.14500
XPr0_030 or0_030 ir0_030 railr0 railr0 sg13_lv_pmos w=1.12u l=0.13u
XNr0_030 or0_030 ir0_030 0 0 sg13_lv_nmos w=0.74u l=0.13u
COr0_030 or0_030 0 2f
VIr0_031 ir0_031 0 0.15000
XPr0_031 or0_031 ir0_031 railr0 railr0 sg13_lv_pmos w=1.12u l=0.13u
XNr0_031 or0_031 ir0_031 0 0 sg13_lv_nmos w=0.74u l=0.13u
COr0_031 or0_031 0 2f
VIr0_032 ir0_032 0 0.15500
XPr0_032 or0_032 ir0_032 railr0 railr0 sg13_lv_pmos w=1.12u l=0.13u
XNr0_032 or0_032 ir0_032 0 0 sg13_lv_nmos w=0.74u l=0.13u
COr0_032 or0_032 0 2f
VIr0_033 ir0_033 0 0.16000
XPr0_033 or0_033 ir0_033 railr0 railr0 sg13_lv_pmos w=1.12u l=0.13u
XNr0_033 or0_033 ir0_033 0 0 sg13_lv_nmos w=0.74u l=0.13u
COr0_033 or0_033 0 2f
VIr0_034 ir0_034 0 0.16500
XPr0_034 or0_034 ir0_034 railr0 railr0 sg13_lv_pmos w=1.12u l=0.13u
XNr0_034 or0_034 ir0_034 0 0 sg13_lv_nmos w=0.74u l=0.13u
COr0_034 or0_034 0 2f
VIr0_035 ir0_035 0 0.17000
XPr0_035 or0_035 ir0_035 railr0 railr0 sg13_lv_pmos w=1.12u l=0.13u
XNr0_035 or0_035 ir0_035 0 0 sg13_lv_nmos w=0.74u l=0.13u
COr0_035 or0_035 0 2f
VIr0_036 ir0_036 0 0.17500
XPr0_036 or0_036 ir0_036 railr0 railr0 sg13_lv_pmos w=1.12u l=0.13u
XNr0_036 or0_036 ir0_036 0 0 sg13_lv_nmos w=0.74u l=0.13u
COr0_036 or0_036 0 2f
VIr0_037 ir0_037 0 0.18000
XPr0_037 or0_037 ir0_037 railr0 railr0 sg13_lv_pmos w=1.12u l=0.13u
XNr0_037 or0_037 ir0_037 0 0 sg13_lv_nmos w=0.74u l=0.13u
COr0_037 or0_037 0 2f
VIr0_038 ir0_038 0 0.18500
XPr0_038 or0_038 ir0_038 railr0 railr0 sg13_lv_pmos w=1.12u l=0.13u
XNr0_038 or0_038 ir0_038 0 0 sg13_lv_nmos w=0.74u l=0.13u
COr0_038 or0_038 0 2f
VIr0_039 ir0_039 0 0.19000
XPr0_039 or0_039 ir0_039 railr0 railr0 sg13_lv_pmos w=1.12u l=0.13u
XNr0_039 or0_039 ir0_039 0 0 sg13_lv_nmos w=0.74u l=0.13u
COr0_039 or0_039 0 2f
VIr0_040 ir0_040 0 0.19500
XPr0_040 or0_040 ir0_040 railr0 railr0 sg13_lv_pmos w=1.12u l=0.13u
XNr0_040 or0_040 ir0_040 0 0 sg13_lv_nmos w=0.74u l=0.13u
COr0_040 or0_040 0 2f
VIr0_041 ir0_041 0 0.20000
XPr0_041 or0_041 ir0_041 railr0 railr0 sg13_lv_pmos w=1.12u l=0.13u
XNr0_041 or0_041 ir0_041 0 0 sg13_lv_nmos w=0.74u l=0.13u
COr0_041 or0_041 0 2f
VIr0_042 ir0_042 0 0.20500
XPr0_042 or0_042 ir0_042 railr0 railr0 sg13_lv_pmos w=1.12u l=0.13u
XNr0_042 or0_042 ir0_042 0 0 sg13_lv_nmos w=0.74u l=0.13u
COr0_042 or0_042 0 2f
VIr0_043 ir0_043 0 0.21000
XPr0_043 or0_043 ir0_043 railr0 railr0 sg13_lv_pmos w=1.12u l=0.13u
XNr0_043 or0_043 ir0_043 0 0 sg13_lv_nmos w=0.74u l=0.13u
COr0_043 or0_043 0 2f
VIr0_044 ir0_044 0 0.21500
XPr0_044 or0_044 ir0_044 railr0 railr0 sg13_lv_pmos w=1.12u l=0.13u
XNr0_044 or0_044 ir0_044 0 0 sg13_lv_nmos w=0.74u l=0.13u
COr0_044 or0_044 0 2f
VIr0_045 ir0_045 0 0.22000
XPr0_045 or0_045 ir0_045 railr0 railr0 sg13_lv_pmos w=1.12u l=0.13u
XNr0_045 or0_045 ir0_045 0 0 sg13_lv_nmos w=0.74u l=0.13u
COr0_045 or0_045 0 2f
VIr0_046 ir0_046 0 0.22500
XPr0_046 or0_046 ir0_046 railr0 railr0 sg13_lv_pmos w=1.12u l=0.13u
XNr0_046 or0_046 ir0_046 0 0 sg13_lv_nmos w=0.74u l=0.13u
COr0_046 or0_046 0 2f
VIr0_047 ir0_047 0 0.23000
XPr0_047 or0_047 ir0_047 railr0 railr0 sg13_lv_pmos w=1.12u l=0.13u
XNr0_047 or0_047 ir0_047 0 0 sg13_lv_nmos w=0.74u l=0.13u
COr0_047 or0_047 0 2f
VIr0_048 ir0_048 0 0.23500
XPr0_048 or0_048 ir0_048 railr0 railr0 sg13_lv_pmos w=1.12u l=0.13u
XNr0_048 or0_048 ir0_048 0 0 sg13_lv_nmos w=0.74u l=0.13u
COr0_048 or0_048 0 2f
VIr0_049 ir0_049 0 0.24000
XPr0_049 or0_049 ir0_049 railr0 railr0 sg13_lv_pmos w=1.12u l=0.13u
XNr0_049 or0_049 ir0_049 0 0 sg13_lv_nmos w=0.74u l=0.13u
COr0_049 or0_049 0 2f
VIr0_050 ir0_050 0 0.24500
XPr0_050 or0_050 ir0_050 railr0 railr0 sg13_lv_pmos w=1.12u l=0.13u
XNr0_050 or0_050 ir0_050 0 0 sg13_lv_nmos w=0.74u l=0.13u
COr0_050 or0_050 0 2f
VIr0_051 ir0_051 0 0.25000
XPr0_051 or0_051 ir0_051 railr0 railr0 sg13_lv_pmos w=1.12u l=0.13u
XNr0_051 or0_051 ir0_051 0 0 sg13_lv_nmos w=0.74u l=0.13u
COr0_051 or0_051 0 2f
VIr0_052 ir0_052 0 0.25500
XPr0_052 or0_052 ir0_052 railr0 railr0 sg13_lv_pmos w=1.12u l=0.13u
XNr0_052 or0_052 ir0_052 0 0 sg13_lv_nmos w=0.74u l=0.13u
COr0_052 or0_052 0 2f
VIr0_053 ir0_053 0 0.26000
XPr0_053 or0_053 ir0_053 railr0 railr0 sg13_lv_pmos w=1.12u l=0.13u
XNr0_053 or0_053 ir0_053 0 0 sg13_lv_nmos w=0.74u l=0.13u
COr0_053 or0_053 0 2f
VIr0_054 ir0_054 0 0.26500
XPr0_054 or0_054 ir0_054 railr0 railr0 sg13_lv_pmos w=1.12u l=0.13u
XNr0_054 or0_054 ir0_054 0 0 sg13_lv_nmos w=0.74u l=0.13u
COr0_054 or0_054 0 2f
VIr0_055 ir0_055 0 0.27000
XPr0_055 or0_055 ir0_055 railr0 railr0 sg13_lv_pmos w=1.12u l=0.13u
XNr0_055 or0_055 ir0_055 0 0 sg13_lv_nmos w=0.74u l=0.13u
COr0_055 or0_055 0 2f
VIr0_056 ir0_056 0 0.27500
XPr0_056 or0_056 ir0_056 railr0 railr0 sg13_lv_pmos w=1.12u l=0.13u
XNr0_056 or0_056 ir0_056 0 0 sg13_lv_nmos w=0.74u l=0.13u
COr0_056 or0_056 0 2f
VIr0_057 ir0_057 0 0.28000
XPr0_057 or0_057 ir0_057 railr0 railr0 sg13_lv_pmos w=1.12u l=0.13u
XNr0_057 or0_057 ir0_057 0 0 sg13_lv_nmos w=0.74u l=0.13u
COr0_057 or0_057 0 2f
VIr0_058 ir0_058 0 0.28500
XPr0_058 or0_058 ir0_058 railr0 railr0 sg13_lv_pmos w=1.12u l=0.13u
XNr0_058 or0_058 ir0_058 0 0 sg13_lv_nmos w=0.74u l=0.13u
COr0_058 or0_058 0 2f
VIr0_059 ir0_059 0 0.29000
XPr0_059 or0_059 ir0_059 railr0 railr0 sg13_lv_pmos w=1.12u l=0.13u
XNr0_059 or0_059 ir0_059 0 0 sg13_lv_nmos w=0.74u l=0.13u
COr0_059 or0_059 0 2f
VIr0_060 ir0_060 0 0.29500
XPr0_060 or0_060 ir0_060 railr0 railr0 sg13_lv_pmos w=1.12u l=0.13u
XNr0_060 or0_060 ir0_060 0 0 sg13_lv_nmos w=0.74u l=0.13u
COr0_060 or0_060 0 2f
VIr0_061 ir0_061 0 0.30000
XPr0_061 or0_061 ir0_061 railr0 railr0 sg13_lv_pmos w=1.12u l=0.13u
XNr0_061 or0_061 ir0_061 0 0 sg13_lv_nmos w=0.74u l=0.13u
COr0_061 or0_061 0 2f
VIr0_062 ir0_062 0 0.30500
XPr0_062 or0_062 ir0_062 railr0 railr0 sg13_lv_pmos w=1.12u l=0.13u
XNr0_062 or0_062 ir0_062 0 0 sg13_lv_nmos w=0.74u l=0.13u
COr0_062 or0_062 0 2f
VIr0_063 ir0_063 0 0.31000
XPr0_063 or0_063 ir0_063 railr0 railr0 sg13_lv_pmos w=1.12u l=0.13u
XNr0_063 or0_063 ir0_063 0 0 sg13_lv_nmos w=0.74u l=0.13u
COr0_063 or0_063 0 2f
VIr0_064 ir0_064 0 0.31500
XPr0_064 or0_064 ir0_064 railr0 railr0 sg13_lv_pmos w=1.12u l=0.13u
XNr0_064 or0_064 ir0_064 0 0 sg13_lv_nmos w=0.74u l=0.13u
COr0_064 or0_064 0 2f
VIr0_065 ir0_065 0 0.32000
XPr0_065 or0_065 ir0_065 railr0 railr0 sg13_lv_pmos w=1.12u l=0.13u
XNr0_065 or0_065 ir0_065 0 0 sg13_lv_nmos w=0.74u l=0.13u
COr0_065 or0_065 0 2f
VIr0_066 ir0_066 0 0.32500
XPr0_066 or0_066 ir0_066 railr0 railr0 sg13_lv_pmos w=1.12u l=0.13u
XNr0_066 or0_066 ir0_066 0 0 sg13_lv_nmos w=0.74u l=0.13u
COr0_066 or0_066 0 2f
VIr0_067 ir0_067 0 0.33000
XPr0_067 or0_067 ir0_067 railr0 railr0 sg13_lv_pmos w=1.12u l=0.13u
XNr0_067 or0_067 ir0_067 0 0 sg13_lv_nmos w=0.74u l=0.13u
COr0_067 or0_067 0 2f
VIr0_068 ir0_068 0 0.33500
XPr0_068 or0_068 ir0_068 railr0 railr0 sg13_lv_pmos w=1.12u l=0.13u
XNr0_068 or0_068 ir0_068 0 0 sg13_lv_nmos w=0.74u l=0.13u
COr0_068 or0_068 0 2f
VIr0_069 ir0_069 0 0.34000
XPr0_069 or0_069 ir0_069 railr0 railr0 sg13_lv_pmos w=1.12u l=0.13u
XNr0_069 or0_069 ir0_069 0 0 sg13_lv_nmos w=0.74u l=0.13u
COr0_069 or0_069 0 2f
VIr0_070 ir0_070 0 0.34500
XPr0_070 or0_070 ir0_070 railr0 railr0 sg13_lv_pmos w=1.12u l=0.13u
XNr0_070 or0_070 ir0_070 0 0 sg13_lv_nmos w=0.74u l=0.13u
COr0_070 or0_070 0 2f
VIr0_071 ir0_071 0 0.35000
XPr0_071 or0_071 ir0_071 railr0 railr0 sg13_lv_pmos w=1.12u l=0.13u
XNr0_071 or0_071 ir0_071 0 0 sg13_lv_nmos w=0.74u l=0.13u
COr0_071 or0_071 0 2f
VIr0_072 ir0_072 0 0.35500
XPr0_072 or0_072 ir0_072 railr0 railr0 sg13_lv_pmos w=1.12u l=0.13u
XNr0_072 or0_072 ir0_072 0 0 sg13_lv_nmos w=0.74u l=0.13u
COr0_072 or0_072 0 2f
VIr0_073 ir0_073 0 0.36000
XPr0_073 or0_073 ir0_073 railr0 railr0 sg13_lv_pmos w=1.12u l=0.13u
XNr0_073 or0_073 ir0_073 0 0 sg13_lv_nmos w=0.74u l=0.13u
COr0_073 or0_073 0 2f
VIr0_074 ir0_074 0 0.36500
XPr0_074 or0_074 ir0_074 railr0 railr0 sg13_lv_pmos w=1.12u l=0.13u
XNr0_074 or0_074 ir0_074 0 0 sg13_lv_nmos w=0.74u l=0.13u
COr0_074 or0_074 0 2f
VIr0_075 ir0_075 0 0.37000
XPr0_075 or0_075 ir0_075 railr0 railr0 sg13_lv_pmos w=1.12u l=0.13u
XNr0_075 or0_075 ir0_075 0 0 sg13_lv_nmos w=0.74u l=0.13u
COr0_075 or0_075 0 2f
VIr0_076 ir0_076 0 0.37500
XPr0_076 or0_076 ir0_076 railr0 railr0 sg13_lv_pmos w=1.12u l=0.13u
XNr0_076 or0_076 ir0_076 0 0 sg13_lv_nmos w=0.74u l=0.13u
COr0_076 or0_076 0 2f
VIr0_077 ir0_077 0 0.38000
XPr0_077 or0_077 ir0_077 railr0 railr0 sg13_lv_pmos w=1.12u l=0.13u
XNr0_077 or0_077 ir0_077 0 0 sg13_lv_nmos w=0.74u l=0.13u
COr0_077 or0_077 0 2f
VIr0_078 ir0_078 0 0.38500
XPr0_078 or0_078 ir0_078 railr0 railr0 sg13_lv_pmos w=1.12u l=0.13u
XNr0_078 or0_078 ir0_078 0 0 sg13_lv_nmos w=0.74u l=0.13u
COr0_078 or0_078 0 2f
VIr0_079 ir0_079 0 0.39000
XPr0_079 or0_079 ir0_079 railr0 railr0 sg13_lv_pmos w=1.12u l=0.13u
XNr0_079 or0_079 ir0_079 0 0 sg13_lv_nmos w=0.74u l=0.13u
COr0_079 or0_079 0 2f
VIr0_080 ir0_080 0 0.39500
XPr0_080 or0_080 ir0_080 railr0 railr0 sg13_lv_pmos w=1.12u l=0.13u
XNr0_080 or0_080 ir0_080 0 0 sg13_lv_nmos w=0.74u l=0.13u
COr0_080 or0_080 0 2f
VIr0_081 ir0_081 0 0.40000
XPr0_081 or0_081 ir0_081 railr0 railr0 sg13_lv_pmos w=1.12u l=0.13u
XNr0_081 or0_081 ir0_081 0 0 sg13_lv_nmos w=0.74u l=0.13u
COr0_081 or0_081 0 2f
VIr0_082 ir0_082 0 0.40500
XPr0_082 or0_082 ir0_082 railr0 railr0 sg13_lv_pmos w=1.12u l=0.13u
XNr0_082 or0_082 ir0_082 0 0 sg13_lv_nmos w=0.74u l=0.13u
COr0_082 or0_082 0 2f
VIr0_083 ir0_083 0 0.41000
XPr0_083 or0_083 ir0_083 railr0 railr0 sg13_lv_pmos w=1.12u l=0.13u
XNr0_083 or0_083 ir0_083 0 0 sg13_lv_nmos w=0.74u l=0.13u
COr0_083 or0_083 0 2f
VIr0_084 ir0_084 0 0.41500
XPr0_084 or0_084 ir0_084 railr0 railr0 sg13_lv_pmos w=1.12u l=0.13u
XNr0_084 or0_084 ir0_084 0 0 sg13_lv_nmos w=0.74u l=0.13u
COr0_084 or0_084 0 2f
VIr0_085 ir0_085 0 0.42000
XPr0_085 or0_085 ir0_085 railr0 railr0 sg13_lv_pmos w=1.12u l=0.13u
XNr0_085 or0_085 ir0_085 0 0 sg13_lv_nmos w=0.74u l=0.13u
COr0_085 or0_085 0 2f
VIr0_086 ir0_086 0 0.42500
XPr0_086 or0_086 ir0_086 railr0 railr0 sg13_lv_pmos w=1.12u l=0.13u
XNr0_086 or0_086 ir0_086 0 0 sg13_lv_nmos w=0.74u l=0.13u
COr0_086 or0_086 0 2f
VIr0_087 ir0_087 0 0.43000
XPr0_087 or0_087 ir0_087 railr0 railr0 sg13_lv_pmos w=1.12u l=0.13u
XNr0_087 or0_087 ir0_087 0 0 sg13_lv_nmos w=0.74u l=0.13u
COr0_087 or0_087 0 2f
VIr0_088 ir0_088 0 0.43500
XPr0_088 or0_088 ir0_088 railr0 railr0 sg13_lv_pmos w=1.12u l=0.13u
XNr0_088 or0_088 ir0_088 0 0 sg13_lv_nmos w=0.74u l=0.13u
COr0_088 or0_088 0 2f
VIr0_089 ir0_089 0 0.44000
XPr0_089 or0_089 ir0_089 railr0 railr0 sg13_lv_pmos w=1.12u l=0.13u
XNr0_089 or0_089 ir0_089 0 0 sg13_lv_nmos w=0.74u l=0.13u
COr0_089 or0_089 0 2f
VIr0_090 ir0_090 0 0.44500
XPr0_090 or0_090 ir0_090 railr0 railr0 sg13_lv_pmos w=1.12u l=0.13u
XNr0_090 or0_090 ir0_090 0 0 sg13_lv_nmos w=0.74u l=0.13u
COr0_090 or0_090 0 2f
VIr0_091 ir0_091 0 0.45000
XPr0_091 or0_091 ir0_091 railr0 railr0 sg13_lv_pmos w=1.12u l=0.13u
XNr0_091 or0_091 ir0_091 0 0 sg13_lv_nmos w=0.74u l=0.13u
COr0_091 or0_091 0 2f
VRr1 railr1 0 0.557100
VIr1_001 ir1_001 0 0.00000
XPr1_001 or1_001 ir1_001 railr1 railr1 sg13_lv_pmos w=1.12u l=0.13u
XNr1_001 or1_001 ir1_001 0 0 sg13_lv_nmos w=0.74u l=0.13u
COr1_001 or1_001 0 2f
VIr1_002 ir1_002 0 0.00500
XPr1_002 or1_002 ir1_002 railr1 railr1 sg13_lv_pmos w=1.12u l=0.13u
XNr1_002 or1_002 ir1_002 0 0 sg13_lv_nmos w=0.74u l=0.13u
COr1_002 or1_002 0 2f
VIr1_003 ir1_003 0 0.01000
XPr1_003 or1_003 ir1_003 railr1 railr1 sg13_lv_pmos w=1.12u l=0.13u
XNr1_003 or1_003 ir1_003 0 0 sg13_lv_nmos w=0.74u l=0.13u
COr1_003 or1_003 0 2f
VIr1_004 ir1_004 0 0.01500
XPr1_004 or1_004 ir1_004 railr1 railr1 sg13_lv_pmos w=1.12u l=0.13u
XNr1_004 or1_004 ir1_004 0 0 sg13_lv_nmos w=0.74u l=0.13u
COr1_004 or1_004 0 2f
VIr1_005 ir1_005 0 0.02000
XPr1_005 or1_005 ir1_005 railr1 railr1 sg13_lv_pmos w=1.12u l=0.13u
XNr1_005 or1_005 ir1_005 0 0 sg13_lv_nmos w=0.74u l=0.13u
COr1_005 or1_005 0 2f
VIr1_006 ir1_006 0 0.02500
XPr1_006 or1_006 ir1_006 railr1 railr1 sg13_lv_pmos w=1.12u l=0.13u
XNr1_006 or1_006 ir1_006 0 0 sg13_lv_nmos w=0.74u l=0.13u
COr1_006 or1_006 0 2f
VIr1_007 ir1_007 0 0.03000
XPr1_007 or1_007 ir1_007 railr1 railr1 sg13_lv_pmos w=1.12u l=0.13u
XNr1_007 or1_007 ir1_007 0 0 sg13_lv_nmos w=0.74u l=0.13u
COr1_007 or1_007 0 2f
VIr1_008 ir1_008 0 0.03500
XPr1_008 or1_008 ir1_008 railr1 railr1 sg13_lv_pmos w=1.12u l=0.13u
XNr1_008 or1_008 ir1_008 0 0 sg13_lv_nmos w=0.74u l=0.13u
COr1_008 or1_008 0 2f
VIr1_009 ir1_009 0 0.04000
XPr1_009 or1_009 ir1_009 railr1 railr1 sg13_lv_pmos w=1.12u l=0.13u
XNr1_009 or1_009 ir1_009 0 0 sg13_lv_nmos w=0.74u l=0.13u
COr1_009 or1_009 0 2f
VIr1_010 ir1_010 0 0.04500
XPr1_010 or1_010 ir1_010 railr1 railr1 sg13_lv_pmos w=1.12u l=0.13u
XNr1_010 or1_010 ir1_010 0 0 sg13_lv_nmos w=0.74u l=0.13u
COr1_010 or1_010 0 2f
VIr1_011 ir1_011 0 0.05000
XPr1_011 or1_011 ir1_011 railr1 railr1 sg13_lv_pmos w=1.12u l=0.13u
XNr1_011 or1_011 ir1_011 0 0 sg13_lv_nmos w=0.74u l=0.13u
COr1_011 or1_011 0 2f
VIr1_012 ir1_012 0 0.05500
XPr1_012 or1_012 ir1_012 railr1 railr1 sg13_lv_pmos w=1.12u l=0.13u
XNr1_012 or1_012 ir1_012 0 0 sg13_lv_nmos w=0.74u l=0.13u
COr1_012 or1_012 0 2f
VIr1_013 ir1_013 0 0.06000
XPr1_013 or1_013 ir1_013 railr1 railr1 sg13_lv_pmos w=1.12u l=0.13u
XNr1_013 or1_013 ir1_013 0 0 sg13_lv_nmos w=0.74u l=0.13u
COr1_013 or1_013 0 2f
VIr1_014 ir1_014 0 0.06500
XPr1_014 or1_014 ir1_014 railr1 railr1 sg13_lv_pmos w=1.12u l=0.13u
XNr1_014 or1_014 ir1_014 0 0 sg13_lv_nmos w=0.74u l=0.13u
COr1_014 or1_014 0 2f
VIr1_015 ir1_015 0 0.07000
XPr1_015 or1_015 ir1_015 railr1 railr1 sg13_lv_pmos w=1.12u l=0.13u
XNr1_015 or1_015 ir1_015 0 0 sg13_lv_nmos w=0.74u l=0.13u
COr1_015 or1_015 0 2f
VIr1_016 ir1_016 0 0.07500
XPr1_016 or1_016 ir1_016 railr1 railr1 sg13_lv_pmos w=1.12u l=0.13u
XNr1_016 or1_016 ir1_016 0 0 sg13_lv_nmos w=0.74u l=0.13u
COr1_016 or1_016 0 2f
VIr1_017 ir1_017 0 0.08000
XPr1_017 or1_017 ir1_017 railr1 railr1 sg13_lv_pmos w=1.12u l=0.13u
XNr1_017 or1_017 ir1_017 0 0 sg13_lv_nmos w=0.74u l=0.13u
COr1_017 or1_017 0 2f
VIr1_018 ir1_018 0 0.08500
XPr1_018 or1_018 ir1_018 railr1 railr1 sg13_lv_pmos w=1.12u l=0.13u
XNr1_018 or1_018 ir1_018 0 0 sg13_lv_nmos w=0.74u l=0.13u
COr1_018 or1_018 0 2f
VIr1_019 ir1_019 0 0.09000
XPr1_019 or1_019 ir1_019 railr1 railr1 sg13_lv_pmos w=1.12u l=0.13u
XNr1_019 or1_019 ir1_019 0 0 sg13_lv_nmos w=0.74u l=0.13u
COr1_019 or1_019 0 2f
VIr1_020 ir1_020 0 0.09500
XPr1_020 or1_020 ir1_020 railr1 railr1 sg13_lv_pmos w=1.12u l=0.13u
XNr1_020 or1_020 ir1_020 0 0 sg13_lv_nmos w=0.74u l=0.13u
COr1_020 or1_020 0 2f
VIr1_021 ir1_021 0 0.10000
XPr1_021 or1_021 ir1_021 railr1 railr1 sg13_lv_pmos w=1.12u l=0.13u
XNr1_021 or1_021 ir1_021 0 0 sg13_lv_nmos w=0.74u l=0.13u
COr1_021 or1_021 0 2f
VIr1_022 ir1_022 0 0.10500
XPr1_022 or1_022 ir1_022 railr1 railr1 sg13_lv_pmos w=1.12u l=0.13u
XNr1_022 or1_022 ir1_022 0 0 sg13_lv_nmos w=0.74u l=0.13u
COr1_022 or1_022 0 2f
VIr1_023 ir1_023 0 0.11000
XPr1_023 or1_023 ir1_023 railr1 railr1 sg13_lv_pmos w=1.12u l=0.13u
XNr1_023 or1_023 ir1_023 0 0 sg13_lv_nmos w=0.74u l=0.13u
COr1_023 or1_023 0 2f
VIr1_024 ir1_024 0 0.11500
XPr1_024 or1_024 ir1_024 railr1 railr1 sg13_lv_pmos w=1.12u l=0.13u
XNr1_024 or1_024 ir1_024 0 0 sg13_lv_nmos w=0.74u l=0.13u
COr1_024 or1_024 0 2f
VIr1_025 ir1_025 0 0.12000
XPr1_025 or1_025 ir1_025 railr1 railr1 sg13_lv_pmos w=1.12u l=0.13u
XNr1_025 or1_025 ir1_025 0 0 sg13_lv_nmos w=0.74u l=0.13u
COr1_025 or1_025 0 2f
VIr1_026 ir1_026 0 0.12500
XPr1_026 or1_026 ir1_026 railr1 railr1 sg13_lv_pmos w=1.12u l=0.13u
XNr1_026 or1_026 ir1_026 0 0 sg13_lv_nmos w=0.74u l=0.13u
COr1_026 or1_026 0 2f
VIr1_027 ir1_027 0 0.13000
XPr1_027 or1_027 ir1_027 railr1 railr1 sg13_lv_pmos w=1.12u l=0.13u
XNr1_027 or1_027 ir1_027 0 0 sg13_lv_nmos w=0.74u l=0.13u
COr1_027 or1_027 0 2f
VIr1_028 ir1_028 0 0.13500
XPr1_028 or1_028 ir1_028 railr1 railr1 sg13_lv_pmos w=1.12u l=0.13u
XNr1_028 or1_028 ir1_028 0 0 sg13_lv_nmos w=0.74u l=0.13u
COr1_028 or1_028 0 2f
VIr1_029 ir1_029 0 0.14000
XPr1_029 or1_029 ir1_029 railr1 railr1 sg13_lv_pmos w=1.12u l=0.13u
XNr1_029 or1_029 ir1_029 0 0 sg13_lv_nmos w=0.74u l=0.13u
COr1_029 or1_029 0 2f
VIr1_030 ir1_030 0 0.14500
XPr1_030 or1_030 ir1_030 railr1 railr1 sg13_lv_pmos w=1.12u l=0.13u
XNr1_030 or1_030 ir1_030 0 0 sg13_lv_nmos w=0.74u l=0.13u
COr1_030 or1_030 0 2f
VIr1_031 ir1_031 0 0.15000
XPr1_031 or1_031 ir1_031 railr1 railr1 sg13_lv_pmos w=1.12u l=0.13u
XNr1_031 or1_031 ir1_031 0 0 sg13_lv_nmos w=0.74u l=0.13u
COr1_031 or1_031 0 2f
VIr1_032 ir1_032 0 0.15500
XPr1_032 or1_032 ir1_032 railr1 railr1 sg13_lv_pmos w=1.12u l=0.13u
XNr1_032 or1_032 ir1_032 0 0 sg13_lv_nmos w=0.74u l=0.13u
COr1_032 or1_032 0 2f
VIr1_033 ir1_033 0 0.16000
XPr1_033 or1_033 ir1_033 railr1 railr1 sg13_lv_pmos w=1.12u l=0.13u
XNr1_033 or1_033 ir1_033 0 0 sg13_lv_nmos w=0.74u l=0.13u
COr1_033 or1_033 0 2f
VIr1_034 ir1_034 0 0.16500
XPr1_034 or1_034 ir1_034 railr1 railr1 sg13_lv_pmos w=1.12u l=0.13u
XNr1_034 or1_034 ir1_034 0 0 sg13_lv_nmos w=0.74u l=0.13u
COr1_034 or1_034 0 2f
VIr1_035 ir1_035 0 0.17000
XPr1_035 or1_035 ir1_035 railr1 railr1 sg13_lv_pmos w=1.12u l=0.13u
XNr1_035 or1_035 ir1_035 0 0 sg13_lv_nmos w=0.74u l=0.13u
COr1_035 or1_035 0 2f
VIr1_036 ir1_036 0 0.17500
XPr1_036 or1_036 ir1_036 railr1 railr1 sg13_lv_pmos w=1.12u l=0.13u
XNr1_036 or1_036 ir1_036 0 0 sg13_lv_nmos w=0.74u l=0.13u
COr1_036 or1_036 0 2f
VIr1_037 ir1_037 0 0.18000
XPr1_037 or1_037 ir1_037 railr1 railr1 sg13_lv_pmos w=1.12u l=0.13u
XNr1_037 or1_037 ir1_037 0 0 sg13_lv_nmos w=0.74u l=0.13u
COr1_037 or1_037 0 2f
VIr1_038 ir1_038 0 0.18500
XPr1_038 or1_038 ir1_038 railr1 railr1 sg13_lv_pmos w=1.12u l=0.13u
XNr1_038 or1_038 ir1_038 0 0 sg13_lv_nmos w=0.74u l=0.13u
COr1_038 or1_038 0 2f
VIr1_039 ir1_039 0 0.19000
XPr1_039 or1_039 ir1_039 railr1 railr1 sg13_lv_pmos w=1.12u l=0.13u
XNr1_039 or1_039 ir1_039 0 0 sg13_lv_nmos w=0.74u l=0.13u
COr1_039 or1_039 0 2f
VIr1_040 ir1_040 0 0.19500
XPr1_040 or1_040 ir1_040 railr1 railr1 sg13_lv_pmos w=1.12u l=0.13u
XNr1_040 or1_040 ir1_040 0 0 sg13_lv_nmos w=0.74u l=0.13u
COr1_040 or1_040 0 2f
VIr1_041 ir1_041 0 0.20000
XPr1_041 or1_041 ir1_041 railr1 railr1 sg13_lv_pmos w=1.12u l=0.13u
XNr1_041 or1_041 ir1_041 0 0 sg13_lv_nmos w=0.74u l=0.13u
COr1_041 or1_041 0 2f
VIr1_042 ir1_042 0 0.20500
XPr1_042 or1_042 ir1_042 railr1 railr1 sg13_lv_pmos w=1.12u l=0.13u
XNr1_042 or1_042 ir1_042 0 0 sg13_lv_nmos w=0.74u l=0.13u
COr1_042 or1_042 0 2f
VIr1_043 ir1_043 0 0.21000
XPr1_043 or1_043 ir1_043 railr1 railr1 sg13_lv_pmos w=1.12u l=0.13u
XNr1_043 or1_043 ir1_043 0 0 sg13_lv_nmos w=0.74u l=0.13u
COr1_043 or1_043 0 2f
VIr1_044 ir1_044 0 0.21500
XPr1_044 or1_044 ir1_044 railr1 railr1 sg13_lv_pmos w=1.12u l=0.13u
XNr1_044 or1_044 ir1_044 0 0 sg13_lv_nmos w=0.74u l=0.13u
COr1_044 or1_044 0 2f
VIr1_045 ir1_045 0 0.22000
XPr1_045 or1_045 ir1_045 railr1 railr1 sg13_lv_pmos w=1.12u l=0.13u
XNr1_045 or1_045 ir1_045 0 0 sg13_lv_nmos w=0.74u l=0.13u
COr1_045 or1_045 0 2f
VIr1_046 ir1_046 0 0.22500
XPr1_046 or1_046 ir1_046 railr1 railr1 sg13_lv_pmos w=1.12u l=0.13u
XNr1_046 or1_046 ir1_046 0 0 sg13_lv_nmos w=0.74u l=0.13u
COr1_046 or1_046 0 2f
VIr1_047 ir1_047 0 0.23000
XPr1_047 or1_047 ir1_047 railr1 railr1 sg13_lv_pmos w=1.12u l=0.13u
XNr1_047 or1_047 ir1_047 0 0 sg13_lv_nmos w=0.74u l=0.13u
COr1_047 or1_047 0 2f
VIr1_048 ir1_048 0 0.23500
XPr1_048 or1_048 ir1_048 railr1 railr1 sg13_lv_pmos w=1.12u l=0.13u
XNr1_048 or1_048 ir1_048 0 0 sg13_lv_nmos w=0.74u l=0.13u
COr1_048 or1_048 0 2f
VIr1_049 ir1_049 0 0.24000
XPr1_049 or1_049 ir1_049 railr1 railr1 sg13_lv_pmos w=1.12u l=0.13u
XNr1_049 or1_049 ir1_049 0 0 sg13_lv_nmos w=0.74u l=0.13u
COr1_049 or1_049 0 2f
VIr1_050 ir1_050 0 0.24500
XPr1_050 or1_050 ir1_050 railr1 railr1 sg13_lv_pmos w=1.12u l=0.13u
XNr1_050 or1_050 ir1_050 0 0 sg13_lv_nmos w=0.74u l=0.13u
COr1_050 or1_050 0 2f
VIr1_051 ir1_051 0 0.25000
XPr1_051 or1_051 ir1_051 railr1 railr1 sg13_lv_pmos w=1.12u l=0.13u
XNr1_051 or1_051 ir1_051 0 0 sg13_lv_nmos w=0.74u l=0.13u
COr1_051 or1_051 0 2f
VIr1_052 ir1_052 0 0.25500
XPr1_052 or1_052 ir1_052 railr1 railr1 sg13_lv_pmos w=1.12u l=0.13u
XNr1_052 or1_052 ir1_052 0 0 sg13_lv_nmos w=0.74u l=0.13u
COr1_052 or1_052 0 2f
VIr1_053 ir1_053 0 0.26000
XPr1_053 or1_053 ir1_053 railr1 railr1 sg13_lv_pmos w=1.12u l=0.13u
XNr1_053 or1_053 ir1_053 0 0 sg13_lv_nmos w=0.74u l=0.13u
COr1_053 or1_053 0 2f
VIr1_054 ir1_054 0 0.26500
XPr1_054 or1_054 ir1_054 railr1 railr1 sg13_lv_pmos w=1.12u l=0.13u
XNr1_054 or1_054 ir1_054 0 0 sg13_lv_nmos w=0.74u l=0.13u
COr1_054 or1_054 0 2f
VIr1_055 ir1_055 0 0.27000
XPr1_055 or1_055 ir1_055 railr1 railr1 sg13_lv_pmos w=1.12u l=0.13u
XNr1_055 or1_055 ir1_055 0 0 sg13_lv_nmos w=0.74u l=0.13u
COr1_055 or1_055 0 2f
VIr1_056 ir1_056 0 0.27500
XPr1_056 or1_056 ir1_056 railr1 railr1 sg13_lv_pmos w=1.12u l=0.13u
XNr1_056 or1_056 ir1_056 0 0 sg13_lv_nmos w=0.74u l=0.13u
COr1_056 or1_056 0 2f
VIr1_057 ir1_057 0 0.28000
XPr1_057 or1_057 ir1_057 railr1 railr1 sg13_lv_pmos w=1.12u l=0.13u
XNr1_057 or1_057 ir1_057 0 0 sg13_lv_nmos w=0.74u l=0.13u
COr1_057 or1_057 0 2f
VIr1_058 ir1_058 0 0.28500
XPr1_058 or1_058 ir1_058 railr1 railr1 sg13_lv_pmos w=1.12u l=0.13u
XNr1_058 or1_058 ir1_058 0 0 sg13_lv_nmos w=0.74u l=0.13u
COr1_058 or1_058 0 2f
VIr1_059 ir1_059 0 0.29000
XPr1_059 or1_059 ir1_059 railr1 railr1 sg13_lv_pmos w=1.12u l=0.13u
XNr1_059 or1_059 ir1_059 0 0 sg13_lv_nmos w=0.74u l=0.13u
COr1_059 or1_059 0 2f
VIr1_060 ir1_060 0 0.29500
XPr1_060 or1_060 ir1_060 railr1 railr1 sg13_lv_pmos w=1.12u l=0.13u
XNr1_060 or1_060 ir1_060 0 0 sg13_lv_nmos w=0.74u l=0.13u
COr1_060 or1_060 0 2f
VIr1_061 ir1_061 0 0.30000
XPr1_061 or1_061 ir1_061 railr1 railr1 sg13_lv_pmos w=1.12u l=0.13u
XNr1_061 or1_061 ir1_061 0 0 sg13_lv_nmos w=0.74u l=0.13u
COr1_061 or1_061 0 2f
VIr1_062 ir1_062 0 0.30500
XPr1_062 or1_062 ir1_062 railr1 railr1 sg13_lv_pmos w=1.12u l=0.13u
XNr1_062 or1_062 ir1_062 0 0 sg13_lv_nmos w=0.74u l=0.13u
COr1_062 or1_062 0 2f
VIr1_063 ir1_063 0 0.31000
XPr1_063 or1_063 ir1_063 railr1 railr1 sg13_lv_pmos w=1.12u l=0.13u
XNr1_063 or1_063 ir1_063 0 0 sg13_lv_nmos w=0.74u l=0.13u
COr1_063 or1_063 0 2f
VIr1_064 ir1_064 0 0.31500
XPr1_064 or1_064 ir1_064 railr1 railr1 sg13_lv_pmos w=1.12u l=0.13u
XNr1_064 or1_064 ir1_064 0 0 sg13_lv_nmos w=0.74u l=0.13u
COr1_064 or1_064 0 2f
VIr1_065 ir1_065 0 0.32000
XPr1_065 or1_065 ir1_065 railr1 railr1 sg13_lv_pmos w=1.12u l=0.13u
XNr1_065 or1_065 ir1_065 0 0 sg13_lv_nmos w=0.74u l=0.13u
COr1_065 or1_065 0 2f
VIr1_066 ir1_066 0 0.32500
XPr1_066 or1_066 ir1_066 railr1 railr1 sg13_lv_pmos w=1.12u l=0.13u
XNr1_066 or1_066 ir1_066 0 0 sg13_lv_nmos w=0.74u l=0.13u
COr1_066 or1_066 0 2f
VIr1_067 ir1_067 0 0.33000
XPr1_067 or1_067 ir1_067 railr1 railr1 sg13_lv_pmos w=1.12u l=0.13u
XNr1_067 or1_067 ir1_067 0 0 sg13_lv_nmos w=0.74u l=0.13u
COr1_067 or1_067 0 2f
VIr1_068 ir1_068 0 0.33500
XPr1_068 or1_068 ir1_068 railr1 railr1 sg13_lv_pmos w=1.12u l=0.13u
XNr1_068 or1_068 ir1_068 0 0 sg13_lv_nmos w=0.74u l=0.13u
COr1_068 or1_068 0 2f
VIr1_069 ir1_069 0 0.34000
XPr1_069 or1_069 ir1_069 railr1 railr1 sg13_lv_pmos w=1.12u l=0.13u
XNr1_069 or1_069 ir1_069 0 0 sg13_lv_nmos w=0.74u l=0.13u
COr1_069 or1_069 0 2f
VIr1_070 ir1_070 0 0.34500
XPr1_070 or1_070 ir1_070 railr1 railr1 sg13_lv_pmos w=1.12u l=0.13u
XNr1_070 or1_070 ir1_070 0 0 sg13_lv_nmos w=0.74u l=0.13u
COr1_070 or1_070 0 2f
VIr1_071 ir1_071 0 0.35000
XPr1_071 or1_071 ir1_071 railr1 railr1 sg13_lv_pmos w=1.12u l=0.13u
XNr1_071 or1_071 ir1_071 0 0 sg13_lv_nmos w=0.74u l=0.13u
COr1_071 or1_071 0 2f
VIr1_072 ir1_072 0 0.35500
XPr1_072 or1_072 ir1_072 railr1 railr1 sg13_lv_pmos w=1.12u l=0.13u
XNr1_072 or1_072 ir1_072 0 0 sg13_lv_nmos w=0.74u l=0.13u
COr1_072 or1_072 0 2f
VIr1_073 ir1_073 0 0.36000
XPr1_073 or1_073 ir1_073 railr1 railr1 sg13_lv_pmos w=1.12u l=0.13u
XNr1_073 or1_073 ir1_073 0 0 sg13_lv_nmos w=0.74u l=0.13u
COr1_073 or1_073 0 2f
VIr1_074 ir1_074 0 0.36500
XPr1_074 or1_074 ir1_074 railr1 railr1 sg13_lv_pmos w=1.12u l=0.13u
XNr1_074 or1_074 ir1_074 0 0 sg13_lv_nmos w=0.74u l=0.13u
COr1_074 or1_074 0 2f
VIr1_075 ir1_075 0 0.37000
XPr1_075 or1_075 ir1_075 railr1 railr1 sg13_lv_pmos w=1.12u l=0.13u
XNr1_075 or1_075 ir1_075 0 0 sg13_lv_nmos w=0.74u l=0.13u
COr1_075 or1_075 0 2f
VIr1_076 ir1_076 0 0.37500
XPr1_076 or1_076 ir1_076 railr1 railr1 sg13_lv_pmos w=1.12u l=0.13u
XNr1_076 or1_076 ir1_076 0 0 sg13_lv_nmos w=0.74u l=0.13u
COr1_076 or1_076 0 2f
VIr1_077 ir1_077 0 0.38000
XPr1_077 or1_077 ir1_077 railr1 railr1 sg13_lv_pmos w=1.12u l=0.13u
XNr1_077 or1_077 ir1_077 0 0 sg13_lv_nmos w=0.74u l=0.13u
COr1_077 or1_077 0 2f
VIr1_078 ir1_078 0 0.38500
XPr1_078 or1_078 ir1_078 railr1 railr1 sg13_lv_pmos w=1.12u l=0.13u
XNr1_078 or1_078 ir1_078 0 0 sg13_lv_nmos w=0.74u l=0.13u
COr1_078 or1_078 0 2f
VIr1_079 ir1_079 0 0.39000
XPr1_079 or1_079 ir1_079 railr1 railr1 sg13_lv_pmos w=1.12u l=0.13u
XNr1_079 or1_079 ir1_079 0 0 sg13_lv_nmos w=0.74u l=0.13u
COr1_079 or1_079 0 2f
VIr1_080 ir1_080 0 0.39500
XPr1_080 or1_080 ir1_080 railr1 railr1 sg13_lv_pmos w=1.12u l=0.13u
XNr1_080 or1_080 ir1_080 0 0 sg13_lv_nmos w=0.74u l=0.13u
COr1_080 or1_080 0 2f
VIr1_081 ir1_081 0 0.40000
XPr1_081 or1_081 ir1_081 railr1 railr1 sg13_lv_pmos w=1.12u l=0.13u
XNr1_081 or1_081 ir1_081 0 0 sg13_lv_nmos w=0.74u l=0.13u
COr1_081 or1_081 0 2f
VIr1_082 ir1_082 0 0.40500
XPr1_082 or1_082 ir1_082 railr1 railr1 sg13_lv_pmos w=1.12u l=0.13u
XNr1_082 or1_082 ir1_082 0 0 sg13_lv_nmos w=0.74u l=0.13u
COr1_082 or1_082 0 2f
VIr1_083 ir1_083 0 0.41000
XPr1_083 or1_083 ir1_083 railr1 railr1 sg13_lv_pmos w=1.12u l=0.13u
XNr1_083 or1_083 ir1_083 0 0 sg13_lv_nmos w=0.74u l=0.13u
COr1_083 or1_083 0 2f
VIr1_084 ir1_084 0 0.41500
XPr1_084 or1_084 ir1_084 railr1 railr1 sg13_lv_pmos w=1.12u l=0.13u
XNr1_084 or1_084 ir1_084 0 0 sg13_lv_nmos w=0.74u l=0.13u
COr1_084 or1_084 0 2f
VIr1_085 ir1_085 0 0.42000
XPr1_085 or1_085 ir1_085 railr1 railr1 sg13_lv_pmos w=1.12u l=0.13u
XNr1_085 or1_085 ir1_085 0 0 sg13_lv_nmos w=0.74u l=0.13u
COr1_085 or1_085 0 2f
VIr1_086 ir1_086 0 0.42500
XPr1_086 or1_086 ir1_086 railr1 railr1 sg13_lv_pmos w=1.12u l=0.13u
XNr1_086 or1_086 ir1_086 0 0 sg13_lv_nmos w=0.74u l=0.13u
COr1_086 or1_086 0 2f
VIr1_087 ir1_087 0 0.43000
XPr1_087 or1_087 ir1_087 railr1 railr1 sg13_lv_pmos w=1.12u l=0.13u
XNr1_087 or1_087 ir1_087 0 0 sg13_lv_nmos w=0.74u l=0.13u
COr1_087 or1_087 0 2f
VIr1_088 ir1_088 0 0.43500
XPr1_088 or1_088 ir1_088 railr1 railr1 sg13_lv_pmos w=1.12u l=0.13u
XNr1_088 or1_088 ir1_088 0 0 sg13_lv_nmos w=0.74u l=0.13u
COr1_088 or1_088 0 2f
VIr1_089 ir1_089 0 0.44000
XPr1_089 or1_089 ir1_089 railr1 railr1 sg13_lv_pmos w=1.12u l=0.13u
XNr1_089 or1_089 ir1_089 0 0 sg13_lv_nmos w=0.74u l=0.13u
COr1_089 or1_089 0 2f
VIr1_090 ir1_090 0 0.44500
XPr1_090 or1_090 ir1_090 railr1 railr1 sg13_lv_pmos w=1.12u l=0.13u
XNr1_090 or1_090 ir1_090 0 0 sg13_lv_nmos w=0.74u l=0.13u
COr1_090 or1_090 0 2f
VIr1_091 ir1_091 0 0.45000
XPr1_091 or1_091 ir1_091 railr1 railr1 sg13_lv_pmos w=1.12u l=0.13u
XNr1_091 or1_091 ir1_091 0 0 sg13_lv_nmos w=0.74u l=0.13u
COr1_091 or1_091 0 2f
VIr1_092 ir1_092 0 0.45500
XPr1_092 or1_092 ir1_092 railr1 railr1 sg13_lv_pmos w=1.12u l=0.13u
XNr1_092 or1_092 ir1_092 0 0 sg13_lv_nmos w=0.74u l=0.13u
COr1_092 or1_092 0 2f
VIr1_093 ir1_093 0 0.46000
XPr1_093 or1_093 ir1_093 railr1 railr1 sg13_lv_pmos w=1.12u l=0.13u
XNr1_093 or1_093 ir1_093 0 0 sg13_lv_nmos w=0.74u l=0.13u
COr1_093 or1_093 0 2f
VIr1_094 ir1_094 0 0.46500
XPr1_094 or1_094 ir1_094 railr1 railr1 sg13_lv_pmos w=1.12u l=0.13u
XNr1_094 or1_094 ir1_094 0 0 sg13_lv_nmos w=0.74u l=0.13u
COr1_094 or1_094 0 2f
VIr1_095 ir1_095 0 0.47000
XPr1_095 or1_095 ir1_095 railr1 railr1 sg13_lv_pmos w=1.12u l=0.13u
XNr1_095 or1_095 ir1_095 0 0 sg13_lv_nmos w=0.74u l=0.13u
COr1_095 or1_095 0 2f
VIr1_096 ir1_096 0 0.47500
XPr1_096 or1_096 ir1_096 railr1 railr1 sg13_lv_pmos w=1.12u l=0.13u
XNr1_096 or1_096 ir1_096 0 0 sg13_lv_nmos w=0.74u l=0.13u
COr1_096 or1_096 0 2f
VIr1_097 ir1_097 0 0.48000
XPr1_097 or1_097 ir1_097 railr1 railr1 sg13_lv_pmos w=1.12u l=0.13u
XNr1_097 or1_097 ir1_097 0 0 sg13_lv_nmos w=0.74u l=0.13u
COr1_097 or1_097 0 2f
VIr1_098 ir1_098 0 0.48500
XPr1_098 or1_098 ir1_098 railr1 railr1 sg13_lv_pmos w=1.12u l=0.13u
XNr1_098 or1_098 ir1_098 0 0 sg13_lv_nmos w=0.74u l=0.13u
COr1_098 or1_098 0 2f
VIr1_099 ir1_099 0 0.49000
XPr1_099 or1_099 ir1_099 railr1 railr1 sg13_lv_pmos w=1.12u l=0.13u
XNr1_099 or1_099 ir1_099 0 0 sg13_lv_nmos w=0.74u l=0.13u
COr1_099 or1_099 0 2f
VIr1_100 ir1_100 0 0.49500
XPr1_100 or1_100 ir1_100 railr1 railr1 sg13_lv_pmos w=1.12u l=0.13u
XNr1_100 or1_100 ir1_100 0 0 sg13_lv_nmos w=0.74u l=0.13u
COr1_100 or1_100 0 2f
VIr1_101 ir1_101 0 0.50000
XPr1_101 or1_101 ir1_101 railr1 railr1 sg13_lv_pmos w=1.12u l=0.13u
XNr1_101 or1_101 ir1_101 0 0 sg13_lv_nmos w=0.74u l=0.13u
COr1_101 or1_101 0 2f
VIr1_102 ir1_102 0 0.50500
XPr1_102 or1_102 ir1_102 railr1 railr1 sg13_lv_pmos w=1.12u l=0.13u
XNr1_102 or1_102 ir1_102 0 0 sg13_lv_nmos w=0.74u l=0.13u
COr1_102 or1_102 0 2f
VIr1_103 ir1_103 0 0.51000
XPr1_103 or1_103 ir1_103 railr1 railr1 sg13_lv_pmos w=1.12u l=0.13u
XNr1_103 or1_103 ir1_103 0 0 sg13_lv_nmos w=0.74u l=0.13u
COr1_103 or1_103 0 2f
VIr1_104 ir1_104 0 0.51500
XPr1_104 or1_104 ir1_104 railr1 railr1 sg13_lv_pmos w=1.12u l=0.13u
XNr1_104 or1_104 ir1_104 0 0 sg13_lv_nmos w=0.74u l=0.13u
COr1_104 or1_104 0 2f
VIr1_105 ir1_105 0 0.52000
XPr1_105 or1_105 ir1_105 railr1 railr1 sg13_lv_pmos w=1.12u l=0.13u
XNr1_105 or1_105 ir1_105 0 0 sg13_lv_nmos w=0.74u l=0.13u
COr1_105 or1_105 0 2f
VIr1_106 ir1_106 0 0.52500
XPr1_106 or1_106 ir1_106 railr1 railr1 sg13_lv_pmos w=1.12u l=0.13u
XNr1_106 or1_106 ir1_106 0 0 sg13_lv_nmos w=0.74u l=0.13u
COr1_106 or1_106 0 2f
VIr1_107 ir1_107 0 0.53000
XPr1_107 or1_107 ir1_107 railr1 railr1 sg13_lv_pmos w=1.12u l=0.13u
XNr1_107 or1_107 ir1_107 0 0 sg13_lv_nmos w=0.74u l=0.13u
COr1_107 or1_107 0 2f
VIr1_108 ir1_108 0 0.53500
XPr1_108 or1_108 ir1_108 railr1 railr1 sg13_lv_pmos w=1.12u l=0.13u
XNr1_108 or1_108 ir1_108 0 0 sg13_lv_nmos w=0.74u l=0.13u
COr1_108 or1_108 0 2f
VIr1_109 ir1_109 0 0.54000
XPr1_109 or1_109 ir1_109 railr1 railr1 sg13_lv_pmos w=1.12u l=0.13u
XNr1_109 or1_109 ir1_109 0 0 sg13_lv_nmos w=0.74u l=0.13u
COr1_109 or1_109 0 2f
VIr1_110 ir1_110 0 0.54500
XPr1_110 or1_110 ir1_110 railr1 railr1 sg13_lv_pmos w=1.12u l=0.13u
XNr1_110 or1_110 ir1_110 0 0 sg13_lv_nmos w=0.74u l=0.13u
COr1_110 or1_110 0 2f
VIr1_111 ir1_111 0 0.55000
XPr1_111 or1_111 ir1_111 railr1 railr1 sg13_lv_pmos w=1.12u l=0.13u
XNr1_111 or1_111 ir1_111 0 0 sg13_lv_nmos w=0.74u l=0.13u
COr1_111 or1_111 0 2f
VIr1_112 ir1_112 0 0.55500
XPr1_112 or1_112 ir1_112 railr1 railr1 sg13_lv_pmos w=1.12u l=0.13u
XNr1_112 or1_112 ir1_112 0 0 sg13_lv_nmos w=0.74u l=0.13u
COr1_112 or1_112 0 2f
VRr2 railr2 0 0.607700
VIr2_001 ir2_001 0 0.00000
XPr2_001 or2_001 ir2_001 railr2 railr2 sg13_lv_pmos w=1.12u l=0.13u
XNr2_001 or2_001 ir2_001 0 0 sg13_lv_nmos w=0.74u l=0.13u
COr2_001 or2_001 0 2f
VIr2_002 ir2_002 0 0.00500
XPr2_002 or2_002 ir2_002 railr2 railr2 sg13_lv_pmos w=1.12u l=0.13u
XNr2_002 or2_002 ir2_002 0 0 sg13_lv_nmos w=0.74u l=0.13u
COr2_002 or2_002 0 2f
VIr2_003 ir2_003 0 0.01000
XPr2_003 or2_003 ir2_003 railr2 railr2 sg13_lv_pmos w=1.12u l=0.13u
XNr2_003 or2_003 ir2_003 0 0 sg13_lv_nmos w=0.74u l=0.13u
COr2_003 or2_003 0 2f
VIr2_004 ir2_004 0 0.01500
XPr2_004 or2_004 ir2_004 railr2 railr2 sg13_lv_pmos w=1.12u l=0.13u
XNr2_004 or2_004 ir2_004 0 0 sg13_lv_nmos w=0.74u l=0.13u
COr2_004 or2_004 0 2f
VIr2_005 ir2_005 0 0.02000
XPr2_005 or2_005 ir2_005 railr2 railr2 sg13_lv_pmos w=1.12u l=0.13u
XNr2_005 or2_005 ir2_005 0 0 sg13_lv_nmos w=0.74u l=0.13u
COr2_005 or2_005 0 2f
VIr2_006 ir2_006 0 0.02500
XPr2_006 or2_006 ir2_006 railr2 railr2 sg13_lv_pmos w=1.12u l=0.13u
XNr2_006 or2_006 ir2_006 0 0 sg13_lv_nmos w=0.74u l=0.13u
COr2_006 or2_006 0 2f
VIr2_007 ir2_007 0 0.03000
XPr2_007 or2_007 ir2_007 railr2 railr2 sg13_lv_pmos w=1.12u l=0.13u
XNr2_007 or2_007 ir2_007 0 0 sg13_lv_nmos w=0.74u l=0.13u
COr2_007 or2_007 0 2f
VIr2_008 ir2_008 0 0.03500
XPr2_008 or2_008 ir2_008 railr2 railr2 sg13_lv_pmos w=1.12u l=0.13u
XNr2_008 or2_008 ir2_008 0 0 sg13_lv_nmos w=0.74u l=0.13u
COr2_008 or2_008 0 2f
VIr2_009 ir2_009 0 0.04000
XPr2_009 or2_009 ir2_009 railr2 railr2 sg13_lv_pmos w=1.12u l=0.13u
XNr2_009 or2_009 ir2_009 0 0 sg13_lv_nmos w=0.74u l=0.13u
COr2_009 or2_009 0 2f
VIr2_010 ir2_010 0 0.04500
XPr2_010 or2_010 ir2_010 railr2 railr2 sg13_lv_pmos w=1.12u l=0.13u
XNr2_010 or2_010 ir2_010 0 0 sg13_lv_nmos w=0.74u l=0.13u
COr2_010 or2_010 0 2f
VIr2_011 ir2_011 0 0.05000
XPr2_011 or2_011 ir2_011 railr2 railr2 sg13_lv_pmos w=1.12u l=0.13u
XNr2_011 or2_011 ir2_011 0 0 sg13_lv_nmos w=0.74u l=0.13u
COr2_011 or2_011 0 2f
VIr2_012 ir2_012 0 0.05500
XPr2_012 or2_012 ir2_012 railr2 railr2 sg13_lv_pmos w=1.12u l=0.13u
XNr2_012 or2_012 ir2_012 0 0 sg13_lv_nmos w=0.74u l=0.13u
COr2_012 or2_012 0 2f
VIr2_013 ir2_013 0 0.06000
XPr2_013 or2_013 ir2_013 railr2 railr2 sg13_lv_pmos w=1.12u l=0.13u
XNr2_013 or2_013 ir2_013 0 0 sg13_lv_nmos w=0.74u l=0.13u
COr2_013 or2_013 0 2f
VIr2_014 ir2_014 0 0.06500
XPr2_014 or2_014 ir2_014 railr2 railr2 sg13_lv_pmos w=1.12u l=0.13u
XNr2_014 or2_014 ir2_014 0 0 sg13_lv_nmos w=0.74u l=0.13u
COr2_014 or2_014 0 2f
VIr2_015 ir2_015 0 0.07000
XPr2_015 or2_015 ir2_015 railr2 railr2 sg13_lv_pmos w=1.12u l=0.13u
XNr2_015 or2_015 ir2_015 0 0 sg13_lv_nmos w=0.74u l=0.13u
COr2_015 or2_015 0 2f
VIr2_016 ir2_016 0 0.07500
XPr2_016 or2_016 ir2_016 railr2 railr2 sg13_lv_pmos w=1.12u l=0.13u
XNr2_016 or2_016 ir2_016 0 0 sg13_lv_nmos w=0.74u l=0.13u
COr2_016 or2_016 0 2f
VIr2_017 ir2_017 0 0.08000
XPr2_017 or2_017 ir2_017 railr2 railr2 sg13_lv_pmos w=1.12u l=0.13u
XNr2_017 or2_017 ir2_017 0 0 sg13_lv_nmos w=0.74u l=0.13u
COr2_017 or2_017 0 2f
VIr2_018 ir2_018 0 0.08500
XPr2_018 or2_018 ir2_018 railr2 railr2 sg13_lv_pmos w=1.12u l=0.13u
XNr2_018 or2_018 ir2_018 0 0 sg13_lv_nmos w=0.74u l=0.13u
COr2_018 or2_018 0 2f
VIr2_019 ir2_019 0 0.09000
XPr2_019 or2_019 ir2_019 railr2 railr2 sg13_lv_pmos w=1.12u l=0.13u
XNr2_019 or2_019 ir2_019 0 0 sg13_lv_nmos w=0.74u l=0.13u
COr2_019 or2_019 0 2f
VIr2_020 ir2_020 0 0.09500
XPr2_020 or2_020 ir2_020 railr2 railr2 sg13_lv_pmos w=1.12u l=0.13u
XNr2_020 or2_020 ir2_020 0 0 sg13_lv_nmos w=0.74u l=0.13u
COr2_020 or2_020 0 2f
VIr2_021 ir2_021 0 0.10000
XPr2_021 or2_021 ir2_021 railr2 railr2 sg13_lv_pmos w=1.12u l=0.13u
XNr2_021 or2_021 ir2_021 0 0 sg13_lv_nmos w=0.74u l=0.13u
COr2_021 or2_021 0 2f
VIr2_022 ir2_022 0 0.10500
XPr2_022 or2_022 ir2_022 railr2 railr2 sg13_lv_pmos w=1.12u l=0.13u
XNr2_022 or2_022 ir2_022 0 0 sg13_lv_nmos w=0.74u l=0.13u
COr2_022 or2_022 0 2f
VIr2_023 ir2_023 0 0.11000
XPr2_023 or2_023 ir2_023 railr2 railr2 sg13_lv_pmos w=1.12u l=0.13u
XNr2_023 or2_023 ir2_023 0 0 sg13_lv_nmos w=0.74u l=0.13u
COr2_023 or2_023 0 2f
VIr2_024 ir2_024 0 0.11500
XPr2_024 or2_024 ir2_024 railr2 railr2 sg13_lv_pmos w=1.12u l=0.13u
XNr2_024 or2_024 ir2_024 0 0 sg13_lv_nmos w=0.74u l=0.13u
COr2_024 or2_024 0 2f
VIr2_025 ir2_025 0 0.12000
XPr2_025 or2_025 ir2_025 railr2 railr2 sg13_lv_pmos w=1.12u l=0.13u
XNr2_025 or2_025 ir2_025 0 0 sg13_lv_nmos w=0.74u l=0.13u
COr2_025 or2_025 0 2f
VIr2_026 ir2_026 0 0.12500
XPr2_026 or2_026 ir2_026 railr2 railr2 sg13_lv_pmos w=1.12u l=0.13u
XNr2_026 or2_026 ir2_026 0 0 sg13_lv_nmos w=0.74u l=0.13u
COr2_026 or2_026 0 2f
VIr2_027 ir2_027 0 0.13000
XPr2_027 or2_027 ir2_027 railr2 railr2 sg13_lv_pmos w=1.12u l=0.13u
XNr2_027 or2_027 ir2_027 0 0 sg13_lv_nmos w=0.74u l=0.13u
COr2_027 or2_027 0 2f
VIr2_028 ir2_028 0 0.13500
XPr2_028 or2_028 ir2_028 railr2 railr2 sg13_lv_pmos w=1.12u l=0.13u
XNr2_028 or2_028 ir2_028 0 0 sg13_lv_nmos w=0.74u l=0.13u
COr2_028 or2_028 0 2f
VIr2_029 ir2_029 0 0.14000
XPr2_029 or2_029 ir2_029 railr2 railr2 sg13_lv_pmos w=1.12u l=0.13u
XNr2_029 or2_029 ir2_029 0 0 sg13_lv_nmos w=0.74u l=0.13u
COr2_029 or2_029 0 2f
VIr2_030 ir2_030 0 0.14500
XPr2_030 or2_030 ir2_030 railr2 railr2 sg13_lv_pmos w=1.12u l=0.13u
XNr2_030 or2_030 ir2_030 0 0 sg13_lv_nmos w=0.74u l=0.13u
COr2_030 or2_030 0 2f
VIr2_031 ir2_031 0 0.15000
XPr2_031 or2_031 ir2_031 railr2 railr2 sg13_lv_pmos w=1.12u l=0.13u
XNr2_031 or2_031 ir2_031 0 0 sg13_lv_nmos w=0.74u l=0.13u
COr2_031 or2_031 0 2f
VIr2_032 ir2_032 0 0.15500
XPr2_032 or2_032 ir2_032 railr2 railr2 sg13_lv_pmos w=1.12u l=0.13u
XNr2_032 or2_032 ir2_032 0 0 sg13_lv_nmos w=0.74u l=0.13u
COr2_032 or2_032 0 2f
VIr2_033 ir2_033 0 0.16000
XPr2_033 or2_033 ir2_033 railr2 railr2 sg13_lv_pmos w=1.12u l=0.13u
XNr2_033 or2_033 ir2_033 0 0 sg13_lv_nmos w=0.74u l=0.13u
COr2_033 or2_033 0 2f
VIr2_034 ir2_034 0 0.16500
XPr2_034 or2_034 ir2_034 railr2 railr2 sg13_lv_pmos w=1.12u l=0.13u
XNr2_034 or2_034 ir2_034 0 0 sg13_lv_nmos w=0.74u l=0.13u
COr2_034 or2_034 0 2f
VIr2_035 ir2_035 0 0.17000
XPr2_035 or2_035 ir2_035 railr2 railr2 sg13_lv_pmos w=1.12u l=0.13u
XNr2_035 or2_035 ir2_035 0 0 sg13_lv_nmos w=0.74u l=0.13u
COr2_035 or2_035 0 2f
VIr2_036 ir2_036 0 0.17500
XPr2_036 or2_036 ir2_036 railr2 railr2 sg13_lv_pmos w=1.12u l=0.13u
XNr2_036 or2_036 ir2_036 0 0 sg13_lv_nmos w=0.74u l=0.13u
COr2_036 or2_036 0 2f
VIr2_037 ir2_037 0 0.18000
XPr2_037 or2_037 ir2_037 railr2 railr2 sg13_lv_pmos w=1.12u l=0.13u
XNr2_037 or2_037 ir2_037 0 0 sg13_lv_nmos w=0.74u l=0.13u
COr2_037 or2_037 0 2f
VIr2_038 ir2_038 0 0.18500
XPr2_038 or2_038 ir2_038 railr2 railr2 sg13_lv_pmos w=1.12u l=0.13u
XNr2_038 or2_038 ir2_038 0 0 sg13_lv_nmos w=0.74u l=0.13u
COr2_038 or2_038 0 2f
VIr2_039 ir2_039 0 0.19000
XPr2_039 or2_039 ir2_039 railr2 railr2 sg13_lv_pmos w=1.12u l=0.13u
XNr2_039 or2_039 ir2_039 0 0 sg13_lv_nmos w=0.74u l=0.13u
COr2_039 or2_039 0 2f
VIr2_040 ir2_040 0 0.19500
XPr2_040 or2_040 ir2_040 railr2 railr2 sg13_lv_pmos w=1.12u l=0.13u
XNr2_040 or2_040 ir2_040 0 0 sg13_lv_nmos w=0.74u l=0.13u
COr2_040 or2_040 0 2f
VIr2_041 ir2_041 0 0.20000
XPr2_041 or2_041 ir2_041 railr2 railr2 sg13_lv_pmos w=1.12u l=0.13u
XNr2_041 or2_041 ir2_041 0 0 sg13_lv_nmos w=0.74u l=0.13u
COr2_041 or2_041 0 2f
VIr2_042 ir2_042 0 0.20500
XPr2_042 or2_042 ir2_042 railr2 railr2 sg13_lv_pmos w=1.12u l=0.13u
XNr2_042 or2_042 ir2_042 0 0 sg13_lv_nmos w=0.74u l=0.13u
COr2_042 or2_042 0 2f
VIr2_043 ir2_043 0 0.21000
XPr2_043 or2_043 ir2_043 railr2 railr2 sg13_lv_pmos w=1.12u l=0.13u
XNr2_043 or2_043 ir2_043 0 0 sg13_lv_nmos w=0.74u l=0.13u
COr2_043 or2_043 0 2f
VIr2_044 ir2_044 0 0.21500
XPr2_044 or2_044 ir2_044 railr2 railr2 sg13_lv_pmos w=1.12u l=0.13u
XNr2_044 or2_044 ir2_044 0 0 sg13_lv_nmos w=0.74u l=0.13u
COr2_044 or2_044 0 2f
VIr2_045 ir2_045 0 0.22000
XPr2_045 or2_045 ir2_045 railr2 railr2 sg13_lv_pmos w=1.12u l=0.13u
XNr2_045 or2_045 ir2_045 0 0 sg13_lv_nmos w=0.74u l=0.13u
COr2_045 or2_045 0 2f
VIr2_046 ir2_046 0 0.22500
XPr2_046 or2_046 ir2_046 railr2 railr2 sg13_lv_pmos w=1.12u l=0.13u
XNr2_046 or2_046 ir2_046 0 0 sg13_lv_nmos w=0.74u l=0.13u
COr2_046 or2_046 0 2f
VIr2_047 ir2_047 0 0.23000
XPr2_047 or2_047 ir2_047 railr2 railr2 sg13_lv_pmos w=1.12u l=0.13u
XNr2_047 or2_047 ir2_047 0 0 sg13_lv_nmos w=0.74u l=0.13u
COr2_047 or2_047 0 2f
VIr2_048 ir2_048 0 0.23500
XPr2_048 or2_048 ir2_048 railr2 railr2 sg13_lv_pmos w=1.12u l=0.13u
XNr2_048 or2_048 ir2_048 0 0 sg13_lv_nmos w=0.74u l=0.13u
COr2_048 or2_048 0 2f
VIr2_049 ir2_049 0 0.24000
XPr2_049 or2_049 ir2_049 railr2 railr2 sg13_lv_pmos w=1.12u l=0.13u
XNr2_049 or2_049 ir2_049 0 0 sg13_lv_nmos w=0.74u l=0.13u
COr2_049 or2_049 0 2f
VIr2_050 ir2_050 0 0.24500
XPr2_050 or2_050 ir2_050 railr2 railr2 sg13_lv_pmos w=1.12u l=0.13u
XNr2_050 or2_050 ir2_050 0 0 sg13_lv_nmos w=0.74u l=0.13u
COr2_050 or2_050 0 2f
VIr2_051 ir2_051 0 0.25000
XPr2_051 or2_051 ir2_051 railr2 railr2 sg13_lv_pmos w=1.12u l=0.13u
XNr2_051 or2_051 ir2_051 0 0 sg13_lv_nmos w=0.74u l=0.13u
COr2_051 or2_051 0 2f
VIr2_052 ir2_052 0 0.25500
XPr2_052 or2_052 ir2_052 railr2 railr2 sg13_lv_pmos w=1.12u l=0.13u
XNr2_052 or2_052 ir2_052 0 0 sg13_lv_nmos w=0.74u l=0.13u
COr2_052 or2_052 0 2f
VIr2_053 ir2_053 0 0.26000
XPr2_053 or2_053 ir2_053 railr2 railr2 sg13_lv_pmos w=1.12u l=0.13u
XNr2_053 or2_053 ir2_053 0 0 sg13_lv_nmos w=0.74u l=0.13u
COr2_053 or2_053 0 2f
VIr2_054 ir2_054 0 0.26500
XPr2_054 or2_054 ir2_054 railr2 railr2 sg13_lv_pmos w=1.12u l=0.13u
XNr2_054 or2_054 ir2_054 0 0 sg13_lv_nmos w=0.74u l=0.13u
COr2_054 or2_054 0 2f
VIr2_055 ir2_055 0 0.27000
XPr2_055 or2_055 ir2_055 railr2 railr2 sg13_lv_pmos w=1.12u l=0.13u
XNr2_055 or2_055 ir2_055 0 0 sg13_lv_nmos w=0.74u l=0.13u
COr2_055 or2_055 0 2f
VIr2_056 ir2_056 0 0.27500
XPr2_056 or2_056 ir2_056 railr2 railr2 sg13_lv_pmos w=1.12u l=0.13u
XNr2_056 or2_056 ir2_056 0 0 sg13_lv_nmos w=0.74u l=0.13u
COr2_056 or2_056 0 2f
VIr2_057 ir2_057 0 0.28000
XPr2_057 or2_057 ir2_057 railr2 railr2 sg13_lv_pmos w=1.12u l=0.13u
XNr2_057 or2_057 ir2_057 0 0 sg13_lv_nmos w=0.74u l=0.13u
COr2_057 or2_057 0 2f
VIr2_058 ir2_058 0 0.28500
XPr2_058 or2_058 ir2_058 railr2 railr2 sg13_lv_pmos w=1.12u l=0.13u
XNr2_058 or2_058 ir2_058 0 0 sg13_lv_nmos w=0.74u l=0.13u
COr2_058 or2_058 0 2f
VIr2_059 ir2_059 0 0.29000
XPr2_059 or2_059 ir2_059 railr2 railr2 sg13_lv_pmos w=1.12u l=0.13u
XNr2_059 or2_059 ir2_059 0 0 sg13_lv_nmos w=0.74u l=0.13u
COr2_059 or2_059 0 2f
VIr2_060 ir2_060 0 0.29500
XPr2_060 or2_060 ir2_060 railr2 railr2 sg13_lv_pmos w=1.12u l=0.13u
XNr2_060 or2_060 ir2_060 0 0 sg13_lv_nmos w=0.74u l=0.13u
COr2_060 or2_060 0 2f
VIr2_061 ir2_061 0 0.30000
XPr2_061 or2_061 ir2_061 railr2 railr2 sg13_lv_pmos w=1.12u l=0.13u
XNr2_061 or2_061 ir2_061 0 0 sg13_lv_nmos w=0.74u l=0.13u
COr2_061 or2_061 0 2f
VIr2_062 ir2_062 0 0.30500
XPr2_062 or2_062 ir2_062 railr2 railr2 sg13_lv_pmos w=1.12u l=0.13u
XNr2_062 or2_062 ir2_062 0 0 sg13_lv_nmos w=0.74u l=0.13u
COr2_062 or2_062 0 2f
VIr2_063 ir2_063 0 0.31000
XPr2_063 or2_063 ir2_063 railr2 railr2 sg13_lv_pmos w=1.12u l=0.13u
XNr2_063 or2_063 ir2_063 0 0 sg13_lv_nmos w=0.74u l=0.13u
COr2_063 or2_063 0 2f
VIr2_064 ir2_064 0 0.31500
XPr2_064 or2_064 ir2_064 railr2 railr2 sg13_lv_pmos w=1.12u l=0.13u
XNr2_064 or2_064 ir2_064 0 0 sg13_lv_nmos w=0.74u l=0.13u
COr2_064 or2_064 0 2f
VIr2_065 ir2_065 0 0.32000
XPr2_065 or2_065 ir2_065 railr2 railr2 sg13_lv_pmos w=1.12u l=0.13u
XNr2_065 or2_065 ir2_065 0 0 sg13_lv_nmos w=0.74u l=0.13u
COr2_065 or2_065 0 2f
VIr2_066 ir2_066 0 0.32500
XPr2_066 or2_066 ir2_066 railr2 railr2 sg13_lv_pmos w=1.12u l=0.13u
XNr2_066 or2_066 ir2_066 0 0 sg13_lv_nmos w=0.74u l=0.13u
COr2_066 or2_066 0 2f
VIr2_067 ir2_067 0 0.33000
XPr2_067 or2_067 ir2_067 railr2 railr2 sg13_lv_pmos w=1.12u l=0.13u
XNr2_067 or2_067 ir2_067 0 0 sg13_lv_nmos w=0.74u l=0.13u
COr2_067 or2_067 0 2f
VIr2_068 ir2_068 0 0.33500
XPr2_068 or2_068 ir2_068 railr2 railr2 sg13_lv_pmos w=1.12u l=0.13u
XNr2_068 or2_068 ir2_068 0 0 sg13_lv_nmos w=0.74u l=0.13u
COr2_068 or2_068 0 2f
VIr2_069 ir2_069 0 0.34000
XPr2_069 or2_069 ir2_069 railr2 railr2 sg13_lv_pmos w=1.12u l=0.13u
XNr2_069 or2_069 ir2_069 0 0 sg13_lv_nmos w=0.74u l=0.13u
COr2_069 or2_069 0 2f
VIr2_070 ir2_070 0 0.34500
XPr2_070 or2_070 ir2_070 railr2 railr2 sg13_lv_pmos w=1.12u l=0.13u
XNr2_070 or2_070 ir2_070 0 0 sg13_lv_nmos w=0.74u l=0.13u
COr2_070 or2_070 0 2f
VIr2_071 ir2_071 0 0.35000
XPr2_071 or2_071 ir2_071 railr2 railr2 sg13_lv_pmos w=1.12u l=0.13u
XNr2_071 or2_071 ir2_071 0 0 sg13_lv_nmos w=0.74u l=0.13u
COr2_071 or2_071 0 2f
VIr2_072 ir2_072 0 0.35500
XPr2_072 or2_072 ir2_072 railr2 railr2 sg13_lv_pmos w=1.12u l=0.13u
XNr2_072 or2_072 ir2_072 0 0 sg13_lv_nmos w=0.74u l=0.13u
COr2_072 or2_072 0 2f
VIr2_073 ir2_073 0 0.36000
XPr2_073 or2_073 ir2_073 railr2 railr2 sg13_lv_pmos w=1.12u l=0.13u
XNr2_073 or2_073 ir2_073 0 0 sg13_lv_nmos w=0.74u l=0.13u
COr2_073 or2_073 0 2f
VIr2_074 ir2_074 0 0.36500
XPr2_074 or2_074 ir2_074 railr2 railr2 sg13_lv_pmos w=1.12u l=0.13u
XNr2_074 or2_074 ir2_074 0 0 sg13_lv_nmos w=0.74u l=0.13u
COr2_074 or2_074 0 2f
VIr2_075 ir2_075 0 0.37000
XPr2_075 or2_075 ir2_075 railr2 railr2 sg13_lv_pmos w=1.12u l=0.13u
XNr2_075 or2_075 ir2_075 0 0 sg13_lv_nmos w=0.74u l=0.13u
COr2_075 or2_075 0 2f
VIr2_076 ir2_076 0 0.37500
XPr2_076 or2_076 ir2_076 railr2 railr2 sg13_lv_pmos w=1.12u l=0.13u
XNr2_076 or2_076 ir2_076 0 0 sg13_lv_nmos w=0.74u l=0.13u
COr2_076 or2_076 0 2f
VIr2_077 ir2_077 0 0.38000
XPr2_077 or2_077 ir2_077 railr2 railr2 sg13_lv_pmos w=1.12u l=0.13u
XNr2_077 or2_077 ir2_077 0 0 sg13_lv_nmos w=0.74u l=0.13u
COr2_077 or2_077 0 2f
VIr2_078 ir2_078 0 0.38500
XPr2_078 or2_078 ir2_078 railr2 railr2 sg13_lv_pmos w=1.12u l=0.13u
XNr2_078 or2_078 ir2_078 0 0 sg13_lv_nmos w=0.74u l=0.13u
COr2_078 or2_078 0 2f
VIr2_079 ir2_079 0 0.39000
XPr2_079 or2_079 ir2_079 railr2 railr2 sg13_lv_pmos w=1.12u l=0.13u
XNr2_079 or2_079 ir2_079 0 0 sg13_lv_nmos w=0.74u l=0.13u
COr2_079 or2_079 0 2f
VIr2_080 ir2_080 0 0.39500
XPr2_080 or2_080 ir2_080 railr2 railr2 sg13_lv_pmos w=1.12u l=0.13u
XNr2_080 or2_080 ir2_080 0 0 sg13_lv_nmos w=0.74u l=0.13u
COr2_080 or2_080 0 2f
VIr2_081 ir2_081 0 0.40000
XPr2_081 or2_081 ir2_081 railr2 railr2 sg13_lv_pmos w=1.12u l=0.13u
XNr2_081 or2_081 ir2_081 0 0 sg13_lv_nmos w=0.74u l=0.13u
COr2_081 or2_081 0 2f
VIr2_082 ir2_082 0 0.40500
XPr2_082 or2_082 ir2_082 railr2 railr2 sg13_lv_pmos w=1.12u l=0.13u
XNr2_082 or2_082 ir2_082 0 0 sg13_lv_nmos w=0.74u l=0.13u
COr2_082 or2_082 0 2f
VIr2_083 ir2_083 0 0.41000
XPr2_083 or2_083 ir2_083 railr2 railr2 sg13_lv_pmos w=1.12u l=0.13u
XNr2_083 or2_083 ir2_083 0 0 sg13_lv_nmos w=0.74u l=0.13u
COr2_083 or2_083 0 2f
VIr2_084 ir2_084 0 0.41500
XPr2_084 or2_084 ir2_084 railr2 railr2 sg13_lv_pmos w=1.12u l=0.13u
XNr2_084 or2_084 ir2_084 0 0 sg13_lv_nmos w=0.74u l=0.13u
COr2_084 or2_084 0 2f
VIr2_085 ir2_085 0 0.42000
XPr2_085 or2_085 ir2_085 railr2 railr2 sg13_lv_pmos w=1.12u l=0.13u
XNr2_085 or2_085 ir2_085 0 0 sg13_lv_nmos w=0.74u l=0.13u
COr2_085 or2_085 0 2f
VIr2_086 ir2_086 0 0.42500
XPr2_086 or2_086 ir2_086 railr2 railr2 sg13_lv_pmos w=1.12u l=0.13u
XNr2_086 or2_086 ir2_086 0 0 sg13_lv_nmos w=0.74u l=0.13u
COr2_086 or2_086 0 2f
VIr2_087 ir2_087 0 0.43000
XPr2_087 or2_087 ir2_087 railr2 railr2 sg13_lv_pmos w=1.12u l=0.13u
XNr2_087 or2_087 ir2_087 0 0 sg13_lv_nmos w=0.74u l=0.13u
COr2_087 or2_087 0 2f
VIr2_088 ir2_088 0 0.43500
XPr2_088 or2_088 ir2_088 railr2 railr2 sg13_lv_pmos w=1.12u l=0.13u
XNr2_088 or2_088 ir2_088 0 0 sg13_lv_nmos w=0.74u l=0.13u
COr2_088 or2_088 0 2f
VIr2_089 ir2_089 0 0.44000
XPr2_089 or2_089 ir2_089 railr2 railr2 sg13_lv_pmos w=1.12u l=0.13u
XNr2_089 or2_089 ir2_089 0 0 sg13_lv_nmos w=0.74u l=0.13u
COr2_089 or2_089 0 2f
VIr2_090 ir2_090 0 0.44500
XPr2_090 or2_090 ir2_090 railr2 railr2 sg13_lv_pmos w=1.12u l=0.13u
XNr2_090 or2_090 ir2_090 0 0 sg13_lv_nmos w=0.74u l=0.13u
COr2_090 or2_090 0 2f
VIr2_091 ir2_091 0 0.45000
XPr2_091 or2_091 ir2_091 railr2 railr2 sg13_lv_pmos w=1.12u l=0.13u
XNr2_091 or2_091 ir2_091 0 0 sg13_lv_nmos w=0.74u l=0.13u
COr2_091 or2_091 0 2f
VIr2_092 ir2_092 0 0.45500
XPr2_092 or2_092 ir2_092 railr2 railr2 sg13_lv_pmos w=1.12u l=0.13u
XNr2_092 or2_092 ir2_092 0 0 sg13_lv_nmos w=0.74u l=0.13u
COr2_092 or2_092 0 2f
VIr2_093 ir2_093 0 0.46000
XPr2_093 or2_093 ir2_093 railr2 railr2 sg13_lv_pmos w=1.12u l=0.13u
XNr2_093 or2_093 ir2_093 0 0 sg13_lv_nmos w=0.74u l=0.13u
COr2_093 or2_093 0 2f
VIr2_094 ir2_094 0 0.46500
XPr2_094 or2_094 ir2_094 railr2 railr2 sg13_lv_pmos w=1.12u l=0.13u
XNr2_094 or2_094 ir2_094 0 0 sg13_lv_nmos w=0.74u l=0.13u
COr2_094 or2_094 0 2f
VIr2_095 ir2_095 0 0.47000
XPr2_095 or2_095 ir2_095 railr2 railr2 sg13_lv_pmos w=1.12u l=0.13u
XNr2_095 or2_095 ir2_095 0 0 sg13_lv_nmos w=0.74u l=0.13u
COr2_095 or2_095 0 2f
VIr2_096 ir2_096 0 0.47500
XPr2_096 or2_096 ir2_096 railr2 railr2 sg13_lv_pmos w=1.12u l=0.13u
XNr2_096 or2_096 ir2_096 0 0 sg13_lv_nmos w=0.74u l=0.13u
COr2_096 or2_096 0 2f
VIr2_097 ir2_097 0 0.48000
XPr2_097 or2_097 ir2_097 railr2 railr2 sg13_lv_pmos w=1.12u l=0.13u
XNr2_097 or2_097 ir2_097 0 0 sg13_lv_nmos w=0.74u l=0.13u
COr2_097 or2_097 0 2f
VIr2_098 ir2_098 0 0.48500
XPr2_098 or2_098 ir2_098 railr2 railr2 sg13_lv_pmos w=1.12u l=0.13u
XNr2_098 or2_098 ir2_098 0 0 sg13_lv_nmos w=0.74u l=0.13u
COr2_098 or2_098 0 2f
VIr2_099 ir2_099 0 0.49000
XPr2_099 or2_099 ir2_099 railr2 railr2 sg13_lv_pmos w=1.12u l=0.13u
XNr2_099 or2_099 ir2_099 0 0 sg13_lv_nmos w=0.74u l=0.13u
COr2_099 or2_099 0 2f
VIr2_100 ir2_100 0 0.49500
XPr2_100 or2_100 ir2_100 railr2 railr2 sg13_lv_pmos w=1.12u l=0.13u
XNr2_100 or2_100 ir2_100 0 0 sg13_lv_nmos w=0.74u l=0.13u
COr2_100 or2_100 0 2f
VIr2_101 ir2_101 0 0.50000
XPr2_101 or2_101 ir2_101 railr2 railr2 sg13_lv_pmos w=1.12u l=0.13u
XNr2_101 or2_101 ir2_101 0 0 sg13_lv_nmos w=0.74u l=0.13u
COr2_101 or2_101 0 2f
VIr2_102 ir2_102 0 0.50500
XPr2_102 or2_102 ir2_102 railr2 railr2 sg13_lv_pmos w=1.12u l=0.13u
XNr2_102 or2_102 ir2_102 0 0 sg13_lv_nmos w=0.74u l=0.13u
COr2_102 or2_102 0 2f
VIr2_103 ir2_103 0 0.51000
XPr2_103 or2_103 ir2_103 railr2 railr2 sg13_lv_pmos w=1.12u l=0.13u
XNr2_103 or2_103 ir2_103 0 0 sg13_lv_nmos w=0.74u l=0.13u
COr2_103 or2_103 0 2f
VIr2_104 ir2_104 0 0.51500
XPr2_104 or2_104 ir2_104 railr2 railr2 sg13_lv_pmos w=1.12u l=0.13u
XNr2_104 or2_104 ir2_104 0 0 sg13_lv_nmos w=0.74u l=0.13u
COr2_104 or2_104 0 2f
VIr2_105 ir2_105 0 0.52000
XPr2_105 or2_105 ir2_105 railr2 railr2 sg13_lv_pmos w=1.12u l=0.13u
XNr2_105 or2_105 ir2_105 0 0 sg13_lv_nmos w=0.74u l=0.13u
COr2_105 or2_105 0 2f
VIr2_106 ir2_106 0 0.52500
XPr2_106 or2_106 ir2_106 railr2 railr2 sg13_lv_pmos w=1.12u l=0.13u
XNr2_106 or2_106 ir2_106 0 0 sg13_lv_nmos w=0.74u l=0.13u
COr2_106 or2_106 0 2f
VIr2_107 ir2_107 0 0.53000
XPr2_107 or2_107 ir2_107 railr2 railr2 sg13_lv_pmos w=1.12u l=0.13u
XNr2_107 or2_107 ir2_107 0 0 sg13_lv_nmos w=0.74u l=0.13u
COr2_107 or2_107 0 2f
VIr2_108 ir2_108 0 0.53500
XPr2_108 or2_108 ir2_108 railr2 railr2 sg13_lv_pmos w=1.12u l=0.13u
XNr2_108 or2_108 ir2_108 0 0 sg13_lv_nmos w=0.74u l=0.13u
COr2_108 or2_108 0 2f
VIr2_109 ir2_109 0 0.54000
XPr2_109 or2_109 ir2_109 railr2 railr2 sg13_lv_pmos w=1.12u l=0.13u
XNr2_109 or2_109 ir2_109 0 0 sg13_lv_nmos w=0.74u l=0.13u
COr2_109 or2_109 0 2f
VIr2_110 ir2_110 0 0.54500
XPr2_110 or2_110 ir2_110 railr2 railr2 sg13_lv_pmos w=1.12u l=0.13u
XNr2_110 or2_110 ir2_110 0 0 sg13_lv_nmos w=0.74u l=0.13u
COr2_110 or2_110 0 2f
VIr2_111 ir2_111 0 0.55000
XPr2_111 or2_111 ir2_111 railr2 railr2 sg13_lv_pmos w=1.12u l=0.13u
XNr2_111 or2_111 ir2_111 0 0 sg13_lv_nmos w=0.74u l=0.13u
COr2_111 or2_111 0 2f
VIr2_112 ir2_112 0 0.55500
XPr2_112 or2_112 ir2_112 railr2 railr2 sg13_lv_pmos w=1.12u l=0.13u
XNr2_112 or2_112 ir2_112 0 0 sg13_lv_nmos w=0.74u l=0.13u
COr2_112 or2_112 0 2f
VIr2_113 ir2_113 0 0.56000
XPr2_113 or2_113 ir2_113 railr2 railr2 sg13_lv_pmos w=1.12u l=0.13u
XNr2_113 or2_113 ir2_113 0 0 sg13_lv_nmos w=0.74u l=0.13u
COr2_113 or2_113 0 2f
VIr2_114 ir2_114 0 0.56500
XPr2_114 or2_114 ir2_114 railr2 railr2 sg13_lv_pmos w=1.12u l=0.13u
XNr2_114 or2_114 ir2_114 0 0 sg13_lv_nmos w=0.74u l=0.13u
COr2_114 or2_114 0 2f
VIr2_115 ir2_115 0 0.57000
XPr2_115 or2_115 ir2_115 railr2 railr2 sg13_lv_pmos w=1.12u l=0.13u
XNr2_115 or2_115 ir2_115 0 0 sg13_lv_nmos w=0.74u l=0.13u
COr2_115 or2_115 0 2f
VIr2_116 ir2_116 0 0.57500
XPr2_116 or2_116 ir2_116 railr2 railr2 sg13_lv_pmos w=1.12u l=0.13u
XNr2_116 or2_116 ir2_116 0 0 sg13_lv_nmos w=0.74u l=0.13u
COr2_116 or2_116 0 2f
VIr2_117 ir2_117 0 0.58000
XPr2_117 or2_117 ir2_117 railr2 railr2 sg13_lv_pmos w=1.12u l=0.13u
XNr2_117 or2_117 ir2_117 0 0 sg13_lv_nmos w=0.74u l=0.13u
COr2_117 or2_117 0 2f
VIr2_118 ir2_118 0 0.58500
XPr2_118 or2_118 ir2_118 railr2 railr2 sg13_lv_pmos w=1.12u l=0.13u
XNr2_118 or2_118 ir2_118 0 0 sg13_lv_nmos w=0.74u l=0.13u
COr2_118 or2_118 0 2f
VIr2_119 ir2_119 0 0.59000
XPr2_119 or2_119 ir2_119 railr2 railr2 sg13_lv_pmos w=1.12u l=0.13u
XNr2_119 or2_119 ir2_119 0 0 sg13_lv_nmos w=0.74u l=0.13u
COr2_119 or2_119 0 2f
VIr2_120 ir2_120 0 0.59500
XPr2_120 or2_120 ir2_120 railr2 railr2 sg13_lv_pmos w=1.12u l=0.13u
XNr2_120 or2_120 ir2_120 0 0 sg13_lv_nmos w=0.74u l=0.13u
COr2_120 or2_120 0 2f
VIr2_121 ir2_121 0 0.60000
XPr2_121 or2_121 ir2_121 railr2 railr2 sg13_lv_pmos w=1.12u l=0.13u
XNr2_121 or2_121 ir2_121 0 0 sg13_lv_nmos w=0.74u l=0.13u
COr2_121 or2_121 0 2f
VIr2_122 ir2_122 0 0.60500
XPr2_122 or2_122 ir2_122 railr2 railr2 sg13_lv_pmos w=1.12u l=0.13u
XNr2_122 or2_122 ir2_122 0 0 sg13_lv_nmos w=0.74u l=0.13u
COr2_122 or2_122 0 2f
VRr3 railr3 0 0.700000
VIr3_001 ir3_001 0 0.00000
XPr3_001 or3_001 ir3_001 railr3 railr3 sg13_lv_pmos w=1.12u l=0.13u
XNr3_001 or3_001 ir3_001 0 0 sg13_lv_nmos w=0.74u l=0.13u
COr3_001 or3_001 0 2f
VIr3_002 ir3_002 0 0.00500
XPr3_002 or3_002 ir3_002 railr3 railr3 sg13_lv_pmos w=1.12u l=0.13u
XNr3_002 or3_002 ir3_002 0 0 sg13_lv_nmos w=0.74u l=0.13u
COr3_002 or3_002 0 2f
VIr3_003 ir3_003 0 0.01000
XPr3_003 or3_003 ir3_003 railr3 railr3 sg13_lv_pmos w=1.12u l=0.13u
XNr3_003 or3_003 ir3_003 0 0 sg13_lv_nmos w=0.74u l=0.13u
COr3_003 or3_003 0 2f
VIr3_004 ir3_004 0 0.01500
XPr3_004 or3_004 ir3_004 railr3 railr3 sg13_lv_pmos w=1.12u l=0.13u
XNr3_004 or3_004 ir3_004 0 0 sg13_lv_nmos w=0.74u l=0.13u
COr3_004 or3_004 0 2f
VIr3_005 ir3_005 0 0.02000
XPr3_005 or3_005 ir3_005 railr3 railr3 sg13_lv_pmos w=1.12u l=0.13u
XNr3_005 or3_005 ir3_005 0 0 sg13_lv_nmos w=0.74u l=0.13u
COr3_005 or3_005 0 2f
VIr3_006 ir3_006 0 0.02500
XPr3_006 or3_006 ir3_006 railr3 railr3 sg13_lv_pmos w=1.12u l=0.13u
XNr3_006 or3_006 ir3_006 0 0 sg13_lv_nmos w=0.74u l=0.13u
COr3_006 or3_006 0 2f
VIr3_007 ir3_007 0 0.03000
XPr3_007 or3_007 ir3_007 railr3 railr3 sg13_lv_pmos w=1.12u l=0.13u
XNr3_007 or3_007 ir3_007 0 0 sg13_lv_nmos w=0.74u l=0.13u
COr3_007 or3_007 0 2f
VIr3_008 ir3_008 0 0.03500
XPr3_008 or3_008 ir3_008 railr3 railr3 sg13_lv_pmos w=1.12u l=0.13u
XNr3_008 or3_008 ir3_008 0 0 sg13_lv_nmos w=0.74u l=0.13u
COr3_008 or3_008 0 2f
VIr3_009 ir3_009 0 0.04000
XPr3_009 or3_009 ir3_009 railr3 railr3 sg13_lv_pmos w=1.12u l=0.13u
XNr3_009 or3_009 ir3_009 0 0 sg13_lv_nmos w=0.74u l=0.13u
COr3_009 or3_009 0 2f
VIr3_010 ir3_010 0 0.04500
XPr3_010 or3_010 ir3_010 railr3 railr3 sg13_lv_pmos w=1.12u l=0.13u
XNr3_010 or3_010 ir3_010 0 0 sg13_lv_nmos w=0.74u l=0.13u
COr3_010 or3_010 0 2f
VIr3_011 ir3_011 0 0.05000
XPr3_011 or3_011 ir3_011 railr3 railr3 sg13_lv_pmos w=1.12u l=0.13u
XNr3_011 or3_011 ir3_011 0 0 sg13_lv_nmos w=0.74u l=0.13u
COr3_011 or3_011 0 2f
VIr3_012 ir3_012 0 0.05500
XPr3_012 or3_012 ir3_012 railr3 railr3 sg13_lv_pmos w=1.12u l=0.13u
XNr3_012 or3_012 ir3_012 0 0 sg13_lv_nmos w=0.74u l=0.13u
COr3_012 or3_012 0 2f
VIr3_013 ir3_013 0 0.06000
XPr3_013 or3_013 ir3_013 railr3 railr3 sg13_lv_pmos w=1.12u l=0.13u
XNr3_013 or3_013 ir3_013 0 0 sg13_lv_nmos w=0.74u l=0.13u
COr3_013 or3_013 0 2f
VIr3_014 ir3_014 0 0.06500
XPr3_014 or3_014 ir3_014 railr3 railr3 sg13_lv_pmos w=1.12u l=0.13u
XNr3_014 or3_014 ir3_014 0 0 sg13_lv_nmos w=0.74u l=0.13u
COr3_014 or3_014 0 2f
VIr3_015 ir3_015 0 0.07000
XPr3_015 or3_015 ir3_015 railr3 railr3 sg13_lv_pmos w=1.12u l=0.13u
XNr3_015 or3_015 ir3_015 0 0 sg13_lv_nmos w=0.74u l=0.13u
COr3_015 or3_015 0 2f
VIr3_016 ir3_016 0 0.07500
XPr3_016 or3_016 ir3_016 railr3 railr3 sg13_lv_pmos w=1.12u l=0.13u
XNr3_016 or3_016 ir3_016 0 0 sg13_lv_nmos w=0.74u l=0.13u
COr3_016 or3_016 0 2f
VIr3_017 ir3_017 0 0.08000
XPr3_017 or3_017 ir3_017 railr3 railr3 sg13_lv_pmos w=1.12u l=0.13u
XNr3_017 or3_017 ir3_017 0 0 sg13_lv_nmos w=0.74u l=0.13u
COr3_017 or3_017 0 2f
VIr3_018 ir3_018 0 0.08500
XPr3_018 or3_018 ir3_018 railr3 railr3 sg13_lv_pmos w=1.12u l=0.13u
XNr3_018 or3_018 ir3_018 0 0 sg13_lv_nmos w=0.74u l=0.13u
COr3_018 or3_018 0 2f
VIr3_019 ir3_019 0 0.09000
XPr3_019 or3_019 ir3_019 railr3 railr3 sg13_lv_pmos w=1.12u l=0.13u
XNr3_019 or3_019 ir3_019 0 0 sg13_lv_nmos w=0.74u l=0.13u
COr3_019 or3_019 0 2f
VIr3_020 ir3_020 0 0.09500
XPr3_020 or3_020 ir3_020 railr3 railr3 sg13_lv_pmos w=1.12u l=0.13u
XNr3_020 or3_020 ir3_020 0 0 sg13_lv_nmos w=0.74u l=0.13u
COr3_020 or3_020 0 2f
VIr3_021 ir3_021 0 0.10000
XPr3_021 or3_021 ir3_021 railr3 railr3 sg13_lv_pmos w=1.12u l=0.13u
XNr3_021 or3_021 ir3_021 0 0 sg13_lv_nmos w=0.74u l=0.13u
COr3_021 or3_021 0 2f
VIr3_022 ir3_022 0 0.10500
XPr3_022 or3_022 ir3_022 railr3 railr3 sg13_lv_pmos w=1.12u l=0.13u
XNr3_022 or3_022 ir3_022 0 0 sg13_lv_nmos w=0.74u l=0.13u
COr3_022 or3_022 0 2f
VIr3_023 ir3_023 0 0.11000
XPr3_023 or3_023 ir3_023 railr3 railr3 sg13_lv_pmos w=1.12u l=0.13u
XNr3_023 or3_023 ir3_023 0 0 sg13_lv_nmos w=0.74u l=0.13u
COr3_023 or3_023 0 2f
VIr3_024 ir3_024 0 0.11500
XPr3_024 or3_024 ir3_024 railr3 railr3 sg13_lv_pmos w=1.12u l=0.13u
XNr3_024 or3_024 ir3_024 0 0 sg13_lv_nmos w=0.74u l=0.13u
COr3_024 or3_024 0 2f
VIr3_025 ir3_025 0 0.12000
XPr3_025 or3_025 ir3_025 railr3 railr3 sg13_lv_pmos w=1.12u l=0.13u
XNr3_025 or3_025 ir3_025 0 0 sg13_lv_nmos w=0.74u l=0.13u
COr3_025 or3_025 0 2f
VIr3_026 ir3_026 0 0.12500
XPr3_026 or3_026 ir3_026 railr3 railr3 sg13_lv_pmos w=1.12u l=0.13u
XNr3_026 or3_026 ir3_026 0 0 sg13_lv_nmos w=0.74u l=0.13u
COr3_026 or3_026 0 2f
VIr3_027 ir3_027 0 0.13000
XPr3_027 or3_027 ir3_027 railr3 railr3 sg13_lv_pmos w=1.12u l=0.13u
XNr3_027 or3_027 ir3_027 0 0 sg13_lv_nmos w=0.74u l=0.13u
COr3_027 or3_027 0 2f
VIr3_028 ir3_028 0 0.13500
XPr3_028 or3_028 ir3_028 railr3 railr3 sg13_lv_pmos w=1.12u l=0.13u
XNr3_028 or3_028 ir3_028 0 0 sg13_lv_nmos w=0.74u l=0.13u
COr3_028 or3_028 0 2f
VIr3_029 ir3_029 0 0.14000
XPr3_029 or3_029 ir3_029 railr3 railr3 sg13_lv_pmos w=1.12u l=0.13u
XNr3_029 or3_029 ir3_029 0 0 sg13_lv_nmos w=0.74u l=0.13u
COr3_029 or3_029 0 2f
VIr3_030 ir3_030 0 0.14500
XPr3_030 or3_030 ir3_030 railr3 railr3 sg13_lv_pmos w=1.12u l=0.13u
XNr3_030 or3_030 ir3_030 0 0 sg13_lv_nmos w=0.74u l=0.13u
COr3_030 or3_030 0 2f
VIr3_031 ir3_031 0 0.15000
XPr3_031 or3_031 ir3_031 railr3 railr3 sg13_lv_pmos w=1.12u l=0.13u
XNr3_031 or3_031 ir3_031 0 0 sg13_lv_nmos w=0.74u l=0.13u
COr3_031 or3_031 0 2f
VIr3_032 ir3_032 0 0.15500
XPr3_032 or3_032 ir3_032 railr3 railr3 sg13_lv_pmos w=1.12u l=0.13u
XNr3_032 or3_032 ir3_032 0 0 sg13_lv_nmos w=0.74u l=0.13u
COr3_032 or3_032 0 2f
VIr3_033 ir3_033 0 0.16000
XPr3_033 or3_033 ir3_033 railr3 railr3 sg13_lv_pmos w=1.12u l=0.13u
XNr3_033 or3_033 ir3_033 0 0 sg13_lv_nmos w=0.74u l=0.13u
COr3_033 or3_033 0 2f
VIr3_034 ir3_034 0 0.16500
XPr3_034 or3_034 ir3_034 railr3 railr3 sg13_lv_pmos w=1.12u l=0.13u
XNr3_034 or3_034 ir3_034 0 0 sg13_lv_nmos w=0.74u l=0.13u
COr3_034 or3_034 0 2f
VIr3_035 ir3_035 0 0.17000
XPr3_035 or3_035 ir3_035 railr3 railr3 sg13_lv_pmos w=1.12u l=0.13u
XNr3_035 or3_035 ir3_035 0 0 sg13_lv_nmos w=0.74u l=0.13u
COr3_035 or3_035 0 2f
VIr3_036 ir3_036 0 0.17500
XPr3_036 or3_036 ir3_036 railr3 railr3 sg13_lv_pmos w=1.12u l=0.13u
XNr3_036 or3_036 ir3_036 0 0 sg13_lv_nmos w=0.74u l=0.13u
COr3_036 or3_036 0 2f
VIr3_037 ir3_037 0 0.18000
XPr3_037 or3_037 ir3_037 railr3 railr3 sg13_lv_pmos w=1.12u l=0.13u
XNr3_037 or3_037 ir3_037 0 0 sg13_lv_nmos w=0.74u l=0.13u
COr3_037 or3_037 0 2f
VIr3_038 ir3_038 0 0.18500
XPr3_038 or3_038 ir3_038 railr3 railr3 sg13_lv_pmos w=1.12u l=0.13u
XNr3_038 or3_038 ir3_038 0 0 sg13_lv_nmos w=0.74u l=0.13u
COr3_038 or3_038 0 2f
VIr3_039 ir3_039 0 0.19000
XPr3_039 or3_039 ir3_039 railr3 railr3 sg13_lv_pmos w=1.12u l=0.13u
XNr3_039 or3_039 ir3_039 0 0 sg13_lv_nmos w=0.74u l=0.13u
COr3_039 or3_039 0 2f
VIr3_040 ir3_040 0 0.19500
XPr3_040 or3_040 ir3_040 railr3 railr3 sg13_lv_pmos w=1.12u l=0.13u
XNr3_040 or3_040 ir3_040 0 0 sg13_lv_nmos w=0.74u l=0.13u
COr3_040 or3_040 0 2f
VIr3_041 ir3_041 0 0.20000
XPr3_041 or3_041 ir3_041 railr3 railr3 sg13_lv_pmos w=1.12u l=0.13u
XNr3_041 or3_041 ir3_041 0 0 sg13_lv_nmos w=0.74u l=0.13u
COr3_041 or3_041 0 2f
VIr3_042 ir3_042 0 0.20500
XPr3_042 or3_042 ir3_042 railr3 railr3 sg13_lv_pmos w=1.12u l=0.13u
XNr3_042 or3_042 ir3_042 0 0 sg13_lv_nmos w=0.74u l=0.13u
COr3_042 or3_042 0 2f
VIr3_043 ir3_043 0 0.21000
XPr3_043 or3_043 ir3_043 railr3 railr3 sg13_lv_pmos w=1.12u l=0.13u
XNr3_043 or3_043 ir3_043 0 0 sg13_lv_nmos w=0.74u l=0.13u
COr3_043 or3_043 0 2f
VIr3_044 ir3_044 0 0.21500
XPr3_044 or3_044 ir3_044 railr3 railr3 sg13_lv_pmos w=1.12u l=0.13u
XNr3_044 or3_044 ir3_044 0 0 sg13_lv_nmos w=0.74u l=0.13u
COr3_044 or3_044 0 2f
VIr3_045 ir3_045 0 0.22000
XPr3_045 or3_045 ir3_045 railr3 railr3 sg13_lv_pmos w=1.12u l=0.13u
XNr3_045 or3_045 ir3_045 0 0 sg13_lv_nmos w=0.74u l=0.13u
COr3_045 or3_045 0 2f
VIr3_046 ir3_046 0 0.22500
XPr3_046 or3_046 ir3_046 railr3 railr3 sg13_lv_pmos w=1.12u l=0.13u
XNr3_046 or3_046 ir3_046 0 0 sg13_lv_nmos w=0.74u l=0.13u
COr3_046 or3_046 0 2f
VIr3_047 ir3_047 0 0.23000
XPr3_047 or3_047 ir3_047 railr3 railr3 sg13_lv_pmos w=1.12u l=0.13u
XNr3_047 or3_047 ir3_047 0 0 sg13_lv_nmos w=0.74u l=0.13u
COr3_047 or3_047 0 2f
VIr3_048 ir3_048 0 0.23500
XPr3_048 or3_048 ir3_048 railr3 railr3 sg13_lv_pmos w=1.12u l=0.13u
XNr3_048 or3_048 ir3_048 0 0 sg13_lv_nmos w=0.74u l=0.13u
COr3_048 or3_048 0 2f
VIr3_049 ir3_049 0 0.24000
XPr3_049 or3_049 ir3_049 railr3 railr3 sg13_lv_pmos w=1.12u l=0.13u
XNr3_049 or3_049 ir3_049 0 0 sg13_lv_nmos w=0.74u l=0.13u
COr3_049 or3_049 0 2f
VIr3_050 ir3_050 0 0.24500
XPr3_050 or3_050 ir3_050 railr3 railr3 sg13_lv_pmos w=1.12u l=0.13u
XNr3_050 or3_050 ir3_050 0 0 sg13_lv_nmos w=0.74u l=0.13u
COr3_050 or3_050 0 2f
VIr3_051 ir3_051 0 0.25000
XPr3_051 or3_051 ir3_051 railr3 railr3 sg13_lv_pmos w=1.12u l=0.13u
XNr3_051 or3_051 ir3_051 0 0 sg13_lv_nmos w=0.74u l=0.13u
COr3_051 or3_051 0 2f
VIr3_052 ir3_052 0 0.25500
XPr3_052 or3_052 ir3_052 railr3 railr3 sg13_lv_pmos w=1.12u l=0.13u
XNr3_052 or3_052 ir3_052 0 0 sg13_lv_nmos w=0.74u l=0.13u
COr3_052 or3_052 0 2f
VIr3_053 ir3_053 0 0.26000
XPr3_053 or3_053 ir3_053 railr3 railr3 sg13_lv_pmos w=1.12u l=0.13u
XNr3_053 or3_053 ir3_053 0 0 sg13_lv_nmos w=0.74u l=0.13u
COr3_053 or3_053 0 2f
VIr3_054 ir3_054 0 0.26500
XPr3_054 or3_054 ir3_054 railr3 railr3 sg13_lv_pmos w=1.12u l=0.13u
XNr3_054 or3_054 ir3_054 0 0 sg13_lv_nmos w=0.74u l=0.13u
COr3_054 or3_054 0 2f
VIr3_055 ir3_055 0 0.27000
XPr3_055 or3_055 ir3_055 railr3 railr3 sg13_lv_pmos w=1.12u l=0.13u
XNr3_055 or3_055 ir3_055 0 0 sg13_lv_nmos w=0.74u l=0.13u
COr3_055 or3_055 0 2f
VIr3_056 ir3_056 0 0.27500
XPr3_056 or3_056 ir3_056 railr3 railr3 sg13_lv_pmos w=1.12u l=0.13u
XNr3_056 or3_056 ir3_056 0 0 sg13_lv_nmos w=0.74u l=0.13u
COr3_056 or3_056 0 2f
VIr3_057 ir3_057 0 0.28000
XPr3_057 or3_057 ir3_057 railr3 railr3 sg13_lv_pmos w=1.12u l=0.13u
XNr3_057 or3_057 ir3_057 0 0 sg13_lv_nmos w=0.74u l=0.13u
COr3_057 or3_057 0 2f
VIr3_058 ir3_058 0 0.28500
XPr3_058 or3_058 ir3_058 railr3 railr3 sg13_lv_pmos w=1.12u l=0.13u
XNr3_058 or3_058 ir3_058 0 0 sg13_lv_nmos w=0.74u l=0.13u
COr3_058 or3_058 0 2f
VIr3_059 ir3_059 0 0.29000
XPr3_059 or3_059 ir3_059 railr3 railr3 sg13_lv_pmos w=1.12u l=0.13u
XNr3_059 or3_059 ir3_059 0 0 sg13_lv_nmos w=0.74u l=0.13u
COr3_059 or3_059 0 2f
VIr3_060 ir3_060 0 0.29500
XPr3_060 or3_060 ir3_060 railr3 railr3 sg13_lv_pmos w=1.12u l=0.13u
XNr3_060 or3_060 ir3_060 0 0 sg13_lv_nmos w=0.74u l=0.13u
COr3_060 or3_060 0 2f
VIr3_061 ir3_061 0 0.30000
XPr3_061 or3_061 ir3_061 railr3 railr3 sg13_lv_pmos w=1.12u l=0.13u
XNr3_061 or3_061 ir3_061 0 0 sg13_lv_nmos w=0.74u l=0.13u
COr3_061 or3_061 0 2f
VIr3_062 ir3_062 0 0.30500
XPr3_062 or3_062 ir3_062 railr3 railr3 sg13_lv_pmos w=1.12u l=0.13u
XNr3_062 or3_062 ir3_062 0 0 sg13_lv_nmos w=0.74u l=0.13u
COr3_062 or3_062 0 2f
VIr3_063 ir3_063 0 0.31000
XPr3_063 or3_063 ir3_063 railr3 railr3 sg13_lv_pmos w=1.12u l=0.13u
XNr3_063 or3_063 ir3_063 0 0 sg13_lv_nmos w=0.74u l=0.13u
COr3_063 or3_063 0 2f
VIr3_064 ir3_064 0 0.31500
XPr3_064 or3_064 ir3_064 railr3 railr3 sg13_lv_pmos w=1.12u l=0.13u
XNr3_064 or3_064 ir3_064 0 0 sg13_lv_nmos w=0.74u l=0.13u
COr3_064 or3_064 0 2f
VIr3_065 ir3_065 0 0.32000
XPr3_065 or3_065 ir3_065 railr3 railr3 sg13_lv_pmos w=1.12u l=0.13u
XNr3_065 or3_065 ir3_065 0 0 sg13_lv_nmos w=0.74u l=0.13u
COr3_065 or3_065 0 2f
VIr3_066 ir3_066 0 0.32500
XPr3_066 or3_066 ir3_066 railr3 railr3 sg13_lv_pmos w=1.12u l=0.13u
XNr3_066 or3_066 ir3_066 0 0 sg13_lv_nmos w=0.74u l=0.13u
COr3_066 or3_066 0 2f
VIr3_067 ir3_067 0 0.33000
XPr3_067 or3_067 ir3_067 railr3 railr3 sg13_lv_pmos w=1.12u l=0.13u
XNr3_067 or3_067 ir3_067 0 0 sg13_lv_nmos w=0.74u l=0.13u
COr3_067 or3_067 0 2f
VIr3_068 ir3_068 0 0.33500
XPr3_068 or3_068 ir3_068 railr3 railr3 sg13_lv_pmos w=1.12u l=0.13u
XNr3_068 or3_068 ir3_068 0 0 sg13_lv_nmos w=0.74u l=0.13u
COr3_068 or3_068 0 2f
VIr3_069 ir3_069 0 0.34000
XPr3_069 or3_069 ir3_069 railr3 railr3 sg13_lv_pmos w=1.12u l=0.13u
XNr3_069 or3_069 ir3_069 0 0 sg13_lv_nmos w=0.74u l=0.13u
COr3_069 or3_069 0 2f
VIr3_070 ir3_070 0 0.34500
XPr3_070 or3_070 ir3_070 railr3 railr3 sg13_lv_pmos w=1.12u l=0.13u
XNr3_070 or3_070 ir3_070 0 0 sg13_lv_nmos w=0.74u l=0.13u
COr3_070 or3_070 0 2f
VIr3_071 ir3_071 0 0.35000
XPr3_071 or3_071 ir3_071 railr3 railr3 sg13_lv_pmos w=1.12u l=0.13u
XNr3_071 or3_071 ir3_071 0 0 sg13_lv_nmos w=0.74u l=0.13u
COr3_071 or3_071 0 2f
VIr3_072 ir3_072 0 0.35500
XPr3_072 or3_072 ir3_072 railr3 railr3 sg13_lv_pmos w=1.12u l=0.13u
XNr3_072 or3_072 ir3_072 0 0 sg13_lv_nmos w=0.74u l=0.13u
COr3_072 or3_072 0 2f
VIr3_073 ir3_073 0 0.36000
XPr3_073 or3_073 ir3_073 railr3 railr3 sg13_lv_pmos w=1.12u l=0.13u
XNr3_073 or3_073 ir3_073 0 0 sg13_lv_nmos w=0.74u l=0.13u
COr3_073 or3_073 0 2f
VIr3_074 ir3_074 0 0.36500
XPr3_074 or3_074 ir3_074 railr3 railr3 sg13_lv_pmos w=1.12u l=0.13u
XNr3_074 or3_074 ir3_074 0 0 sg13_lv_nmos w=0.74u l=0.13u
COr3_074 or3_074 0 2f
VIr3_075 ir3_075 0 0.37000
XPr3_075 or3_075 ir3_075 railr3 railr3 sg13_lv_pmos w=1.12u l=0.13u
XNr3_075 or3_075 ir3_075 0 0 sg13_lv_nmos w=0.74u l=0.13u
COr3_075 or3_075 0 2f
VIr3_076 ir3_076 0 0.37500
XPr3_076 or3_076 ir3_076 railr3 railr3 sg13_lv_pmos w=1.12u l=0.13u
XNr3_076 or3_076 ir3_076 0 0 sg13_lv_nmos w=0.74u l=0.13u
COr3_076 or3_076 0 2f
VIr3_077 ir3_077 0 0.38000
XPr3_077 or3_077 ir3_077 railr3 railr3 sg13_lv_pmos w=1.12u l=0.13u
XNr3_077 or3_077 ir3_077 0 0 sg13_lv_nmos w=0.74u l=0.13u
COr3_077 or3_077 0 2f
VIr3_078 ir3_078 0 0.38500
XPr3_078 or3_078 ir3_078 railr3 railr3 sg13_lv_pmos w=1.12u l=0.13u
XNr3_078 or3_078 ir3_078 0 0 sg13_lv_nmos w=0.74u l=0.13u
COr3_078 or3_078 0 2f
VIr3_079 ir3_079 0 0.39000
XPr3_079 or3_079 ir3_079 railr3 railr3 sg13_lv_pmos w=1.12u l=0.13u
XNr3_079 or3_079 ir3_079 0 0 sg13_lv_nmos w=0.74u l=0.13u
COr3_079 or3_079 0 2f
VIr3_080 ir3_080 0 0.39500
XPr3_080 or3_080 ir3_080 railr3 railr3 sg13_lv_pmos w=1.12u l=0.13u
XNr3_080 or3_080 ir3_080 0 0 sg13_lv_nmos w=0.74u l=0.13u
COr3_080 or3_080 0 2f
VIr3_081 ir3_081 0 0.40000
XPr3_081 or3_081 ir3_081 railr3 railr3 sg13_lv_pmos w=1.12u l=0.13u
XNr3_081 or3_081 ir3_081 0 0 sg13_lv_nmos w=0.74u l=0.13u
COr3_081 or3_081 0 2f
VIr3_082 ir3_082 0 0.40500
XPr3_082 or3_082 ir3_082 railr3 railr3 sg13_lv_pmos w=1.12u l=0.13u
XNr3_082 or3_082 ir3_082 0 0 sg13_lv_nmos w=0.74u l=0.13u
COr3_082 or3_082 0 2f
VIr3_083 ir3_083 0 0.41000
XPr3_083 or3_083 ir3_083 railr3 railr3 sg13_lv_pmos w=1.12u l=0.13u
XNr3_083 or3_083 ir3_083 0 0 sg13_lv_nmos w=0.74u l=0.13u
COr3_083 or3_083 0 2f
VIr3_084 ir3_084 0 0.41500
XPr3_084 or3_084 ir3_084 railr3 railr3 sg13_lv_pmos w=1.12u l=0.13u
XNr3_084 or3_084 ir3_084 0 0 sg13_lv_nmos w=0.74u l=0.13u
COr3_084 or3_084 0 2f
VIr3_085 ir3_085 0 0.42000
XPr3_085 or3_085 ir3_085 railr3 railr3 sg13_lv_pmos w=1.12u l=0.13u
XNr3_085 or3_085 ir3_085 0 0 sg13_lv_nmos w=0.74u l=0.13u
COr3_085 or3_085 0 2f
VIr3_086 ir3_086 0 0.42500
XPr3_086 or3_086 ir3_086 railr3 railr3 sg13_lv_pmos w=1.12u l=0.13u
XNr3_086 or3_086 ir3_086 0 0 sg13_lv_nmos w=0.74u l=0.13u
COr3_086 or3_086 0 2f
VIr3_087 ir3_087 0 0.43000
XPr3_087 or3_087 ir3_087 railr3 railr3 sg13_lv_pmos w=1.12u l=0.13u
XNr3_087 or3_087 ir3_087 0 0 sg13_lv_nmos w=0.74u l=0.13u
COr3_087 or3_087 0 2f
VIr3_088 ir3_088 0 0.43500
XPr3_088 or3_088 ir3_088 railr3 railr3 sg13_lv_pmos w=1.12u l=0.13u
XNr3_088 or3_088 ir3_088 0 0 sg13_lv_nmos w=0.74u l=0.13u
COr3_088 or3_088 0 2f
VIr3_089 ir3_089 0 0.44000
XPr3_089 or3_089 ir3_089 railr3 railr3 sg13_lv_pmos w=1.12u l=0.13u
XNr3_089 or3_089 ir3_089 0 0 sg13_lv_nmos w=0.74u l=0.13u
COr3_089 or3_089 0 2f
VIr3_090 ir3_090 0 0.44500
XPr3_090 or3_090 ir3_090 railr3 railr3 sg13_lv_pmos w=1.12u l=0.13u
XNr3_090 or3_090 ir3_090 0 0 sg13_lv_nmos w=0.74u l=0.13u
COr3_090 or3_090 0 2f
VIr3_091 ir3_091 0 0.45000
XPr3_091 or3_091 ir3_091 railr3 railr3 sg13_lv_pmos w=1.12u l=0.13u
XNr3_091 or3_091 ir3_091 0 0 sg13_lv_nmos w=0.74u l=0.13u
COr3_091 or3_091 0 2f
VIr3_092 ir3_092 0 0.45500
XPr3_092 or3_092 ir3_092 railr3 railr3 sg13_lv_pmos w=1.12u l=0.13u
XNr3_092 or3_092 ir3_092 0 0 sg13_lv_nmos w=0.74u l=0.13u
COr3_092 or3_092 0 2f
VIr3_093 ir3_093 0 0.46000
XPr3_093 or3_093 ir3_093 railr3 railr3 sg13_lv_pmos w=1.12u l=0.13u
XNr3_093 or3_093 ir3_093 0 0 sg13_lv_nmos w=0.74u l=0.13u
COr3_093 or3_093 0 2f
VIr3_094 ir3_094 0 0.46500
XPr3_094 or3_094 ir3_094 railr3 railr3 sg13_lv_pmos w=1.12u l=0.13u
XNr3_094 or3_094 ir3_094 0 0 sg13_lv_nmos w=0.74u l=0.13u
COr3_094 or3_094 0 2f
VIr3_095 ir3_095 0 0.47000
XPr3_095 or3_095 ir3_095 railr3 railr3 sg13_lv_pmos w=1.12u l=0.13u
XNr3_095 or3_095 ir3_095 0 0 sg13_lv_nmos w=0.74u l=0.13u
COr3_095 or3_095 0 2f
VIr3_096 ir3_096 0 0.47500
XPr3_096 or3_096 ir3_096 railr3 railr3 sg13_lv_pmos w=1.12u l=0.13u
XNr3_096 or3_096 ir3_096 0 0 sg13_lv_nmos w=0.74u l=0.13u
COr3_096 or3_096 0 2f
VIr3_097 ir3_097 0 0.48000
XPr3_097 or3_097 ir3_097 railr3 railr3 sg13_lv_pmos w=1.12u l=0.13u
XNr3_097 or3_097 ir3_097 0 0 sg13_lv_nmos w=0.74u l=0.13u
COr3_097 or3_097 0 2f
VIr3_098 ir3_098 0 0.48500
XPr3_098 or3_098 ir3_098 railr3 railr3 sg13_lv_pmos w=1.12u l=0.13u
XNr3_098 or3_098 ir3_098 0 0 sg13_lv_nmos w=0.74u l=0.13u
COr3_098 or3_098 0 2f
VIr3_099 ir3_099 0 0.49000
XPr3_099 or3_099 ir3_099 railr3 railr3 sg13_lv_pmos w=1.12u l=0.13u
XNr3_099 or3_099 ir3_099 0 0 sg13_lv_nmos w=0.74u l=0.13u
COr3_099 or3_099 0 2f
VIr3_100 ir3_100 0 0.49500
XPr3_100 or3_100 ir3_100 railr3 railr3 sg13_lv_pmos w=1.12u l=0.13u
XNr3_100 or3_100 ir3_100 0 0 sg13_lv_nmos w=0.74u l=0.13u
COr3_100 or3_100 0 2f
VIr3_101 ir3_101 0 0.50000
XPr3_101 or3_101 ir3_101 railr3 railr3 sg13_lv_pmos w=1.12u l=0.13u
XNr3_101 or3_101 ir3_101 0 0 sg13_lv_nmos w=0.74u l=0.13u
COr3_101 or3_101 0 2f
VIr3_102 ir3_102 0 0.50500
XPr3_102 or3_102 ir3_102 railr3 railr3 sg13_lv_pmos w=1.12u l=0.13u
XNr3_102 or3_102 ir3_102 0 0 sg13_lv_nmos w=0.74u l=0.13u
COr3_102 or3_102 0 2f
VIr3_103 ir3_103 0 0.51000
XPr3_103 or3_103 ir3_103 railr3 railr3 sg13_lv_pmos w=1.12u l=0.13u
XNr3_103 or3_103 ir3_103 0 0 sg13_lv_nmos w=0.74u l=0.13u
COr3_103 or3_103 0 2f
VIr3_104 ir3_104 0 0.51500
XPr3_104 or3_104 ir3_104 railr3 railr3 sg13_lv_pmos w=1.12u l=0.13u
XNr3_104 or3_104 ir3_104 0 0 sg13_lv_nmos w=0.74u l=0.13u
COr3_104 or3_104 0 2f
VIr3_105 ir3_105 0 0.52000
XPr3_105 or3_105 ir3_105 railr3 railr3 sg13_lv_pmos w=1.12u l=0.13u
XNr3_105 or3_105 ir3_105 0 0 sg13_lv_nmos w=0.74u l=0.13u
COr3_105 or3_105 0 2f
VIr3_106 ir3_106 0 0.52500
XPr3_106 or3_106 ir3_106 railr3 railr3 sg13_lv_pmos w=1.12u l=0.13u
XNr3_106 or3_106 ir3_106 0 0 sg13_lv_nmos w=0.74u l=0.13u
COr3_106 or3_106 0 2f
VIr3_107 ir3_107 0 0.53000
XPr3_107 or3_107 ir3_107 railr3 railr3 sg13_lv_pmos w=1.12u l=0.13u
XNr3_107 or3_107 ir3_107 0 0 sg13_lv_nmos w=0.74u l=0.13u
COr3_107 or3_107 0 2f
VIr3_108 ir3_108 0 0.53500
XPr3_108 or3_108 ir3_108 railr3 railr3 sg13_lv_pmos w=1.12u l=0.13u
XNr3_108 or3_108 ir3_108 0 0 sg13_lv_nmos w=0.74u l=0.13u
COr3_108 or3_108 0 2f
VIr3_109 ir3_109 0 0.54000
XPr3_109 or3_109 ir3_109 railr3 railr3 sg13_lv_pmos w=1.12u l=0.13u
XNr3_109 or3_109 ir3_109 0 0 sg13_lv_nmos w=0.74u l=0.13u
COr3_109 or3_109 0 2f
VIr3_110 ir3_110 0 0.54500
XPr3_110 or3_110 ir3_110 railr3 railr3 sg13_lv_pmos w=1.12u l=0.13u
XNr3_110 or3_110 ir3_110 0 0 sg13_lv_nmos w=0.74u l=0.13u
COr3_110 or3_110 0 2f
VIr3_111 ir3_111 0 0.55000
XPr3_111 or3_111 ir3_111 railr3 railr3 sg13_lv_pmos w=1.12u l=0.13u
XNr3_111 or3_111 ir3_111 0 0 sg13_lv_nmos w=0.74u l=0.13u
COr3_111 or3_111 0 2f
VIr3_112 ir3_112 0 0.55500
XPr3_112 or3_112 ir3_112 railr3 railr3 sg13_lv_pmos w=1.12u l=0.13u
XNr3_112 or3_112 ir3_112 0 0 sg13_lv_nmos w=0.74u l=0.13u
COr3_112 or3_112 0 2f
VIr3_113 ir3_113 0 0.56000
XPr3_113 or3_113 ir3_113 railr3 railr3 sg13_lv_pmos w=1.12u l=0.13u
XNr3_113 or3_113 ir3_113 0 0 sg13_lv_nmos w=0.74u l=0.13u
COr3_113 or3_113 0 2f
VIr3_114 ir3_114 0 0.56500
XPr3_114 or3_114 ir3_114 railr3 railr3 sg13_lv_pmos w=1.12u l=0.13u
XNr3_114 or3_114 ir3_114 0 0 sg13_lv_nmos w=0.74u l=0.13u
COr3_114 or3_114 0 2f
VIr3_115 ir3_115 0 0.57000
XPr3_115 or3_115 ir3_115 railr3 railr3 sg13_lv_pmos w=1.12u l=0.13u
XNr3_115 or3_115 ir3_115 0 0 sg13_lv_nmos w=0.74u l=0.13u
COr3_115 or3_115 0 2f
VIr3_116 ir3_116 0 0.57500
XPr3_116 or3_116 ir3_116 railr3 railr3 sg13_lv_pmos w=1.12u l=0.13u
XNr3_116 or3_116 ir3_116 0 0 sg13_lv_nmos w=0.74u l=0.13u
COr3_116 or3_116 0 2f
VIr3_117 ir3_117 0 0.58000
XPr3_117 or3_117 ir3_117 railr3 railr3 sg13_lv_pmos w=1.12u l=0.13u
XNr3_117 or3_117 ir3_117 0 0 sg13_lv_nmos w=0.74u l=0.13u
COr3_117 or3_117 0 2f
VIr3_118 ir3_118 0 0.58500
XPr3_118 or3_118 ir3_118 railr3 railr3 sg13_lv_pmos w=1.12u l=0.13u
XNr3_118 or3_118 ir3_118 0 0 sg13_lv_nmos w=0.74u l=0.13u
COr3_118 or3_118 0 2f
VIr3_119 ir3_119 0 0.59000
XPr3_119 or3_119 ir3_119 railr3 railr3 sg13_lv_pmos w=1.12u l=0.13u
XNr3_119 or3_119 ir3_119 0 0 sg13_lv_nmos w=0.74u l=0.13u
COr3_119 or3_119 0 2f
VIr3_120 ir3_120 0 0.59500
XPr3_120 or3_120 ir3_120 railr3 railr3 sg13_lv_pmos w=1.12u l=0.13u
XNr3_120 or3_120 ir3_120 0 0 sg13_lv_nmos w=0.74u l=0.13u
COr3_120 or3_120 0 2f
VIr3_121 ir3_121 0 0.60000
XPr3_121 or3_121 ir3_121 railr3 railr3 sg13_lv_pmos w=1.12u l=0.13u
XNr3_121 or3_121 ir3_121 0 0 sg13_lv_nmos w=0.74u l=0.13u
COr3_121 or3_121 0 2f
VIr3_122 ir3_122 0 0.60500
XPr3_122 or3_122 ir3_122 railr3 railr3 sg13_lv_pmos w=1.12u l=0.13u
XNr3_122 or3_122 ir3_122 0 0 sg13_lv_nmos w=0.74u l=0.13u
COr3_122 or3_122 0 2f
VIr3_123 ir3_123 0 0.61000
XPr3_123 or3_123 ir3_123 railr3 railr3 sg13_lv_pmos w=1.12u l=0.13u
XNr3_123 or3_123 ir3_123 0 0 sg13_lv_nmos w=0.74u l=0.13u
COr3_123 or3_123 0 2f
VIr3_124 ir3_124 0 0.61500
XPr3_124 or3_124 ir3_124 railr3 railr3 sg13_lv_pmos w=1.12u l=0.13u
XNr3_124 or3_124 ir3_124 0 0 sg13_lv_nmos w=0.74u l=0.13u
COr3_124 or3_124 0 2f
VIr3_125 ir3_125 0 0.62000
XPr3_125 or3_125 ir3_125 railr3 railr3 sg13_lv_pmos w=1.12u l=0.13u
XNr3_125 or3_125 ir3_125 0 0 sg13_lv_nmos w=0.74u l=0.13u
COr3_125 or3_125 0 2f
VIr3_126 ir3_126 0 0.62500
XPr3_126 or3_126 ir3_126 railr3 railr3 sg13_lv_pmos w=1.12u l=0.13u
XNr3_126 or3_126 ir3_126 0 0 sg13_lv_nmos w=0.74u l=0.13u
COr3_126 or3_126 0 2f
VIr3_127 ir3_127 0 0.63000
XPr3_127 or3_127 ir3_127 railr3 railr3 sg13_lv_pmos w=1.12u l=0.13u
XNr3_127 or3_127 ir3_127 0 0 sg13_lv_nmos w=0.74u l=0.13u
COr3_127 or3_127 0 2f
VIr3_128 ir3_128 0 0.63500
XPr3_128 or3_128 ir3_128 railr3 railr3 sg13_lv_pmos w=1.12u l=0.13u
XNr3_128 or3_128 ir3_128 0 0 sg13_lv_nmos w=0.74u l=0.13u
COr3_128 or3_128 0 2f
VIr3_129 ir3_129 0 0.64000
XPr3_129 or3_129 ir3_129 railr3 railr3 sg13_lv_pmos w=1.12u l=0.13u
XNr3_129 or3_129 ir3_129 0 0 sg13_lv_nmos w=0.74u l=0.13u
COr3_129 or3_129 0 2f
VIr3_130 ir3_130 0 0.64500
XPr3_130 or3_130 ir3_130 railr3 railr3 sg13_lv_pmos w=1.12u l=0.13u
XNr3_130 or3_130 ir3_130 0 0 sg13_lv_nmos w=0.74u l=0.13u
COr3_130 or3_130 0 2f
VIr3_131 ir3_131 0 0.65000
XPr3_131 or3_131 ir3_131 railr3 railr3 sg13_lv_pmos w=1.12u l=0.13u
XNr3_131 or3_131 ir3_131 0 0 sg13_lv_nmos w=0.74u l=0.13u
COr3_131 or3_131 0 2f
VIr3_132 ir3_132 0 0.65500
XPr3_132 or3_132 ir3_132 railr3 railr3 sg13_lv_pmos w=1.12u l=0.13u
XNr3_132 or3_132 ir3_132 0 0 sg13_lv_nmos w=0.74u l=0.13u
COr3_132 or3_132 0 2f
VIr3_133 ir3_133 0 0.66000
XPr3_133 or3_133 ir3_133 railr3 railr3 sg13_lv_pmos w=1.12u l=0.13u
XNr3_133 or3_133 ir3_133 0 0 sg13_lv_nmos w=0.74u l=0.13u
COr3_133 or3_133 0 2f
VIr3_134 ir3_134 0 0.66500
XPr3_134 or3_134 ir3_134 railr3 railr3 sg13_lv_pmos w=1.12u l=0.13u
XNr3_134 or3_134 ir3_134 0 0 sg13_lv_nmos w=0.74u l=0.13u
COr3_134 or3_134 0 2f
VIr3_135 ir3_135 0 0.67000
XPr3_135 or3_135 ir3_135 railr3 railr3 sg13_lv_pmos w=1.12u l=0.13u
XNr3_135 or3_135 ir3_135 0 0 sg13_lv_nmos w=0.74u l=0.13u
COr3_135 or3_135 0 2f
VIr3_136 ir3_136 0 0.67500
XPr3_136 or3_136 ir3_136 railr3 railr3 sg13_lv_pmos w=1.12u l=0.13u
XNr3_136 or3_136 ir3_136 0 0 sg13_lv_nmos w=0.74u l=0.13u
COr3_136 or3_136 0 2f
VIr3_137 ir3_137 0 0.68000
XPr3_137 or3_137 ir3_137 railr3 railr3 sg13_lv_pmos w=1.12u l=0.13u
XNr3_137 or3_137 ir3_137 0 0 sg13_lv_nmos w=0.74u l=0.13u
COr3_137 or3_137 0 2f
VIr3_138 ir3_138 0 0.68500
XPr3_138 or3_138 ir3_138 railr3 railr3 sg13_lv_pmos w=1.12u l=0.13u
XNr3_138 or3_138 ir3_138 0 0 sg13_lv_nmos w=0.74u l=0.13u
COr3_138 or3_138 0 2f
VIr3_139 ir3_139 0 0.69000
XPr3_139 or3_139 ir3_139 railr3 railr3 sg13_lv_pmos w=1.12u l=0.13u
XNr3_139 or3_139 ir3_139 0 0 sg13_lv_nmos w=0.74u l=0.13u
COr3_139 or3_139 0 2f
VIr3_140 ir3_140 0 0.69500
XPr3_140 or3_140 ir3_140 railr3 railr3 sg13_lv_pmos w=1.12u l=0.13u
XNr3_140 or3_140 ir3_140 0 0 sg13_lv_nmos w=0.74u l=0.13u
COr3_140 or3_140 0 2f
VIr3_141 ir3_141 0 0.70000
XPr3_141 or3_141 ir3_141 railr3 railr3 sg13_lv_pmos w=1.12u l=0.13u
XNr3_141 or3_141 ir3_141 0 0 sg13_lv_nmos w=0.74u l=0.13u
COr3_141 or3_141 0 2f
VRr4 railr4 0 1.000000
VIr4_001 ir4_001 0 0.00000
XPr4_001 or4_001 ir4_001 railr4 railr4 sg13_lv_pmos w=1.12u l=0.13u
XNr4_001 or4_001 ir4_001 0 0 sg13_lv_nmos w=0.74u l=0.13u
COr4_001 or4_001 0 2f
VIr4_002 ir4_002 0 0.00500
XPr4_002 or4_002 ir4_002 railr4 railr4 sg13_lv_pmos w=1.12u l=0.13u
XNr4_002 or4_002 ir4_002 0 0 sg13_lv_nmos w=0.74u l=0.13u
COr4_002 or4_002 0 2f
VIr4_003 ir4_003 0 0.01000
XPr4_003 or4_003 ir4_003 railr4 railr4 sg13_lv_pmos w=1.12u l=0.13u
XNr4_003 or4_003 ir4_003 0 0 sg13_lv_nmos w=0.74u l=0.13u
COr4_003 or4_003 0 2f
VIr4_004 ir4_004 0 0.01500
XPr4_004 or4_004 ir4_004 railr4 railr4 sg13_lv_pmos w=1.12u l=0.13u
XNr4_004 or4_004 ir4_004 0 0 sg13_lv_nmos w=0.74u l=0.13u
COr4_004 or4_004 0 2f
VIr4_005 ir4_005 0 0.02000
XPr4_005 or4_005 ir4_005 railr4 railr4 sg13_lv_pmos w=1.12u l=0.13u
XNr4_005 or4_005 ir4_005 0 0 sg13_lv_nmos w=0.74u l=0.13u
COr4_005 or4_005 0 2f
VIr4_006 ir4_006 0 0.02500
XPr4_006 or4_006 ir4_006 railr4 railr4 sg13_lv_pmos w=1.12u l=0.13u
XNr4_006 or4_006 ir4_006 0 0 sg13_lv_nmos w=0.74u l=0.13u
COr4_006 or4_006 0 2f
VIr4_007 ir4_007 0 0.03000
XPr4_007 or4_007 ir4_007 railr4 railr4 sg13_lv_pmos w=1.12u l=0.13u
XNr4_007 or4_007 ir4_007 0 0 sg13_lv_nmos w=0.74u l=0.13u
COr4_007 or4_007 0 2f
VIr4_008 ir4_008 0 0.03500
XPr4_008 or4_008 ir4_008 railr4 railr4 sg13_lv_pmos w=1.12u l=0.13u
XNr4_008 or4_008 ir4_008 0 0 sg13_lv_nmos w=0.74u l=0.13u
COr4_008 or4_008 0 2f
VIr4_009 ir4_009 0 0.04000
XPr4_009 or4_009 ir4_009 railr4 railr4 sg13_lv_pmos w=1.12u l=0.13u
XNr4_009 or4_009 ir4_009 0 0 sg13_lv_nmos w=0.74u l=0.13u
COr4_009 or4_009 0 2f
VIr4_010 ir4_010 0 0.04500
XPr4_010 or4_010 ir4_010 railr4 railr4 sg13_lv_pmos w=1.12u l=0.13u
XNr4_010 or4_010 ir4_010 0 0 sg13_lv_nmos w=0.74u l=0.13u
COr4_010 or4_010 0 2f
VIr4_011 ir4_011 0 0.05000
XPr4_011 or4_011 ir4_011 railr4 railr4 sg13_lv_pmos w=1.12u l=0.13u
XNr4_011 or4_011 ir4_011 0 0 sg13_lv_nmos w=0.74u l=0.13u
COr4_011 or4_011 0 2f
VIr4_012 ir4_012 0 0.05500
XPr4_012 or4_012 ir4_012 railr4 railr4 sg13_lv_pmos w=1.12u l=0.13u
XNr4_012 or4_012 ir4_012 0 0 sg13_lv_nmos w=0.74u l=0.13u
COr4_012 or4_012 0 2f
VIr4_013 ir4_013 0 0.06000
XPr4_013 or4_013 ir4_013 railr4 railr4 sg13_lv_pmos w=1.12u l=0.13u
XNr4_013 or4_013 ir4_013 0 0 sg13_lv_nmos w=0.74u l=0.13u
COr4_013 or4_013 0 2f
VIr4_014 ir4_014 0 0.06500
XPr4_014 or4_014 ir4_014 railr4 railr4 sg13_lv_pmos w=1.12u l=0.13u
XNr4_014 or4_014 ir4_014 0 0 sg13_lv_nmos w=0.74u l=0.13u
COr4_014 or4_014 0 2f
VIr4_015 ir4_015 0 0.07000
XPr4_015 or4_015 ir4_015 railr4 railr4 sg13_lv_pmos w=1.12u l=0.13u
XNr4_015 or4_015 ir4_015 0 0 sg13_lv_nmos w=0.74u l=0.13u
COr4_015 or4_015 0 2f
VIr4_016 ir4_016 0 0.07500
XPr4_016 or4_016 ir4_016 railr4 railr4 sg13_lv_pmos w=1.12u l=0.13u
XNr4_016 or4_016 ir4_016 0 0 sg13_lv_nmos w=0.74u l=0.13u
COr4_016 or4_016 0 2f
VIr4_017 ir4_017 0 0.08000
XPr4_017 or4_017 ir4_017 railr4 railr4 sg13_lv_pmos w=1.12u l=0.13u
XNr4_017 or4_017 ir4_017 0 0 sg13_lv_nmos w=0.74u l=0.13u
COr4_017 or4_017 0 2f
VIr4_018 ir4_018 0 0.08500
XPr4_018 or4_018 ir4_018 railr4 railr4 sg13_lv_pmos w=1.12u l=0.13u
XNr4_018 or4_018 ir4_018 0 0 sg13_lv_nmos w=0.74u l=0.13u
COr4_018 or4_018 0 2f
VIr4_019 ir4_019 0 0.09000
XPr4_019 or4_019 ir4_019 railr4 railr4 sg13_lv_pmos w=1.12u l=0.13u
XNr4_019 or4_019 ir4_019 0 0 sg13_lv_nmos w=0.74u l=0.13u
COr4_019 or4_019 0 2f
VIr4_020 ir4_020 0 0.09500
XPr4_020 or4_020 ir4_020 railr4 railr4 sg13_lv_pmos w=1.12u l=0.13u
XNr4_020 or4_020 ir4_020 0 0 sg13_lv_nmos w=0.74u l=0.13u
COr4_020 or4_020 0 2f
VIr4_021 ir4_021 0 0.10000
XPr4_021 or4_021 ir4_021 railr4 railr4 sg13_lv_pmos w=1.12u l=0.13u
XNr4_021 or4_021 ir4_021 0 0 sg13_lv_nmos w=0.74u l=0.13u
COr4_021 or4_021 0 2f
VIr4_022 ir4_022 0 0.10500
XPr4_022 or4_022 ir4_022 railr4 railr4 sg13_lv_pmos w=1.12u l=0.13u
XNr4_022 or4_022 ir4_022 0 0 sg13_lv_nmos w=0.74u l=0.13u
COr4_022 or4_022 0 2f
VIr4_023 ir4_023 0 0.11000
XPr4_023 or4_023 ir4_023 railr4 railr4 sg13_lv_pmos w=1.12u l=0.13u
XNr4_023 or4_023 ir4_023 0 0 sg13_lv_nmos w=0.74u l=0.13u
COr4_023 or4_023 0 2f
VIr4_024 ir4_024 0 0.11500
XPr4_024 or4_024 ir4_024 railr4 railr4 sg13_lv_pmos w=1.12u l=0.13u
XNr4_024 or4_024 ir4_024 0 0 sg13_lv_nmos w=0.74u l=0.13u
COr4_024 or4_024 0 2f
VIr4_025 ir4_025 0 0.12000
XPr4_025 or4_025 ir4_025 railr4 railr4 sg13_lv_pmos w=1.12u l=0.13u
XNr4_025 or4_025 ir4_025 0 0 sg13_lv_nmos w=0.74u l=0.13u
COr4_025 or4_025 0 2f
VIr4_026 ir4_026 0 0.12500
XPr4_026 or4_026 ir4_026 railr4 railr4 sg13_lv_pmos w=1.12u l=0.13u
XNr4_026 or4_026 ir4_026 0 0 sg13_lv_nmos w=0.74u l=0.13u
COr4_026 or4_026 0 2f
VIr4_027 ir4_027 0 0.13000
XPr4_027 or4_027 ir4_027 railr4 railr4 sg13_lv_pmos w=1.12u l=0.13u
XNr4_027 or4_027 ir4_027 0 0 sg13_lv_nmos w=0.74u l=0.13u
COr4_027 or4_027 0 2f
VIr4_028 ir4_028 0 0.13500
XPr4_028 or4_028 ir4_028 railr4 railr4 sg13_lv_pmos w=1.12u l=0.13u
XNr4_028 or4_028 ir4_028 0 0 sg13_lv_nmos w=0.74u l=0.13u
COr4_028 or4_028 0 2f
VIr4_029 ir4_029 0 0.14000
XPr4_029 or4_029 ir4_029 railr4 railr4 sg13_lv_pmos w=1.12u l=0.13u
XNr4_029 or4_029 ir4_029 0 0 sg13_lv_nmos w=0.74u l=0.13u
COr4_029 or4_029 0 2f
VIr4_030 ir4_030 0 0.14500
XPr4_030 or4_030 ir4_030 railr4 railr4 sg13_lv_pmos w=1.12u l=0.13u
XNr4_030 or4_030 ir4_030 0 0 sg13_lv_nmos w=0.74u l=0.13u
COr4_030 or4_030 0 2f
VIr4_031 ir4_031 0 0.15000
XPr4_031 or4_031 ir4_031 railr4 railr4 sg13_lv_pmos w=1.12u l=0.13u
XNr4_031 or4_031 ir4_031 0 0 sg13_lv_nmos w=0.74u l=0.13u
COr4_031 or4_031 0 2f
VIr4_032 ir4_032 0 0.15500
XPr4_032 or4_032 ir4_032 railr4 railr4 sg13_lv_pmos w=1.12u l=0.13u
XNr4_032 or4_032 ir4_032 0 0 sg13_lv_nmos w=0.74u l=0.13u
COr4_032 or4_032 0 2f
VIr4_033 ir4_033 0 0.16000
XPr4_033 or4_033 ir4_033 railr4 railr4 sg13_lv_pmos w=1.12u l=0.13u
XNr4_033 or4_033 ir4_033 0 0 sg13_lv_nmos w=0.74u l=0.13u
COr4_033 or4_033 0 2f
VIr4_034 ir4_034 0 0.16500
XPr4_034 or4_034 ir4_034 railr4 railr4 sg13_lv_pmos w=1.12u l=0.13u
XNr4_034 or4_034 ir4_034 0 0 sg13_lv_nmos w=0.74u l=0.13u
COr4_034 or4_034 0 2f
VIr4_035 ir4_035 0 0.17000
XPr4_035 or4_035 ir4_035 railr4 railr4 sg13_lv_pmos w=1.12u l=0.13u
XNr4_035 or4_035 ir4_035 0 0 sg13_lv_nmos w=0.74u l=0.13u
COr4_035 or4_035 0 2f
VIr4_036 ir4_036 0 0.17500
XPr4_036 or4_036 ir4_036 railr4 railr4 sg13_lv_pmos w=1.12u l=0.13u
XNr4_036 or4_036 ir4_036 0 0 sg13_lv_nmos w=0.74u l=0.13u
COr4_036 or4_036 0 2f
VIr4_037 ir4_037 0 0.18000
XPr4_037 or4_037 ir4_037 railr4 railr4 sg13_lv_pmos w=1.12u l=0.13u
XNr4_037 or4_037 ir4_037 0 0 sg13_lv_nmos w=0.74u l=0.13u
COr4_037 or4_037 0 2f
VIr4_038 ir4_038 0 0.18500
XPr4_038 or4_038 ir4_038 railr4 railr4 sg13_lv_pmos w=1.12u l=0.13u
XNr4_038 or4_038 ir4_038 0 0 sg13_lv_nmos w=0.74u l=0.13u
COr4_038 or4_038 0 2f
VIr4_039 ir4_039 0 0.19000
XPr4_039 or4_039 ir4_039 railr4 railr4 sg13_lv_pmos w=1.12u l=0.13u
XNr4_039 or4_039 ir4_039 0 0 sg13_lv_nmos w=0.74u l=0.13u
COr4_039 or4_039 0 2f
VIr4_040 ir4_040 0 0.19500
XPr4_040 or4_040 ir4_040 railr4 railr4 sg13_lv_pmos w=1.12u l=0.13u
XNr4_040 or4_040 ir4_040 0 0 sg13_lv_nmos w=0.74u l=0.13u
COr4_040 or4_040 0 2f
VIr4_041 ir4_041 0 0.20000
XPr4_041 or4_041 ir4_041 railr4 railr4 sg13_lv_pmos w=1.12u l=0.13u
XNr4_041 or4_041 ir4_041 0 0 sg13_lv_nmos w=0.74u l=0.13u
COr4_041 or4_041 0 2f
VIr4_042 ir4_042 0 0.20500
XPr4_042 or4_042 ir4_042 railr4 railr4 sg13_lv_pmos w=1.12u l=0.13u
XNr4_042 or4_042 ir4_042 0 0 sg13_lv_nmos w=0.74u l=0.13u
COr4_042 or4_042 0 2f
VIr4_043 ir4_043 0 0.21000
XPr4_043 or4_043 ir4_043 railr4 railr4 sg13_lv_pmos w=1.12u l=0.13u
XNr4_043 or4_043 ir4_043 0 0 sg13_lv_nmos w=0.74u l=0.13u
COr4_043 or4_043 0 2f
VIr4_044 ir4_044 0 0.21500
XPr4_044 or4_044 ir4_044 railr4 railr4 sg13_lv_pmos w=1.12u l=0.13u
XNr4_044 or4_044 ir4_044 0 0 sg13_lv_nmos w=0.74u l=0.13u
COr4_044 or4_044 0 2f
VIr4_045 ir4_045 0 0.22000
XPr4_045 or4_045 ir4_045 railr4 railr4 sg13_lv_pmos w=1.12u l=0.13u
XNr4_045 or4_045 ir4_045 0 0 sg13_lv_nmos w=0.74u l=0.13u
COr4_045 or4_045 0 2f
VIr4_046 ir4_046 0 0.22500
XPr4_046 or4_046 ir4_046 railr4 railr4 sg13_lv_pmos w=1.12u l=0.13u
XNr4_046 or4_046 ir4_046 0 0 sg13_lv_nmos w=0.74u l=0.13u
COr4_046 or4_046 0 2f
VIr4_047 ir4_047 0 0.23000
XPr4_047 or4_047 ir4_047 railr4 railr4 sg13_lv_pmos w=1.12u l=0.13u
XNr4_047 or4_047 ir4_047 0 0 sg13_lv_nmos w=0.74u l=0.13u
COr4_047 or4_047 0 2f
VIr4_048 ir4_048 0 0.23500
XPr4_048 or4_048 ir4_048 railr4 railr4 sg13_lv_pmos w=1.12u l=0.13u
XNr4_048 or4_048 ir4_048 0 0 sg13_lv_nmos w=0.74u l=0.13u
COr4_048 or4_048 0 2f
VIr4_049 ir4_049 0 0.24000
XPr4_049 or4_049 ir4_049 railr4 railr4 sg13_lv_pmos w=1.12u l=0.13u
XNr4_049 or4_049 ir4_049 0 0 sg13_lv_nmos w=0.74u l=0.13u
COr4_049 or4_049 0 2f
VIr4_050 ir4_050 0 0.24500
XPr4_050 or4_050 ir4_050 railr4 railr4 sg13_lv_pmos w=1.12u l=0.13u
XNr4_050 or4_050 ir4_050 0 0 sg13_lv_nmos w=0.74u l=0.13u
COr4_050 or4_050 0 2f
VIr4_051 ir4_051 0 0.25000
XPr4_051 or4_051 ir4_051 railr4 railr4 sg13_lv_pmos w=1.12u l=0.13u
XNr4_051 or4_051 ir4_051 0 0 sg13_lv_nmos w=0.74u l=0.13u
COr4_051 or4_051 0 2f
VIr4_052 ir4_052 0 0.25500
XPr4_052 or4_052 ir4_052 railr4 railr4 sg13_lv_pmos w=1.12u l=0.13u
XNr4_052 or4_052 ir4_052 0 0 sg13_lv_nmos w=0.74u l=0.13u
COr4_052 or4_052 0 2f
VIr4_053 ir4_053 0 0.26000
XPr4_053 or4_053 ir4_053 railr4 railr4 sg13_lv_pmos w=1.12u l=0.13u
XNr4_053 or4_053 ir4_053 0 0 sg13_lv_nmos w=0.74u l=0.13u
COr4_053 or4_053 0 2f
VIr4_054 ir4_054 0 0.26500
XPr4_054 or4_054 ir4_054 railr4 railr4 sg13_lv_pmos w=1.12u l=0.13u
XNr4_054 or4_054 ir4_054 0 0 sg13_lv_nmos w=0.74u l=0.13u
COr4_054 or4_054 0 2f
VIr4_055 ir4_055 0 0.27000
XPr4_055 or4_055 ir4_055 railr4 railr4 sg13_lv_pmos w=1.12u l=0.13u
XNr4_055 or4_055 ir4_055 0 0 sg13_lv_nmos w=0.74u l=0.13u
COr4_055 or4_055 0 2f
VIr4_056 ir4_056 0 0.27500
XPr4_056 or4_056 ir4_056 railr4 railr4 sg13_lv_pmos w=1.12u l=0.13u
XNr4_056 or4_056 ir4_056 0 0 sg13_lv_nmos w=0.74u l=0.13u
COr4_056 or4_056 0 2f
VIr4_057 ir4_057 0 0.28000
XPr4_057 or4_057 ir4_057 railr4 railr4 sg13_lv_pmos w=1.12u l=0.13u
XNr4_057 or4_057 ir4_057 0 0 sg13_lv_nmos w=0.74u l=0.13u
COr4_057 or4_057 0 2f
VIr4_058 ir4_058 0 0.28500
XPr4_058 or4_058 ir4_058 railr4 railr4 sg13_lv_pmos w=1.12u l=0.13u
XNr4_058 or4_058 ir4_058 0 0 sg13_lv_nmos w=0.74u l=0.13u
COr4_058 or4_058 0 2f
VIr4_059 ir4_059 0 0.29000
XPr4_059 or4_059 ir4_059 railr4 railr4 sg13_lv_pmos w=1.12u l=0.13u
XNr4_059 or4_059 ir4_059 0 0 sg13_lv_nmos w=0.74u l=0.13u
COr4_059 or4_059 0 2f
VIr4_060 ir4_060 0 0.29500
XPr4_060 or4_060 ir4_060 railr4 railr4 sg13_lv_pmos w=1.12u l=0.13u
XNr4_060 or4_060 ir4_060 0 0 sg13_lv_nmos w=0.74u l=0.13u
COr4_060 or4_060 0 2f
VIr4_061 ir4_061 0 0.30000
XPr4_061 or4_061 ir4_061 railr4 railr4 sg13_lv_pmos w=1.12u l=0.13u
XNr4_061 or4_061 ir4_061 0 0 sg13_lv_nmos w=0.74u l=0.13u
COr4_061 or4_061 0 2f
VIr4_062 ir4_062 0 0.30500
XPr4_062 or4_062 ir4_062 railr4 railr4 sg13_lv_pmos w=1.12u l=0.13u
XNr4_062 or4_062 ir4_062 0 0 sg13_lv_nmos w=0.74u l=0.13u
COr4_062 or4_062 0 2f
VIr4_063 ir4_063 0 0.31000
XPr4_063 or4_063 ir4_063 railr4 railr4 sg13_lv_pmos w=1.12u l=0.13u
XNr4_063 or4_063 ir4_063 0 0 sg13_lv_nmos w=0.74u l=0.13u
COr4_063 or4_063 0 2f
VIr4_064 ir4_064 0 0.31500
XPr4_064 or4_064 ir4_064 railr4 railr4 sg13_lv_pmos w=1.12u l=0.13u
XNr4_064 or4_064 ir4_064 0 0 sg13_lv_nmos w=0.74u l=0.13u
COr4_064 or4_064 0 2f
VIr4_065 ir4_065 0 0.32000
XPr4_065 or4_065 ir4_065 railr4 railr4 sg13_lv_pmos w=1.12u l=0.13u
XNr4_065 or4_065 ir4_065 0 0 sg13_lv_nmos w=0.74u l=0.13u
COr4_065 or4_065 0 2f
VIr4_066 ir4_066 0 0.32500
XPr4_066 or4_066 ir4_066 railr4 railr4 sg13_lv_pmos w=1.12u l=0.13u
XNr4_066 or4_066 ir4_066 0 0 sg13_lv_nmos w=0.74u l=0.13u
COr4_066 or4_066 0 2f
VIr4_067 ir4_067 0 0.33000
XPr4_067 or4_067 ir4_067 railr4 railr4 sg13_lv_pmos w=1.12u l=0.13u
XNr4_067 or4_067 ir4_067 0 0 sg13_lv_nmos w=0.74u l=0.13u
COr4_067 or4_067 0 2f
VIr4_068 ir4_068 0 0.33500
XPr4_068 or4_068 ir4_068 railr4 railr4 sg13_lv_pmos w=1.12u l=0.13u
XNr4_068 or4_068 ir4_068 0 0 sg13_lv_nmos w=0.74u l=0.13u
COr4_068 or4_068 0 2f
VIr4_069 ir4_069 0 0.34000
XPr4_069 or4_069 ir4_069 railr4 railr4 sg13_lv_pmos w=1.12u l=0.13u
XNr4_069 or4_069 ir4_069 0 0 sg13_lv_nmos w=0.74u l=0.13u
COr4_069 or4_069 0 2f
VIr4_070 ir4_070 0 0.34500
XPr4_070 or4_070 ir4_070 railr4 railr4 sg13_lv_pmos w=1.12u l=0.13u
XNr4_070 or4_070 ir4_070 0 0 sg13_lv_nmos w=0.74u l=0.13u
COr4_070 or4_070 0 2f
VIr4_071 ir4_071 0 0.35000
XPr4_071 or4_071 ir4_071 railr4 railr4 sg13_lv_pmos w=1.12u l=0.13u
XNr4_071 or4_071 ir4_071 0 0 sg13_lv_nmos w=0.74u l=0.13u
COr4_071 or4_071 0 2f
VIr4_072 ir4_072 0 0.35500
XPr4_072 or4_072 ir4_072 railr4 railr4 sg13_lv_pmos w=1.12u l=0.13u
XNr4_072 or4_072 ir4_072 0 0 sg13_lv_nmos w=0.74u l=0.13u
COr4_072 or4_072 0 2f
VIr4_073 ir4_073 0 0.36000
XPr4_073 or4_073 ir4_073 railr4 railr4 sg13_lv_pmos w=1.12u l=0.13u
XNr4_073 or4_073 ir4_073 0 0 sg13_lv_nmos w=0.74u l=0.13u
COr4_073 or4_073 0 2f
VIr4_074 ir4_074 0 0.36500
XPr4_074 or4_074 ir4_074 railr4 railr4 sg13_lv_pmos w=1.12u l=0.13u
XNr4_074 or4_074 ir4_074 0 0 sg13_lv_nmos w=0.74u l=0.13u
COr4_074 or4_074 0 2f
VIr4_075 ir4_075 0 0.37000
XPr4_075 or4_075 ir4_075 railr4 railr4 sg13_lv_pmos w=1.12u l=0.13u
XNr4_075 or4_075 ir4_075 0 0 sg13_lv_nmos w=0.74u l=0.13u
COr4_075 or4_075 0 2f
VIr4_076 ir4_076 0 0.37500
XPr4_076 or4_076 ir4_076 railr4 railr4 sg13_lv_pmos w=1.12u l=0.13u
XNr4_076 or4_076 ir4_076 0 0 sg13_lv_nmos w=0.74u l=0.13u
COr4_076 or4_076 0 2f
VIr4_077 ir4_077 0 0.38000
XPr4_077 or4_077 ir4_077 railr4 railr4 sg13_lv_pmos w=1.12u l=0.13u
XNr4_077 or4_077 ir4_077 0 0 sg13_lv_nmos w=0.74u l=0.13u
COr4_077 or4_077 0 2f
VIr4_078 ir4_078 0 0.38500
XPr4_078 or4_078 ir4_078 railr4 railr4 sg13_lv_pmos w=1.12u l=0.13u
XNr4_078 or4_078 ir4_078 0 0 sg13_lv_nmos w=0.74u l=0.13u
COr4_078 or4_078 0 2f
VIr4_079 ir4_079 0 0.39000
XPr4_079 or4_079 ir4_079 railr4 railr4 sg13_lv_pmos w=1.12u l=0.13u
XNr4_079 or4_079 ir4_079 0 0 sg13_lv_nmos w=0.74u l=0.13u
COr4_079 or4_079 0 2f
VIr4_080 ir4_080 0 0.39500
XPr4_080 or4_080 ir4_080 railr4 railr4 sg13_lv_pmos w=1.12u l=0.13u
XNr4_080 or4_080 ir4_080 0 0 sg13_lv_nmos w=0.74u l=0.13u
COr4_080 or4_080 0 2f
VIr4_081 ir4_081 0 0.40000
XPr4_081 or4_081 ir4_081 railr4 railr4 sg13_lv_pmos w=1.12u l=0.13u
XNr4_081 or4_081 ir4_081 0 0 sg13_lv_nmos w=0.74u l=0.13u
COr4_081 or4_081 0 2f
VIr4_082 ir4_082 0 0.40500
XPr4_082 or4_082 ir4_082 railr4 railr4 sg13_lv_pmos w=1.12u l=0.13u
XNr4_082 or4_082 ir4_082 0 0 sg13_lv_nmos w=0.74u l=0.13u
COr4_082 or4_082 0 2f
VIr4_083 ir4_083 0 0.41000
XPr4_083 or4_083 ir4_083 railr4 railr4 sg13_lv_pmos w=1.12u l=0.13u
XNr4_083 or4_083 ir4_083 0 0 sg13_lv_nmos w=0.74u l=0.13u
COr4_083 or4_083 0 2f
VIr4_084 ir4_084 0 0.41500
XPr4_084 or4_084 ir4_084 railr4 railr4 sg13_lv_pmos w=1.12u l=0.13u
XNr4_084 or4_084 ir4_084 0 0 sg13_lv_nmos w=0.74u l=0.13u
COr4_084 or4_084 0 2f
VIr4_085 ir4_085 0 0.42000
XPr4_085 or4_085 ir4_085 railr4 railr4 sg13_lv_pmos w=1.12u l=0.13u
XNr4_085 or4_085 ir4_085 0 0 sg13_lv_nmos w=0.74u l=0.13u
COr4_085 or4_085 0 2f
VIr4_086 ir4_086 0 0.42500
XPr4_086 or4_086 ir4_086 railr4 railr4 sg13_lv_pmos w=1.12u l=0.13u
XNr4_086 or4_086 ir4_086 0 0 sg13_lv_nmos w=0.74u l=0.13u
COr4_086 or4_086 0 2f
VIr4_087 ir4_087 0 0.43000
XPr4_087 or4_087 ir4_087 railr4 railr4 sg13_lv_pmos w=1.12u l=0.13u
XNr4_087 or4_087 ir4_087 0 0 sg13_lv_nmos w=0.74u l=0.13u
COr4_087 or4_087 0 2f
VIr4_088 ir4_088 0 0.43500
XPr4_088 or4_088 ir4_088 railr4 railr4 sg13_lv_pmos w=1.12u l=0.13u
XNr4_088 or4_088 ir4_088 0 0 sg13_lv_nmos w=0.74u l=0.13u
COr4_088 or4_088 0 2f
VIr4_089 ir4_089 0 0.44000
XPr4_089 or4_089 ir4_089 railr4 railr4 sg13_lv_pmos w=1.12u l=0.13u
XNr4_089 or4_089 ir4_089 0 0 sg13_lv_nmos w=0.74u l=0.13u
COr4_089 or4_089 0 2f
VIr4_090 ir4_090 0 0.44500
XPr4_090 or4_090 ir4_090 railr4 railr4 sg13_lv_pmos w=1.12u l=0.13u
XNr4_090 or4_090 ir4_090 0 0 sg13_lv_nmos w=0.74u l=0.13u
COr4_090 or4_090 0 2f
VIr4_091 ir4_091 0 0.45000
XPr4_091 or4_091 ir4_091 railr4 railr4 sg13_lv_pmos w=1.12u l=0.13u
XNr4_091 or4_091 ir4_091 0 0 sg13_lv_nmos w=0.74u l=0.13u
COr4_091 or4_091 0 2f
VIr4_092 ir4_092 0 0.45500
XPr4_092 or4_092 ir4_092 railr4 railr4 sg13_lv_pmos w=1.12u l=0.13u
XNr4_092 or4_092 ir4_092 0 0 sg13_lv_nmos w=0.74u l=0.13u
COr4_092 or4_092 0 2f
VIr4_093 ir4_093 0 0.46000
XPr4_093 or4_093 ir4_093 railr4 railr4 sg13_lv_pmos w=1.12u l=0.13u
XNr4_093 or4_093 ir4_093 0 0 sg13_lv_nmos w=0.74u l=0.13u
COr4_093 or4_093 0 2f
VIr4_094 ir4_094 0 0.46500
XPr4_094 or4_094 ir4_094 railr4 railr4 sg13_lv_pmos w=1.12u l=0.13u
XNr4_094 or4_094 ir4_094 0 0 sg13_lv_nmos w=0.74u l=0.13u
COr4_094 or4_094 0 2f
VIr4_095 ir4_095 0 0.47000
XPr4_095 or4_095 ir4_095 railr4 railr4 sg13_lv_pmos w=1.12u l=0.13u
XNr4_095 or4_095 ir4_095 0 0 sg13_lv_nmos w=0.74u l=0.13u
COr4_095 or4_095 0 2f
VIr4_096 ir4_096 0 0.47500
XPr4_096 or4_096 ir4_096 railr4 railr4 sg13_lv_pmos w=1.12u l=0.13u
XNr4_096 or4_096 ir4_096 0 0 sg13_lv_nmos w=0.74u l=0.13u
COr4_096 or4_096 0 2f
VIr4_097 ir4_097 0 0.48000
XPr4_097 or4_097 ir4_097 railr4 railr4 sg13_lv_pmos w=1.12u l=0.13u
XNr4_097 or4_097 ir4_097 0 0 sg13_lv_nmos w=0.74u l=0.13u
COr4_097 or4_097 0 2f
VIr4_098 ir4_098 0 0.48500
XPr4_098 or4_098 ir4_098 railr4 railr4 sg13_lv_pmos w=1.12u l=0.13u
XNr4_098 or4_098 ir4_098 0 0 sg13_lv_nmos w=0.74u l=0.13u
COr4_098 or4_098 0 2f
VIr4_099 ir4_099 0 0.49000
XPr4_099 or4_099 ir4_099 railr4 railr4 sg13_lv_pmos w=1.12u l=0.13u
XNr4_099 or4_099 ir4_099 0 0 sg13_lv_nmos w=0.74u l=0.13u
COr4_099 or4_099 0 2f
VIr4_100 ir4_100 0 0.49500
XPr4_100 or4_100 ir4_100 railr4 railr4 sg13_lv_pmos w=1.12u l=0.13u
XNr4_100 or4_100 ir4_100 0 0 sg13_lv_nmos w=0.74u l=0.13u
COr4_100 or4_100 0 2f
VIr4_101 ir4_101 0 0.50000
XPr4_101 or4_101 ir4_101 railr4 railr4 sg13_lv_pmos w=1.12u l=0.13u
XNr4_101 or4_101 ir4_101 0 0 sg13_lv_nmos w=0.74u l=0.13u
COr4_101 or4_101 0 2f
VIr4_102 ir4_102 0 0.50500
XPr4_102 or4_102 ir4_102 railr4 railr4 sg13_lv_pmos w=1.12u l=0.13u
XNr4_102 or4_102 ir4_102 0 0 sg13_lv_nmos w=0.74u l=0.13u
COr4_102 or4_102 0 2f
VIr4_103 ir4_103 0 0.51000
XPr4_103 or4_103 ir4_103 railr4 railr4 sg13_lv_pmos w=1.12u l=0.13u
XNr4_103 or4_103 ir4_103 0 0 sg13_lv_nmos w=0.74u l=0.13u
COr4_103 or4_103 0 2f
VIr4_104 ir4_104 0 0.51500
XPr4_104 or4_104 ir4_104 railr4 railr4 sg13_lv_pmos w=1.12u l=0.13u
XNr4_104 or4_104 ir4_104 0 0 sg13_lv_nmos w=0.74u l=0.13u
COr4_104 or4_104 0 2f
VIr4_105 ir4_105 0 0.52000
XPr4_105 or4_105 ir4_105 railr4 railr4 sg13_lv_pmos w=1.12u l=0.13u
XNr4_105 or4_105 ir4_105 0 0 sg13_lv_nmos w=0.74u l=0.13u
COr4_105 or4_105 0 2f
VIr4_106 ir4_106 0 0.52500
XPr4_106 or4_106 ir4_106 railr4 railr4 sg13_lv_pmos w=1.12u l=0.13u
XNr4_106 or4_106 ir4_106 0 0 sg13_lv_nmos w=0.74u l=0.13u
COr4_106 or4_106 0 2f
VIr4_107 ir4_107 0 0.53000
XPr4_107 or4_107 ir4_107 railr4 railr4 sg13_lv_pmos w=1.12u l=0.13u
XNr4_107 or4_107 ir4_107 0 0 sg13_lv_nmos w=0.74u l=0.13u
COr4_107 or4_107 0 2f
VIr4_108 ir4_108 0 0.53500
XPr4_108 or4_108 ir4_108 railr4 railr4 sg13_lv_pmos w=1.12u l=0.13u
XNr4_108 or4_108 ir4_108 0 0 sg13_lv_nmos w=0.74u l=0.13u
COr4_108 or4_108 0 2f
VIr4_109 ir4_109 0 0.54000
XPr4_109 or4_109 ir4_109 railr4 railr4 sg13_lv_pmos w=1.12u l=0.13u
XNr4_109 or4_109 ir4_109 0 0 sg13_lv_nmos w=0.74u l=0.13u
COr4_109 or4_109 0 2f
VIr4_110 ir4_110 0 0.54500
XPr4_110 or4_110 ir4_110 railr4 railr4 sg13_lv_pmos w=1.12u l=0.13u
XNr4_110 or4_110 ir4_110 0 0 sg13_lv_nmos w=0.74u l=0.13u
COr4_110 or4_110 0 2f
VIr4_111 ir4_111 0 0.55000
XPr4_111 or4_111 ir4_111 railr4 railr4 sg13_lv_pmos w=1.12u l=0.13u
XNr4_111 or4_111 ir4_111 0 0 sg13_lv_nmos w=0.74u l=0.13u
COr4_111 or4_111 0 2f
VIr4_112 ir4_112 0 0.55500
XPr4_112 or4_112 ir4_112 railr4 railr4 sg13_lv_pmos w=1.12u l=0.13u
XNr4_112 or4_112 ir4_112 0 0 sg13_lv_nmos w=0.74u l=0.13u
COr4_112 or4_112 0 2f
VIr4_113 ir4_113 0 0.56000
XPr4_113 or4_113 ir4_113 railr4 railr4 sg13_lv_pmos w=1.12u l=0.13u
XNr4_113 or4_113 ir4_113 0 0 sg13_lv_nmos w=0.74u l=0.13u
COr4_113 or4_113 0 2f
VIr4_114 ir4_114 0 0.56500
XPr4_114 or4_114 ir4_114 railr4 railr4 sg13_lv_pmos w=1.12u l=0.13u
XNr4_114 or4_114 ir4_114 0 0 sg13_lv_nmos w=0.74u l=0.13u
COr4_114 or4_114 0 2f
VIr4_115 ir4_115 0 0.57000
XPr4_115 or4_115 ir4_115 railr4 railr4 sg13_lv_pmos w=1.12u l=0.13u
XNr4_115 or4_115 ir4_115 0 0 sg13_lv_nmos w=0.74u l=0.13u
COr4_115 or4_115 0 2f
VIr4_116 ir4_116 0 0.57500
XPr4_116 or4_116 ir4_116 railr4 railr4 sg13_lv_pmos w=1.12u l=0.13u
XNr4_116 or4_116 ir4_116 0 0 sg13_lv_nmos w=0.74u l=0.13u
COr4_116 or4_116 0 2f
VIr4_117 ir4_117 0 0.58000
XPr4_117 or4_117 ir4_117 railr4 railr4 sg13_lv_pmos w=1.12u l=0.13u
XNr4_117 or4_117 ir4_117 0 0 sg13_lv_nmos w=0.74u l=0.13u
COr4_117 or4_117 0 2f
VIr4_118 ir4_118 0 0.58500
XPr4_118 or4_118 ir4_118 railr4 railr4 sg13_lv_pmos w=1.12u l=0.13u
XNr4_118 or4_118 ir4_118 0 0 sg13_lv_nmos w=0.74u l=0.13u
COr4_118 or4_118 0 2f
VIr4_119 ir4_119 0 0.59000
XPr4_119 or4_119 ir4_119 railr4 railr4 sg13_lv_pmos w=1.12u l=0.13u
XNr4_119 or4_119 ir4_119 0 0 sg13_lv_nmos w=0.74u l=0.13u
COr4_119 or4_119 0 2f
VIr4_120 ir4_120 0 0.59500
XPr4_120 or4_120 ir4_120 railr4 railr4 sg13_lv_pmos w=1.12u l=0.13u
XNr4_120 or4_120 ir4_120 0 0 sg13_lv_nmos w=0.74u l=0.13u
COr4_120 or4_120 0 2f
VIr4_121 ir4_121 0 0.60000
XPr4_121 or4_121 ir4_121 railr4 railr4 sg13_lv_pmos w=1.12u l=0.13u
XNr4_121 or4_121 ir4_121 0 0 sg13_lv_nmos w=0.74u l=0.13u
COr4_121 or4_121 0 2f
VIr4_122 ir4_122 0 0.60500
XPr4_122 or4_122 ir4_122 railr4 railr4 sg13_lv_pmos w=1.12u l=0.13u
XNr4_122 or4_122 ir4_122 0 0 sg13_lv_nmos w=0.74u l=0.13u
COr4_122 or4_122 0 2f
VIr4_123 ir4_123 0 0.61000
XPr4_123 or4_123 ir4_123 railr4 railr4 sg13_lv_pmos w=1.12u l=0.13u
XNr4_123 or4_123 ir4_123 0 0 sg13_lv_nmos w=0.74u l=0.13u
COr4_123 or4_123 0 2f
VIr4_124 ir4_124 0 0.61500
XPr4_124 or4_124 ir4_124 railr4 railr4 sg13_lv_pmos w=1.12u l=0.13u
XNr4_124 or4_124 ir4_124 0 0 sg13_lv_nmos w=0.74u l=0.13u
COr4_124 or4_124 0 2f
VIr4_125 ir4_125 0 0.62000
XPr4_125 or4_125 ir4_125 railr4 railr4 sg13_lv_pmos w=1.12u l=0.13u
XNr4_125 or4_125 ir4_125 0 0 sg13_lv_nmos w=0.74u l=0.13u
COr4_125 or4_125 0 2f
VIr4_126 ir4_126 0 0.62500
XPr4_126 or4_126 ir4_126 railr4 railr4 sg13_lv_pmos w=1.12u l=0.13u
XNr4_126 or4_126 ir4_126 0 0 sg13_lv_nmos w=0.74u l=0.13u
COr4_126 or4_126 0 2f
VIr4_127 ir4_127 0 0.63000
XPr4_127 or4_127 ir4_127 railr4 railr4 sg13_lv_pmos w=1.12u l=0.13u
XNr4_127 or4_127 ir4_127 0 0 sg13_lv_nmos w=0.74u l=0.13u
COr4_127 or4_127 0 2f
VIr4_128 ir4_128 0 0.63500
XPr4_128 or4_128 ir4_128 railr4 railr4 sg13_lv_pmos w=1.12u l=0.13u
XNr4_128 or4_128 ir4_128 0 0 sg13_lv_nmos w=0.74u l=0.13u
COr4_128 or4_128 0 2f
VIr4_129 ir4_129 0 0.64000
XPr4_129 or4_129 ir4_129 railr4 railr4 sg13_lv_pmos w=1.12u l=0.13u
XNr4_129 or4_129 ir4_129 0 0 sg13_lv_nmos w=0.74u l=0.13u
COr4_129 or4_129 0 2f
VIr4_130 ir4_130 0 0.64500
XPr4_130 or4_130 ir4_130 railr4 railr4 sg13_lv_pmos w=1.12u l=0.13u
XNr4_130 or4_130 ir4_130 0 0 sg13_lv_nmos w=0.74u l=0.13u
COr4_130 or4_130 0 2f
VIr4_131 ir4_131 0 0.65000
XPr4_131 or4_131 ir4_131 railr4 railr4 sg13_lv_pmos w=1.12u l=0.13u
XNr4_131 or4_131 ir4_131 0 0 sg13_lv_nmos w=0.74u l=0.13u
COr4_131 or4_131 0 2f
VIr4_132 ir4_132 0 0.65500
XPr4_132 or4_132 ir4_132 railr4 railr4 sg13_lv_pmos w=1.12u l=0.13u
XNr4_132 or4_132 ir4_132 0 0 sg13_lv_nmos w=0.74u l=0.13u
COr4_132 or4_132 0 2f
VIr4_133 ir4_133 0 0.66000
XPr4_133 or4_133 ir4_133 railr4 railr4 sg13_lv_pmos w=1.12u l=0.13u
XNr4_133 or4_133 ir4_133 0 0 sg13_lv_nmos w=0.74u l=0.13u
COr4_133 or4_133 0 2f
VIr4_134 ir4_134 0 0.66500
XPr4_134 or4_134 ir4_134 railr4 railr4 sg13_lv_pmos w=1.12u l=0.13u
XNr4_134 or4_134 ir4_134 0 0 sg13_lv_nmos w=0.74u l=0.13u
COr4_134 or4_134 0 2f
VIr4_135 ir4_135 0 0.67000
XPr4_135 or4_135 ir4_135 railr4 railr4 sg13_lv_pmos w=1.12u l=0.13u
XNr4_135 or4_135 ir4_135 0 0 sg13_lv_nmos w=0.74u l=0.13u
COr4_135 or4_135 0 2f
VIr4_136 ir4_136 0 0.67500
XPr4_136 or4_136 ir4_136 railr4 railr4 sg13_lv_pmos w=1.12u l=0.13u
XNr4_136 or4_136 ir4_136 0 0 sg13_lv_nmos w=0.74u l=0.13u
COr4_136 or4_136 0 2f
VIr4_137 ir4_137 0 0.68000
XPr4_137 or4_137 ir4_137 railr4 railr4 sg13_lv_pmos w=1.12u l=0.13u
XNr4_137 or4_137 ir4_137 0 0 sg13_lv_nmos w=0.74u l=0.13u
COr4_137 or4_137 0 2f
VIr4_138 ir4_138 0 0.68500
XPr4_138 or4_138 ir4_138 railr4 railr4 sg13_lv_pmos w=1.12u l=0.13u
XNr4_138 or4_138 ir4_138 0 0 sg13_lv_nmos w=0.74u l=0.13u
COr4_138 or4_138 0 2f
VIr4_139 ir4_139 0 0.69000
XPr4_139 or4_139 ir4_139 railr4 railr4 sg13_lv_pmos w=1.12u l=0.13u
XNr4_139 or4_139 ir4_139 0 0 sg13_lv_nmos w=0.74u l=0.13u
COr4_139 or4_139 0 2f
VIr4_140 ir4_140 0 0.69500
XPr4_140 or4_140 ir4_140 railr4 railr4 sg13_lv_pmos w=1.12u l=0.13u
XNr4_140 or4_140 ir4_140 0 0 sg13_lv_nmos w=0.74u l=0.13u
COr4_140 or4_140 0 2f
VIr4_141 ir4_141 0 0.70000
XPr4_141 or4_141 ir4_141 railr4 railr4 sg13_lv_pmos w=1.12u l=0.13u
XNr4_141 or4_141 ir4_141 0 0 sg13_lv_nmos w=0.74u l=0.13u
COr4_141 or4_141 0 2f
VIr4_142 ir4_142 0 0.70500
XPr4_142 or4_142 ir4_142 railr4 railr4 sg13_lv_pmos w=1.12u l=0.13u
XNr4_142 or4_142 ir4_142 0 0 sg13_lv_nmos w=0.74u l=0.13u
COr4_142 or4_142 0 2f
VIr4_143 ir4_143 0 0.71000
XPr4_143 or4_143 ir4_143 railr4 railr4 sg13_lv_pmos w=1.12u l=0.13u
XNr4_143 or4_143 ir4_143 0 0 sg13_lv_nmos w=0.74u l=0.13u
COr4_143 or4_143 0 2f
VIr4_144 ir4_144 0 0.71500
XPr4_144 or4_144 ir4_144 railr4 railr4 sg13_lv_pmos w=1.12u l=0.13u
XNr4_144 or4_144 ir4_144 0 0 sg13_lv_nmos w=0.74u l=0.13u
COr4_144 or4_144 0 2f
VIr4_145 ir4_145 0 0.72000
XPr4_145 or4_145 ir4_145 railr4 railr4 sg13_lv_pmos w=1.12u l=0.13u
XNr4_145 or4_145 ir4_145 0 0 sg13_lv_nmos w=0.74u l=0.13u
COr4_145 or4_145 0 2f
VIr4_146 ir4_146 0 0.72500
XPr4_146 or4_146 ir4_146 railr4 railr4 sg13_lv_pmos w=1.12u l=0.13u
XNr4_146 or4_146 ir4_146 0 0 sg13_lv_nmos w=0.74u l=0.13u
COr4_146 or4_146 0 2f
VIr4_147 ir4_147 0 0.73000
XPr4_147 or4_147 ir4_147 railr4 railr4 sg13_lv_pmos w=1.12u l=0.13u
XNr4_147 or4_147 ir4_147 0 0 sg13_lv_nmos w=0.74u l=0.13u
COr4_147 or4_147 0 2f
VIr4_148 ir4_148 0 0.73500
XPr4_148 or4_148 ir4_148 railr4 railr4 sg13_lv_pmos w=1.12u l=0.13u
XNr4_148 or4_148 ir4_148 0 0 sg13_lv_nmos w=0.74u l=0.13u
COr4_148 or4_148 0 2f
VIr4_149 ir4_149 0 0.74000
XPr4_149 or4_149 ir4_149 railr4 railr4 sg13_lv_pmos w=1.12u l=0.13u
XNr4_149 or4_149 ir4_149 0 0 sg13_lv_nmos w=0.74u l=0.13u
COr4_149 or4_149 0 2f
VIr4_150 ir4_150 0 0.74500
XPr4_150 or4_150 ir4_150 railr4 railr4 sg13_lv_pmos w=1.12u l=0.13u
XNr4_150 or4_150 ir4_150 0 0 sg13_lv_nmos w=0.74u l=0.13u
COr4_150 or4_150 0 2f
VIr4_151 ir4_151 0 0.75000
XPr4_151 or4_151 ir4_151 railr4 railr4 sg13_lv_pmos w=1.12u l=0.13u
XNr4_151 or4_151 ir4_151 0 0 sg13_lv_nmos w=0.74u l=0.13u
COr4_151 or4_151 0 2f
VIr4_152 ir4_152 0 0.75500
XPr4_152 or4_152 ir4_152 railr4 railr4 sg13_lv_pmos w=1.12u l=0.13u
XNr4_152 or4_152 ir4_152 0 0 sg13_lv_nmos w=0.74u l=0.13u
COr4_152 or4_152 0 2f
VIr4_153 ir4_153 0 0.76000
XPr4_153 or4_153 ir4_153 railr4 railr4 sg13_lv_pmos w=1.12u l=0.13u
XNr4_153 or4_153 ir4_153 0 0 sg13_lv_nmos w=0.74u l=0.13u
COr4_153 or4_153 0 2f
VIr4_154 ir4_154 0 0.76500
XPr4_154 or4_154 ir4_154 railr4 railr4 sg13_lv_pmos w=1.12u l=0.13u
XNr4_154 or4_154 ir4_154 0 0 sg13_lv_nmos w=0.74u l=0.13u
COr4_154 or4_154 0 2f
VIr4_155 ir4_155 0 0.77000
XPr4_155 or4_155 ir4_155 railr4 railr4 sg13_lv_pmos w=1.12u l=0.13u
XNr4_155 or4_155 ir4_155 0 0 sg13_lv_nmos w=0.74u l=0.13u
COr4_155 or4_155 0 2f
VIr4_156 ir4_156 0 0.77500
XPr4_156 or4_156 ir4_156 railr4 railr4 sg13_lv_pmos w=1.12u l=0.13u
XNr4_156 or4_156 ir4_156 0 0 sg13_lv_nmos w=0.74u l=0.13u
COr4_156 or4_156 0 2f
VIr4_157 ir4_157 0 0.78000
XPr4_157 or4_157 ir4_157 railr4 railr4 sg13_lv_pmos w=1.12u l=0.13u
XNr4_157 or4_157 ir4_157 0 0 sg13_lv_nmos w=0.74u l=0.13u
COr4_157 or4_157 0 2f
VIr4_158 ir4_158 0 0.78500
XPr4_158 or4_158 ir4_158 railr4 railr4 sg13_lv_pmos w=1.12u l=0.13u
XNr4_158 or4_158 ir4_158 0 0 sg13_lv_nmos w=0.74u l=0.13u
COr4_158 or4_158 0 2f
VIr4_159 ir4_159 0 0.79000
XPr4_159 or4_159 ir4_159 railr4 railr4 sg13_lv_pmos w=1.12u l=0.13u
XNr4_159 or4_159 ir4_159 0 0 sg13_lv_nmos w=0.74u l=0.13u
COr4_159 or4_159 0 2f
VIr4_160 ir4_160 0 0.79500
XPr4_160 or4_160 ir4_160 railr4 railr4 sg13_lv_pmos w=1.12u l=0.13u
XNr4_160 or4_160 ir4_160 0 0 sg13_lv_nmos w=0.74u l=0.13u
COr4_160 or4_160 0 2f
VIr4_161 ir4_161 0 0.80000
XPr4_161 or4_161 ir4_161 railr4 railr4 sg13_lv_pmos w=1.12u l=0.13u
XNr4_161 or4_161 ir4_161 0 0 sg13_lv_nmos w=0.74u l=0.13u
COr4_161 or4_161 0 2f
VIr4_162 ir4_162 0 0.80500
XPr4_162 or4_162 ir4_162 railr4 railr4 sg13_lv_pmos w=1.12u l=0.13u
XNr4_162 or4_162 ir4_162 0 0 sg13_lv_nmos w=0.74u l=0.13u
COr4_162 or4_162 0 2f
VIr4_163 ir4_163 0 0.81000
XPr4_163 or4_163 ir4_163 railr4 railr4 sg13_lv_pmos w=1.12u l=0.13u
XNr4_163 or4_163 ir4_163 0 0 sg13_lv_nmos w=0.74u l=0.13u
COr4_163 or4_163 0 2f
VIr4_164 ir4_164 0 0.81500
XPr4_164 or4_164 ir4_164 railr4 railr4 sg13_lv_pmos w=1.12u l=0.13u
XNr4_164 or4_164 ir4_164 0 0 sg13_lv_nmos w=0.74u l=0.13u
COr4_164 or4_164 0 2f
VIr4_165 ir4_165 0 0.82000
XPr4_165 or4_165 ir4_165 railr4 railr4 sg13_lv_pmos w=1.12u l=0.13u
XNr4_165 or4_165 ir4_165 0 0 sg13_lv_nmos w=0.74u l=0.13u
COr4_165 or4_165 0 2f
VIr4_166 ir4_166 0 0.82500
XPr4_166 or4_166 ir4_166 railr4 railr4 sg13_lv_pmos w=1.12u l=0.13u
XNr4_166 or4_166 ir4_166 0 0 sg13_lv_nmos w=0.74u l=0.13u
COr4_166 or4_166 0 2f
VIr4_167 ir4_167 0 0.83000
XPr4_167 or4_167 ir4_167 railr4 railr4 sg13_lv_pmos w=1.12u l=0.13u
XNr4_167 or4_167 ir4_167 0 0 sg13_lv_nmos w=0.74u l=0.13u
COr4_167 or4_167 0 2f
VIr4_168 ir4_168 0 0.83500
XPr4_168 or4_168 ir4_168 railr4 railr4 sg13_lv_pmos w=1.12u l=0.13u
XNr4_168 or4_168 ir4_168 0 0 sg13_lv_nmos w=0.74u l=0.13u
COr4_168 or4_168 0 2f
VIr4_169 ir4_169 0 0.84000
XPr4_169 or4_169 ir4_169 railr4 railr4 sg13_lv_pmos w=1.12u l=0.13u
XNr4_169 or4_169 ir4_169 0 0 sg13_lv_nmos w=0.74u l=0.13u
COr4_169 or4_169 0 2f
VIr4_170 ir4_170 0 0.84500
XPr4_170 or4_170 ir4_170 railr4 railr4 sg13_lv_pmos w=1.12u l=0.13u
XNr4_170 or4_170 ir4_170 0 0 sg13_lv_nmos w=0.74u l=0.13u
COr4_170 or4_170 0 2f
VIr4_171 ir4_171 0 0.85000
XPr4_171 or4_171 ir4_171 railr4 railr4 sg13_lv_pmos w=1.12u l=0.13u
XNr4_171 or4_171 ir4_171 0 0 sg13_lv_nmos w=0.74u l=0.13u
COr4_171 or4_171 0 2f
VIr4_172 ir4_172 0 0.85500
XPr4_172 or4_172 ir4_172 railr4 railr4 sg13_lv_pmos w=1.12u l=0.13u
XNr4_172 or4_172 ir4_172 0 0 sg13_lv_nmos w=0.74u l=0.13u
COr4_172 or4_172 0 2f
VIr4_173 ir4_173 0 0.86000
XPr4_173 or4_173 ir4_173 railr4 railr4 sg13_lv_pmos w=1.12u l=0.13u
XNr4_173 or4_173 ir4_173 0 0 sg13_lv_nmos w=0.74u l=0.13u
COr4_173 or4_173 0 2f
VIr4_174 ir4_174 0 0.86500
XPr4_174 or4_174 ir4_174 railr4 railr4 sg13_lv_pmos w=1.12u l=0.13u
XNr4_174 or4_174 ir4_174 0 0 sg13_lv_nmos w=0.74u l=0.13u
COr4_174 or4_174 0 2f
VIr4_175 ir4_175 0 0.87000
XPr4_175 or4_175 ir4_175 railr4 railr4 sg13_lv_pmos w=1.12u l=0.13u
XNr4_175 or4_175 ir4_175 0 0 sg13_lv_nmos w=0.74u l=0.13u
COr4_175 or4_175 0 2f
VIr4_176 ir4_176 0 0.87500
XPr4_176 or4_176 ir4_176 railr4 railr4 sg13_lv_pmos w=1.12u l=0.13u
XNr4_176 or4_176 ir4_176 0 0 sg13_lv_nmos w=0.74u l=0.13u
COr4_176 or4_176 0 2f
VIr4_177 ir4_177 0 0.88000
XPr4_177 or4_177 ir4_177 railr4 railr4 sg13_lv_pmos w=1.12u l=0.13u
XNr4_177 or4_177 ir4_177 0 0 sg13_lv_nmos w=0.74u l=0.13u
COr4_177 or4_177 0 2f
VIr4_178 ir4_178 0 0.88500
XPr4_178 or4_178 ir4_178 railr4 railr4 sg13_lv_pmos w=1.12u l=0.13u
XNr4_178 or4_178 ir4_178 0 0 sg13_lv_nmos w=0.74u l=0.13u
COr4_178 or4_178 0 2f
VIr4_179 ir4_179 0 0.89000
XPr4_179 or4_179 ir4_179 railr4 railr4 sg13_lv_pmos w=1.12u l=0.13u
XNr4_179 or4_179 ir4_179 0 0 sg13_lv_nmos w=0.74u l=0.13u
COr4_179 or4_179 0 2f
VIr4_180 ir4_180 0 0.89500
XPr4_180 or4_180 ir4_180 railr4 railr4 sg13_lv_pmos w=1.12u l=0.13u
XNr4_180 or4_180 ir4_180 0 0 sg13_lv_nmos w=0.74u l=0.13u
COr4_180 or4_180 0 2f
VIr4_181 ir4_181 0 0.90000
XPr4_181 or4_181 ir4_181 railr4 railr4 sg13_lv_pmos w=1.12u l=0.13u
XNr4_181 or4_181 ir4_181 0 0 sg13_lv_nmos w=0.74u l=0.13u
COr4_181 or4_181 0 2f
VIr4_182 ir4_182 0 0.90500
XPr4_182 or4_182 ir4_182 railr4 railr4 sg13_lv_pmos w=1.12u l=0.13u
XNr4_182 or4_182 ir4_182 0 0 sg13_lv_nmos w=0.74u l=0.13u
COr4_182 or4_182 0 2f
VIr4_183 ir4_183 0 0.91000
XPr4_183 or4_183 ir4_183 railr4 railr4 sg13_lv_pmos w=1.12u l=0.13u
XNr4_183 or4_183 ir4_183 0 0 sg13_lv_nmos w=0.74u l=0.13u
COr4_183 or4_183 0 2f
VIr4_184 ir4_184 0 0.91500
XPr4_184 or4_184 ir4_184 railr4 railr4 sg13_lv_pmos w=1.12u l=0.13u
XNr4_184 or4_184 ir4_184 0 0 sg13_lv_nmos w=0.74u l=0.13u
COr4_184 or4_184 0 2f
VIr4_185 ir4_185 0 0.92000
XPr4_185 or4_185 ir4_185 railr4 railr4 sg13_lv_pmos w=1.12u l=0.13u
XNr4_185 or4_185 ir4_185 0 0 sg13_lv_nmos w=0.74u l=0.13u
COr4_185 or4_185 0 2f
VIr4_186 ir4_186 0 0.92500
XPr4_186 or4_186 ir4_186 railr4 railr4 sg13_lv_pmos w=1.12u l=0.13u
XNr4_186 or4_186 ir4_186 0 0 sg13_lv_nmos w=0.74u l=0.13u
COr4_186 or4_186 0 2f
VIr4_187 ir4_187 0 0.93000
XPr4_187 or4_187 ir4_187 railr4 railr4 sg13_lv_pmos w=1.12u l=0.13u
XNr4_187 or4_187 ir4_187 0 0 sg13_lv_nmos w=0.74u l=0.13u
COr4_187 or4_187 0 2f
VIr4_188 ir4_188 0 0.93500
XPr4_188 or4_188 ir4_188 railr4 railr4 sg13_lv_pmos w=1.12u l=0.13u
XNr4_188 or4_188 ir4_188 0 0 sg13_lv_nmos w=0.74u l=0.13u
COr4_188 or4_188 0 2f
VIr4_189 ir4_189 0 0.94000
XPr4_189 or4_189 ir4_189 railr4 railr4 sg13_lv_pmos w=1.12u l=0.13u
XNr4_189 or4_189 ir4_189 0 0 sg13_lv_nmos w=0.74u l=0.13u
COr4_189 or4_189 0 2f
VIr4_190 ir4_190 0 0.94500
XPr4_190 or4_190 ir4_190 railr4 railr4 sg13_lv_pmos w=1.12u l=0.13u
XNr4_190 or4_190 ir4_190 0 0 sg13_lv_nmos w=0.74u l=0.13u
COr4_190 or4_190 0 2f
VIr4_191 ir4_191 0 0.95000
XPr4_191 or4_191 ir4_191 railr4 railr4 sg13_lv_pmos w=1.12u l=0.13u
XNr4_191 or4_191 ir4_191 0 0 sg13_lv_nmos w=0.74u l=0.13u
COr4_191 or4_191 0 2f
VIr4_192 ir4_192 0 0.95500
XPr4_192 or4_192 ir4_192 railr4 railr4 sg13_lv_pmos w=1.12u l=0.13u
XNr4_192 or4_192 ir4_192 0 0 sg13_lv_nmos w=0.74u l=0.13u
COr4_192 or4_192 0 2f
VIr4_193 ir4_193 0 0.96000
XPr4_193 or4_193 ir4_193 railr4 railr4 sg13_lv_pmos w=1.12u l=0.13u
XNr4_193 or4_193 ir4_193 0 0 sg13_lv_nmos w=0.74u l=0.13u
COr4_193 or4_193 0 2f
VIr4_194 ir4_194 0 0.96500
XPr4_194 or4_194 ir4_194 railr4 railr4 sg13_lv_pmos w=1.12u l=0.13u
XNr4_194 or4_194 ir4_194 0 0 sg13_lv_nmos w=0.74u l=0.13u
COr4_194 or4_194 0 2f
VIr4_195 ir4_195 0 0.97000
XPr4_195 or4_195 ir4_195 railr4 railr4 sg13_lv_pmos w=1.12u l=0.13u
XNr4_195 or4_195 ir4_195 0 0 sg13_lv_nmos w=0.74u l=0.13u
COr4_195 or4_195 0 2f
VIr4_196 ir4_196 0 0.97500
XPr4_196 or4_196 ir4_196 railr4 railr4 sg13_lv_pmos w=1.12u l=0.13u
XNr4_196 or4_196 ir4_196 0 0 sg13_lv_nmos w=0.74u l=0.13u
COr4_196 or4_196 0 2f
VIr4_197 ir4_197 0 0.98000
XPr4_197 or4_197 ir4_197 railr4 railr4 sg13_lv_pmos w=1.12u l=0.13u
XNr4_197 or4_197 ir4_197 0 0 sg13_lv_nmos w=0.74u l=0.13u
COr4_197 or4_197 0 2f
VIr4_198 ir4_198 0 0.98500
XPr4_198 or4_198 ir4_198 railr4 railr4 sg13_lv_pmos w=1.12u l=0.13u
XNr4_198 or4_198 ir4_198 0 0 sg13_lv_nmos w=0.74u l=0.13u
COr4_198 or4_198 0 2f
VIr4_199 ir4_199 0 0.99000
XPr4_199 or4_199 ir4_199 railr4 railr4 sg13_lv_pmos w=1.12u l=0.13u
XNr4_199 or4_199 ir4_199 0 0 sg13_lv_nmos w=0.74u l=0.13u
COr4_199 or4_199 0 2f
VIr4_200 ir4_200 0 0.99500
XPr4_200 or4_200 ir4_200 railr4 railr4 sg13_lv_pmos w=1.12u l=0.13u
XNr4_200 or4_200 ir4_200 0 0 sg13_lv_nmos w=0.74u l=0.13u
COr4_200 or4_200 0 2f
VIr4_201 ir4_201 0 1.00000
XPr4_201 or4_201 ir4_201 railr4 railr4 sg13_lv_pmos w=1.12u l=0.13u
XNr4_201 or4_201 ir4_201 0 0 sg13_lv_nmos w=0.74u l=0.13u
COr4_201 or4_201 0 2f
.tran 1n 50n 0 5n
.print tran format=noindex V(or0_001) V(or0_002) V(or0_003) V(or0_004) V(or0_005) V(or0_006) V(or0_007) V(or0_008) V(or0_009) V(or0_010) V(or0_011) V(or0_012) V(or0_013) V(or0_014) V(or0_015) V(or0_016) V(or0_017) V(or0_018) V(or0_019) V(or0_020) V(or0_021) V(or0_022) V(or0_023) V(or0_024) V(or0_025) V(or0_026) V(or0_027) V(or0_028) V(or0_029) V(or0_030) V(or0_031) V(or0_032) V(or0_033) V(or0_034) V(or0_035) V(or0_036) V(or0_037) V(or0_038) V(or0_039) V(or0_040) V(or0_041) V(or0_042) V(or0_043) V(or0_044) V(or0_045) V(or0_046) V(or0_047) V(or0_048) V(or0_049) V(or0_050) V(or0_051) V(or0_052) V(or0_053) V(or0_054) V(or0_055) V(or0_056) V(or0_057) V(or0_058) V(or0_059) V(or0_060) V(or0_061) V(or0_062) V(or0_063) V(or0_064) V(or0_065) V(or0_066) V(or0_067) V(or0_068) V(or0_069) V(or0_070) V(or0_071) V(or0_072) V(or0_073) V(or0_074) V(or0_075) V(or0_076) V(or0_077) V(or0_078) V(or0_079) V(or0_080) V(or0_081) V(or0_082) V(or0_083) V(or0_084) V(or0_085) V(or0_086) V(or0_087) V(or0_088) V(or0_089) V(or0_090) V(or0_091) V(or1_001) V(or1_002) V(or1_003) V(or1_004) V(or1_005) V(or1_006) V(or1_007) V(or1_008) V(or1_009) V(or1_010) V(or1_011) V(or1_012) V(or1_013) V(or1_014) V(or1_015) V(or1_016) V(or1_017) V(or1_018) V(or1_019) V(or1_020) V(or1_021) V(or1_022) V(or1_023) V(or1_024) V(or1_025) V(or1_026) V(or1_027) V(or1_028) V(or1_029) V(or1_030) V(or1_031) V(or1_032) V(or1_033) V(or1_034) V(or1_035) V(or1_036) V(or1_037) V(or1_038) V(or1_039) V(or1_040) V(or1_041) V(or1_042) V(or1_043) V(or1_044) V(or1_045) V(or1_046) V(or1_047) V(or1_048) V(or1_049) V(or1_050) V(or1_051) V(or1_052) V(or1_053) V(or1_054) V(or1_055) V(or1_056) V(or1_057) V(or1_058) V(or1_059) V(or1_060) V(or1_061) V(or1_062) V(or1_063) V(or1_064) V(or1_065) V(or1_066) V(or1_067) V(or1_068) V(or1_069) V(or1_070) V(or1_071) V(or1_072) V(or1_073) V(or1_074) V(or1_075) V(or1_076) V(or1_077) V(or1_078) V(or1_079) V(or1_080) V(or1_081) V(or1_082) V(or1_083) V(or1_084) V(or1_085) V(or1_086) V(or1_087) V(or1_088) V(or1_089) V(or1_090) V(or1_091) V(or1_092) V(or1_093) V(or1_094) V(or1_095) V(or1_096) V(or1_097) V(or1_098) V(or1_099) V(or1_100) V(or1_101) V(or1_102) V(or1_103) V(or1_104) V(or1_105) V(or1_106) V(or1_107) V(or1_108) V(or1_109) V(or1_110) V(or1_111) V(or1_112) V(or2_001) V(or2_002) V(or2_003) V(or2_004) V(or2_005) V(or2_006) V(or2_007) V(or2_008) V(or2_009) V(or2_010) V(or2_011) V(or2_012) V(or2_013) V(or2_014) V(or2_015) V(or2_016) V(or2_017) V(or2_018) V(or2_019) V(or2_020) V(or2_021) V(or2_022) V(or2_023) V(or2_024) V(or2_025) V(or2_026) V(or2_027) V(or2_028) V(or2_029) V(or2_030) V(or2_031) V(or2_032) V(or2_033) V(or2_034) V(or2_035) V(or2_036) V(or2_037) V(or2_038) V(or2_039) V(or2_040) V(or2_041) V(or2_042) V(or2_043) V(or2_044) V(or2_045) V(or2_046) V(or2_047) V(or2_048) V(or2_049) V(or2_050) V(or2_051) V(or2_052) V(or2_053) V(or2_054) V(or2_055) V(or2_056) V(or2_057) V(or2_058) V(or2_059) V(or2_060) V(or2_061) V(or2_062) V(or2_063) V(or2_064) V(or2_065) V(or2_066) V(or2_067) V(or2_068) V(or2_069) V(or2_070) V(or2_071) V(or2_072) V(or2_073) V(or2_074) V(or2_075) V(or2_076) V(or2_077) V(or2_078) V(or2_079) V(or2_080) V(or2_081) V(or2_082) V(or2_083) V(or2_084) V(or2_085) V(or2_086) V(or2_087) V(or2_088) V(or2_089) V(or2_090) V(or2_091) V(or2_092) V(or2_093) V(or2_094) V(or2_095) V(or2_096) V(or2_097) V(or2_098) V(or2_099) V(or2_100) V(or2_101) V(or2_102) V(or2_103) V(or2_104) V(or2_105) V(or2_106) V(or2_107) V(or2_108) V(or2_109) V(or2_110) V(or2_111) V(or2_112) V(or2_113) V(or2_114) V(or2_115) V(or2_116) V(or2_117) V(or2_118) V(or2_119) V(or2_120) V(or2_121) V(or2_122) V(or3_001) V(or3_002) V(or3_003) V(or3_004) V(or3_005) V(or3_006) V(or3_007) V(or3_008) V(or3_009) V(or3_010) V(or3_011) V(or3_012) V(or3_013) V(or3_014) V(or3_015) V(or3_016) V(or3_017) V(or3_018) V(or3_019) V(or3_020) V(or3_021) V(or3_022) V(or3_023) V(or3_024) V(or3_025) V(or3_026) V(or3_027) V(or3_028) V(or3_029) V(or3_030) V(or3_031) V(or3_032) V(or3_033) V(or3_034) V(or3_035) V(or3_036) V(or3_037) V(or3_038) V(or3_039) V(or3_040) V(or3_041) V(or3_042) V(or3_043) V(or3_044) V(or3_045) V(or3_046) V(or3_047) V(or3_048) V(or3_049) V(or3_050) V(or3_051) V(or3_052) V(or3_053) V(or3_054) V(or3_055) V(or3_056) V(or3_057) V(or3_058) V(or3_059) V(or3_060) V(or3_061) V(or3_062) V(or3_063) V(or3_064) V(or3_065) V(or3_066) V(or3_067) V(or3_068) V(or3_069) V(or3_070) V(or3_071) V(or3_072) V(or3_073) V(or3_074) V(or3_075) V(or3_076) V(or3_077) V(or3_078) V(or3_079) V(or3_080) V(or3_081) V(or3_082) V(or3_083) V(or3_084) V(or3_085) V(or3_086) V(or3_087) V(or3_088) V(or3_089) V(or3_090) V(or3_091) V(or3_092) V(or3_093) V(or3_094) V(or3_095) V(or3_096) V(or3_097) V(or3_098) V(or3_099) V(or3_100) V(or3_101) V(or3_102) V(or3_103) V(or3_104) V(or3_105) V(or3_106) V(or3_107) V(or3_108) V(or3_109) V(or3_110) V(or3_111) V(or3_112) V(or3_113) V(or3_114) V(or3_115) V(or3_116) V(or3_117) V(or3_118) V(or3_119) V(or3_120) V(or3_121) V(or3_122) V(or3_123) V(or3_124) V(or3_125) V(or3_126) V(or3_127) V(or3_128) V(or3_129) V(or3_130) V(or3_131) V(or3_132) V(or3_133) V(or3_134) V(or3_135) V(or3_136) V(or3_137) V(or3_138) V(or3_139) V(or3_140) V(or3_141) V(or4_001) V(or4_002) V(or4_003) V(or4_004) V(or4_005) V(or4_006) V(or4_007) V(or4_008) V(or4_009) V(or4_010) V(or4_011) V(or4_012) V(or4_013) V(or4_014) V(or4_015) V(or4_016) V(or4_017) V(or4_018) V(or4_019) V(or4_020) V(or4_021) V(or4_022) V(or4_023) V(or4_024) V(or4_025) V(or4_026) V(or4_027) V(or4_028) V(or4_029) V(or4_030) V(or4_031) V(or4_032) V(or4_033) V(or4_034) V(or4_035) V(or4_036) V(or4_037) V(or4_038) V(or4_039) V(or4_040) V(or4_041) V(or4_042) V(or4_043) V(or4_044) V(or4_045) V(or4_046) V(or4_047) V(or4_048) V(or4_049) V(or4_050) V(or4_051) V(or4_052) V(or4_053) V(or4_054) V(or4_055) V(or4_056) V(or4_057) V(or4_058) V(or4_059) V(or4_060) V(or4_061) V(or4_062) V(or4_063) V(or4_064) V(or4_065) V(or4_066) V(or4_067) V(or4_068) V(or4_069) V(or4_070) V(or4_071) V(or4_072) V(or4_073) V(or4_074) V(or4_075) V(or4_076) V(or4_077) V(or4_078) V(or4_079) V(or4_080) V(or4_081) V(or4_082) V(or4_083) V(or4_084) V(or4_085) V(or4_086) V(or4_087) V(or4_088) V(or4_089) V(or4_090) V(or4_091) V(or4_092) V(or4_093) V(or4_094) V(or4_095) V(or4_096) V(or4_097) V(or4_098) V(or4_099) V(or4_100) V(or4_101) V(or4_102) V(or4_103) V(or4_104) V(or4_105) V(or4_106) V(or4_107) V(or4_108) V(or4_109) V(or4_110) V(or4_111) V(or4_112) V(or4_113) V(or4_114) V(or4_115) V(or4_116) V(or4_117) V(or4_118) V(or4_119) V(or4_120) V(or4_121) V(or4_122) V(or4_123) V(or4_124) V(or4_125) V(or4_126) V(or4_127) V(or4_128) V(or4_129) V(or4_130) V(or4_131) V(or4_132) V(or4_133) V(or4_134) V(or4_135) V(or4_136) V(or4_137) V(or4_138) V(or4_139) V(or4_140) V(or4_141) V(or4_142) V(or4_143) V(or4_144) V(or4_145) V(or4_146) V(or4_147) V(or4_148) V(or4_149) V(or4_150) V(or4_151) V(or4_152) V(or4_153) V(or4_154) V(or4_155) V(or4_156) V(or4_157) V(or4_158) V(or4_159) V(or4_160) V(or4_161) V(or4_162) V(or4_163) V(or4_164) V(or4_165) V(or4_166) V(or4_167) V(or4_168) V(or4_169) V(or4_170) V(or4_171) V(or4_172) V(or4_173) V(or4_174) V(or4_175) V(or4_176) V(or4_177) V(or4_178) V(or4_179) V(or4_180) V(or4_181) V(or4_182) V(or4_183) V(or4_184) V(or4_185) V(or4_186) V(or4_187) V(or4_188) V(or4_189) V(or4_190) V(or4_191) V(or4_192) V(or4_193) V(or4_194) V(or4_195) V(or4_196) V(or4_197) V(or4_198) V(or4_199) V(or4_200) V(or4_201)
.end
