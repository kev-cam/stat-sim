* SKEPT Vt deck: Id = 100 nA * W/L at |Vds| = 0.1 V
.hdl "/usr/local/share/xyce/verilog-a/psp103/psp103.va"
.include "/usr/local/src/kestrel/sim/models/sg13g2_psp103_tt.lib"
.include "/usr/local/src/stat-sim/qal/sg13lv_compat.sp"
.OPTIONS TIMEINT METHOD=GEAR RELTOL=1e-6 ABSTOL=1e-16 CHGTOL=1e-18
VGn001 gn001 0 0.3000
VDn001 dn001 0 0.1000
Xn001 dn001 gn001 0 0 sg13_lv_nmos w=0.74u l=0.13u
VGn002 gn002 0 0.3050
VDn002 dn002 0 0.1000
Xn002 dn002 gn002 0 0 sg13_lv_nmos w=0.74u l=0.13u
VGn003 gn003 0 0.3100
VDn003 dn003 0 0.1000
Xn003 dn003 gn003 0 0 sg13_lv_nmos w=0.74u l=0.13u
VGn004 gn004 0 0.3150
VDn004 dn004 0 0.1000
Xn004 dn004 gn004 0 0 sg13_lv_nmos w=0.74u l=0.13u
VGn005 gn005 0 0.3200
VDn005 dn005 0 0.1000
Xn005 dn005 gn005 0 0 sg13_lv_nmos w=0.74u l=0.13u
VGn006 gn006 0 0.3250
VDn006 dn006 0 0.1000
Xn006 dn006 gn006 0 0 sg13_lv_nmos w=0.74u l=0.13u
VGn007 gn007 0 0.3300
VDn007 dn007 0 0.1000
Xn007 dn007 gn007 0 0 sg13_lv_nmos w=0.74u l=0.13u
VGn008 gn008 0 0.3350
VDn008 dn008 0 0.1000
Xn008 dn008 gn008 0 0 sg13_lv_nmos w=0.74u l=0.13u
VGn009 gn009 0 0.3400
VDn009 dn009 0 0.1000
Xn009 dn009 gn009 0 0 sg13_lv_nmos w=0.74u l=0.13u
VGn010 gn010 0 0.3450
VDn010 dn010 0 0.1000
Xn010 dn010 gn010 0 0 sg13_lv_nmos w=0.74u l=0.13u
VGn011 gn011 0 0.3500
VDn011 dn011 0 0.1000
Xn011 dn011 gn011 0 0 sg13_lv_nmos w=0.74u l=0.13u
VGn012 gn012 0 0.3550
VDn012 dn012 0 0.1000
Xn012 dn012 gn012 0 0 sg13_lv_nmos w=0.74u l=0.13u
VGn013 gn013 0 0.3600
VDn013 dn013 0 0.1000
Xn013 dn013 gn013 0 0 sg13_lv_nmos w=0.74u l=0.13u
VGn014 gn014 0 0.3650
VDn014 dn014 0 0.1000
Xn014 dn014 gn014 0 0 sg13_lv_nmos w=0.74u l=0.13u
VGn015 gn015 0 0.3700
VDn015 dn015 0 0.1000
Xn015 dn015 gn015 0 0 sg13_lv_nmos w=0.74u l=0.13u
VGn016 gn016 0 0.3750
VDn016 dn016 0 0.1000
Xn016 dn016 gn016 0 0 sg13_lv_nmos w=0.74u l=0.13u
VGn017 gn017 0 0.3800
VDn017 dn017 0 0.1000
Xn017 dn017 gn017 0 0 sg13_lv_nmos w=0.74u l=0.13u
VGn018 gn018 0 0.3850
VDn018 dn018 0 0.1000
Xn018 dn018 gn018 0 0 sg13_lv_nmos w=0.74u l=0.13u
VGn019 gn019 0 0.3900
VDn019 dn019 0 0.1000
Xn019 dn019 gn019 0 0 sg13_lv_nmos w=0.74u l=0.13u
VGn020 gn020 0 0.3950
VDn020 dn020 0 0.1000
Xn020 dn020 gn020 0 0 sg13_lv_nmos w=0.74u l=0.13u
VGn021 gn021 0 0.4000
VDn021 dn021 0 0.1000
Xn021 dn021 gn021 0 0 sg13_lv_nmos w=0.74u l=0.13u
VGn022 gn022 0 0.4050
VDn022 dn022 0 0.1000
Xn022 dn022 gn022 0 0 sg13_lv_nmos w=0.74u l=0.13u
VGn023 gn023 0 0.4100
VDn023 dn023 0 0.1000
Xn023 dn023 gn023 0 0 sg13_lv_nmos w=0.74u l=0.13u
VGn024 gn024 0 0.4150
VDn024 dn024 0 0.1000
Xn024 dn024 gn024 0 0 sg13_lv_nmos w=0.74u l=0.13u
VGn025 gn025 0 0.4200
VDn025 dn025 0 0.1000
Xn025 dn025 gn025 0 0 sg13_lv_nmos w=0.74u l=0.13u
VGn026 gn026 0 0.4250
VDn026 dn026 0 0.1000
Xn026 dn026 gn026 0 0 sg13_lv_nmos w=0.74u l=0.13u
VGn027 gn027 0 0.4300
VDn027 dn027 0 0.1000
Xn027 dn027 gn027 0 0 sg13_lv_nmos w=0.74u l=0.13u
VGn028 gn028 0 0.4350
VDn028 dn028 0 0.1000
Xn028 dn028 gn028 0 0 sg13_lv_nmos w=0.74u l=0.13u
VGn029 gn029 0 0.4400
VDn029 dn029 0 0.1000
Xn029 dn029 gn029 0 0 sg13_lv_nmos w=0.74u l=0.13u
VGn030 gn030 0 0.4450
VDn030 dn030 0 0.1000
Xn030 dn030 gn030 0 0 sg13_lv_nmos w=0.74u l=0.13u
VGn031 gn031 0 0.4500
VDn031 dn031 0 0.1000
Xn031 dn031 gn031 0 0 sg13_lv_nmos w=0.74u l=0.13u
VGn032 gn032 0 0.4550
VDn032 dn032 0 0.1000
Xn032 dn032 gn032 0 0 sg13_lv_nmos w=0.74u l=0.13u
VGn033 gn033 0 0.4600
VDn033 dn033 0 0.1000
Xn033 dn033 gn033 0 0 sg13_lv_nmos w=0.74u l=0.13u
VGn034 gn034 0 0.4650
VDn034 dn034 0 0.1000
Xn034 dn034 gn034 0 0 sg13_lv_nmos w=0.74u l=0.13u
VGn035 gn035 0 0.4700
VDn035 dn035 0 0.1000
Xn035 dn035 gn035 0 0 sg13_lv_nmos w=0.74u l=0.13u
VGn036 gn036 0 0.4750
VDn036 dn036 0 0.1000
Xn036 dn036 gn036 0 0 sg13_lv_nmos w=0.74u l=0.13u
VGn037 gn037 0 0.4800
VDn037 dn037 0 0.1000
Xn037 dn037 gn037 0 0 sg13_lv_nmos w=0.74u l=0.13u
VGn038 gn038 0 0.4850
VDn038 dn038 0 0.1000
Xn038 dn038 gn038 0 0 sg13_lv_nmos w=0.74u l=0.13u
VGn039 gn039 0 0.4900
VDn039 dn039 0 0.1000
Xn039 dn039 gn039 0 0 sg13_lv_nmos w=0.74u l=0.13u
VGn040 gn040 0 0.4950
VDn040 dn040 0 0.1000
Xn040 dn040 gn040 0 0 sg13_lv_nmos w=0.74u l=0.13u
VGn041 gn041 0 0.5000
VDn041 dn041 0 0.1000
Xn041 dn041 gn041 0 0 sg13_lv_nmos w=0.74u l=0.13u
VGn042 gn042 0 0.5050
VDn042 dn042 0 0.1000
Xn042 dn042 gn042 0 0 sg13_lv_nmos w=0.74u l=0.13u
VGn043 gn043 0 0.5100
VDn043 dn043 0 0.1000
Xn043 dn043 gn043 0 0 sg13_lv_nmos w=0.74u l=0.13u
VGn044 gn044 0 0.5150
VDn044 dn044 0 0.1000
Xn044 dn044 gn044 0 0 sg13_lv_nmos w=0.74u l=0.13u
VGn045 gn045 0 0.5200
VDn045 dn045 0 0.1000
Xn045 dn045 gn045 0 0 sg13_lv_nmos w=0.74u l=0.13u
VGn046 gn046 0 0.5250
VDn046 dn046 0 0.1000
Xn046 dn046 gn046 0 0 sg13_lv_nmos w=0.74u l=0.13u
VGn047 gn047 0 0.5300
VDn047 dn047 0 0.1000
Xn047 dn047 gn047 0 0 sg13_lv_nmos w=0.74u l=0.13u
VGn048 gn048 0 0.5350
VDn048 dn048 0 0.1000
Xn048 dn048 gn048 0 0 sg13_lv_nmos w=0.74u l=0.13u
VGn049 gn049 0 0.5400
VDn049 dn049 0 0.1000
Xn049 dn049 gn049 0 0 sg13_lv_nmos w=0.74u l=0.13u
VGn050 gn050 0 0.5450
VDn050 dn050 0 0.1000
Xn050 dn050 gn050 0 0 sg13_lv_nmos w=0.74u l=0.13u
VGn051 gn051 0 0.5500
VDn051 dn051 0 0.1000
Xn051 dn051 gn051 0 0 sg13_lv_nmos w=0.74u l=0.13u
VGn052 gn052 0 0.5550
VDn052 dn052 0 0.1000
Xn052 dn052 gn052 0 0 sg13_lv_nmos w=0.74u l=0.13u
VGn053 gn053 0 0.5600
VDn053 dn053 0 0.1000
Xn053 dn053 gn053 0 0 sg13_lv_nmos w=0.74u l=0.13u
VGn054 gn054 0 0.5650
VDn054 dn054 0 0.1000
Xn054 dn054 gn054 0 0 sg13_lv_nmos w=0.74u l=0.13u
VGn055 gn055 0 0.5700
VDn055 dn055 0 0.1000
Xn055 dn055 gn055 0 0 sg13_lv_nmos w=0.74u l=0.13u
VGn056 gn056 0 0.5750
VDn056 dn056 0 0.1000
Xn056 dn056 gn056 0 0 sg13_lv_nmos w=0.74u l=0.13u
VGn057 gn057 0 0.5800
VDn057 dn057 0 0.1000
Xn057 dn057 gn057 0 0 sg13_lv_nmos w=0.74u l=0.13u
VGn058 gn058 0 0.5850
VDn058 dn058 0 0.1000
Xn058 dn058 gn058 0 0 sg13_lv_nmos w=0.74u l=0.13u
VGn059 gn059 0 0.5900
VDn059 dn059 0 0.1000
Xn059 dn059 gn059 0 0 sg13_lv_nmos w=0.74u l=0.13u
VGn060 gn060 0 0.5950
VDn060 dn060 0 0.1000
Xn060 dn060 gn060 0 0 sg13_lv_nmos w=0.74u l=0.13u
VGn061 gn061 0 0.6000
VDn061 dn061 0 0.1000
Xn061 dn061 gn061 0 0 sg13_lv_nmos w=0.74u l=0.13u
VGn062 gn062 0 0.6050
VDn062 dn062 0 0.1000
Xn062 dn062 gn062 0 0 sg13_lv_nmos w=0.74u l=0.13u
VGn063 gn063 0 0.6100
VDn063 dn063 0 0.1000
Xn063 dn063 gn063 0 0 sg13_lv_nmos w=0.74u l=0.13u
VGn064 gn064 0 0.6150
VDn064 dn064 0 0.1000
Xn064 dn064 gn064 0 0 sg13_lv_nmos w=0.74u l=0.13u
VGn065 gn065 0 0.6200
VDn065 dn065 0 0.1000
Xn065 dn065 gn065 0 0 sg13_lv_nmos w=0.74u l=0.13u
VGn066 gn066 0 0.6250
VDn066 dn066 0 0.1000
Xn066 dn066 gn066 0 0 sg13_lv_nmos w=0.74u l=0.13u
VGn067 gn067 0 0.6300
VDn067 dn067 0 0.1000
Xn067 dn067 gn067 0 0 sg13_lv_nmos w=0.74u l=0.13u
VGn068 gn068 0 0.6350
VDn068 dn068 0 0.1000
Xn068 dn068 gn068 0 0 sg13_lv_nmos w=0.74u l=0.13u
VGn069 gn069 0 0.6400
VDn069 dn069 0 0.1000
Xn069 dn069 gn069 0 0 sg13_lv_nmos w=0.74u l=0.13u
VGn070 gn070 0 0.6450
VDn070 dn070 0 0.1000
Xn070 dn070 gn070 0 0 sg13_lv_nmos w=0.74u l=0.13u
VGn071 gn071 0 0.6500
VDn071 dn071 0 0.1000
Xn071 dn071 gn071 0 0 sg13_lv_nmos w=0.74u l=0.13u
VGn072 gn072 0 0.6550
VDn072 dn072 0 0.1000
Xn072 dn072 gn072 0 0 sg13_lv_nmos w=0.74u l=0.13u
VGn073 gn073 0 0.6600
VDn073 dn073 0 0.1000
Xn073 dn073 gn073 0 0 sg13_lv_nmos w=0.74u l=0.13u
VGn074 gn074 0 0.6650
VDn074 dn074 0 0.1000
Xn074 dn074 gn074 0 0 sg13_lv_nmos w=0.74u l=0.13u
VGn075 gn075 0 0.6700
VDn075 dn075 0 0.1000
Xn075 dn075 gn075 0 0 sg13_lv_nmos w=0.74u l=0.13u
VGn076 gn076 0 0.6750
VDn076 dn076 0 0.1000
Xn076 dn076 gn076 0 0 sg13_lv_nmos w=0.74u l=0.13u
VGn077 gn077 0 0.6800
VDn077 dn077 0 0.1000
Xn077 dn077 gn077 0 0 sg13_lv_nmos w=0.74u l=0.13u
VGn078 gn078 0 0.6850
VDn078 dn078 0 0.1000
Xn078 dn078 gn078 0 0 sg13_lv_nmos w=0.74u l=0.13u
VGn079 gn079 0 0.6900
VDn079 dn079 0 0.1000
Xn079 dn079 gn079 0 0 sg13_lv_nmos w=0.74u l=0.13u
VGn080 gn080 0 0.6950
VDn080 dn080 0 0.1000
Xn080 dn080 gn080 0 0 sg13_lv_nmos w=0.74u l=0.13u
VGn081 gn081 0 0.7000
VDn081 dn081 0 0.1000
Xn081 dn081 gn081 0 0 sg13_lv_nmos w=0.74u l=0.13u
VGn082 gn082 0 0.7050
VDn082 dn082 0 0.1000
Xn082 dn082 gn082 0 0 sg13_lv_nmos w=0.74u l=0.13u
VGn083 gn083 0 0.7100
VDn083 dn083 0 0.1000
Xn083 dn083 gn083 0 0 sg13_lv_nmos w=0.74u l=0.13u
VGn084 gn084 0 0.7150
VDn084 dn084 0 0.1000
Xn084 dn084 gn084 0 0 sg13_lv_nmos w=0.74u l=0.13u
VGn085 gn085 0 0.7200
VDn085 dn085 0 0.1000
Xn085 dn085 gn085 0 0 sg13_lv_nmos w=0.74u l=0.13u
VGn086 gn086 0 0.7250
VDn086 dn086 0 0.1000
Xn086 dn086 gn086 0 0 sg13_lv_nmos w=0.74u l=0.13u
VGn087 gn087 0 0.7300
VDn087 dn087 0 0.1000
Xn087 dn087 gn087 0 0 sg13_lv_nmos w=0.74u l=0.13u
VGn088 gn088 0 0.7350
VDn088 dn088 0 0.1000
Xn088 dn088 gn088 0 0 sg13_lv_nmos w=0.74u l=0.13u
VGn089 gn089 0 0.7400
VDn089 dn089 0 0.1000
Xn089 dn089 gn089 0 0 sg13_lv_nmos w=0.74u l=0.13u
VGn090 gn090 0 0.7450
VDn090 dn090 0 0.1000
Xn090 dn090 gn090 0 0 sg13_lv_nmos w=0.74u l=0.13u
VGn091 gn091 0 0.7500
VDn091 dn091 0 0.1000
Xn091 dn091 gn091 0 0 sg13_lv_nmos w=0.74u l=0.13u
VGp001 gp001 0 -0.3000
VDp001 dp001 0 -0.1000
Xp001 dp001 gp001 0 0 sg13_lv_pmos w=1.12u l=0.13u
VGp002 gp002 0 -0.3050
VDp002 dp002 0 -0.1000
Xp002 dp002 gp002 0 0 sg13_lv_pmos w=1.12u l=0.13u
VGp003 gp003 0 -0.3100
VDp003 dp003 0 -0.1000
Xp003 dp003 gp003 0 0 sg13_lv_pmos w=1.12u l=0.13u
VGp004 gp004 0 -0.3150
VDp004 dp004 0 -0.1000
Xp004 dp004 gp004 0 0 sg13_lv_pmos w=1.12u l=0.13u
VGp005 gp005 0 -0.3200
VDp005 dp005 0 -0.1000
Xp005 dp005 gp005 0 0 sg13_lv_pmos w=1.12u l=0.13u
VGp006 gp006 0 -0.3250
VDp006 dp006 0 -0.1000
Xp006 dp006 gp006 0 0 sg13_lv_pmos w=1.12u l=0.13u
VGp007 gp007 0 -0.3300
VDp007 dp007 0 -0.1000
Xp007 dp007 gp007 0 0 sg13_lv_pmos w=1.12u l=0.13u
VGp008 gp008 0 -0.3350
VDp008 dp008 0 -0.1000
Xp008 dp008 gp008 0 0 sg13_lv_pmos w=1.12u l=0.13u
VGp009 gp009 0 -0.3400
VDp009 dp009 0 -0.1000
Xp009 dp009 gp009 0 0 sg13_lv_pmos w=1.12u l=0.13u
VGp010 gp010 0 -0.3450
VDp010 dp010 0 -0.1000
Xp010 dp010 gp010 0 0 sg13_lv_pmos w=1.12u l=0.13u
VGp011 gp011 0 -0.3500
VDp011 dp011 0 -0.1000
Xp011 dp011 gp011 0 0 sg13_lv_pmos w=1.12u l=0.13u
VGp012 gp012 0 -0.3550
VDp012 dp012 0 -0.1000
Xp012 dp012 gp012 0 0 sg13_lv_pmos w=1.12u l=0.13u
VGp013 gp013 0 -0.3600
VDp013 dp013 0 -0.1000
Xp013 dp013 gp013 0 0 sg13_lv_pmos w=1.12u l=0.13u
VGp014 gp014 0 -0.3650
VDp014 dp014 0 -0.1000
Xp014 dp014 gp014 0 0 sg13_lv_pmos w=1.12u l=0.13u
VGp015 gp015 0 -0.3700
VDp015 dp015 0 -0.1000
Xp015 dp015 gp015 0 0 sg13_lv_pmos w=1.12u l=0.13u
VGp016 gp016 0 -0.3750
VDp016 dp016 0 -0.1000
Xp016 dp016 gp016 0 0 sg13_lv_pmos w=1.12u l=0.13u
VGp017 gp017 0 -0.3800
VDp017 dp017 0 -0.1000
Xp017 dp017 gp017 0 0 sg13_lv_pmos w=1.12u l=0.13u
VGp018 gp018 0 -0.3850
VDp018 dp018 0 -0.1000
Xp018 dp018 gp018 0 0 sg13_lv_pmos w=1.12u l=0.13u
VGp019 gp019 0 -0.3900
VDp019 dp019 0 -0.1000
Xp019 dp019 gp019 0 0 sg13_lv_pmos w=1.12u l=0.13u
VGp020 gp020 0 -0.3950
VDp020 dp020 0 -0.1000
Xp020 dp020 gp020 0 0 sg13_lv_pmos w=1.12u l=0.13u
VGp021 gp021 0 -0.4000
VDp021 dp021 0 -0.1000
Xp021 dp021 gp021 0 0 sg13_lv_pmos w=1.12u l=0.13u
VGp022 gp022 0 -0.4050
VDp022 dp022 0 -0.1000
Xp022 dp022 gp022 0 0 sg13_lv_pmos w=1.12u l=0.13u
VGp023 gp023 0 -0.4100
VDp023 dp023 0 -0.1000
Xp023 dp023 gp023 0 0 sg13_lv_pmos w=1.12u l=0.13u
VGp024 gp024 0 -0.4150
VDp024 dp024 0 -0.1000
Xp024 dp024 gp024 0 0 sg13_lv_pmos w=1.12u l=0.13u
VGp025 gp025 0 -0.4200
VDp025 dp025 0 -0.1000
Xp025 dp025 gp025 0 0 sg13_lv_pmos w=1.12u l=0.13u
VGp026 gp026 0 -0.4250
VDp026 dp026 0 -0.1000
Xp026 dp026 gp026 0 0 sg13_lv_pmos w=1.12u l=0.13u
VGp027 gp027 0 -0.4300
VDp027 dp027 0 -0.1000
Xp027 dp027 gp027 0 0 sg13_lv_pmos w=1.12u l=0.13u
VGp028 gp028 0 -0.4350
VDp028 dp028 0 -0.1000
Xp028 dp028 gp028 0 0 sg13_lv_pmos w=1.12u l=0.13u
VGp029 gp029 0 -0.4400
VDp029 dp029 0 -0.1000
Xp029 dp029 gp029 0 0 sg13_lv_pmos w=1.12u l=0.13u
VGp030 gp030 0 -0.4450
VDp030 dp030 0 -0.1000
Xp030 dp030 gp030 0 0 sg13_lv_pmos w=1.12u l=0.13u
VGp031 gp031 0 -0.4500
VDp031 dp031 0 -0.1000
Xp031 dp031 gp031 0 0 sg13_lv_pmos w=1.12u l=0.13u
VGp032 gp032 0 -0.4550
VDp032 dp032 0 -0.1000
Xp032 dp032 gp032 0 0 sg13_lv_pmos w=1.12u l=0.13u
VGp033 gp033 0 -0.4600
VDp033 dp033 0 -0.1000
Xp033 dp033 gp033 0 0 sg13_lv_pmos w=1.12u l=0.13u
VGp034 gp034 0 -0.4650
VDp034 dp034 0 -0.1000
Xp034 dp034 gp034 0 0 sg13_lv_pmos w=1.12u l=0.13u
VGp035 gp035 0 -0.4700
VDp035 dp035 0 -0.1000
Xp035 dp035 gp035 0 0 sg13_lv_pmos w=1.12u l=0.13u
VGp036 gp036 0 -0.4750
VDp036 dp036 0 -0.1000
Xp036 dp036 gp036 0 0 sg13_lv_pmos w=1.12u l=0.13u
VGp037 gp037 0 -0.4800
VDp037 dp037 0 -0.1000
Xp037 dp037 gp037 0 0 sg13_lv_pmos w=1.12u l=0.13u
VGp038 gp038 0 -0.4850
VDp038 dp038 0 -0.1000
Xp038 dp038 gp038 0 0 sg13_lv_pmos w=1.12u l=0.13u
VGp039 gp039 0 -0.4900
VDp039 dp039 0 -0.1000
Xp039 dp039 gp039 0 0 sg13_lv_pmos w=1.12u l=0.13u
VGp040 gp040 0 -0.4950
VDp040 dp040 0 -0.1000
Xp040 dp040 gp040 0 0 sg13_lv_pmos w=1.12u l=0.13u
VGp041 gp041 0 -0.5000
VDp041 dp041 0 -0.1000
Xp041 dp041 gp041 0 0 sg13_lv_pmos w=1.12u l=0.13u
VGp042 gp042 0 -0.5050
VDp042 dp042 0 -0.1000
Xp042 dp042 gp042 0 0 sg13_lv_pmos w=1.12u l=0.13u
VGp043 gp043 0 -0.5100
VDp043 dp043 0 -0.1000
Xp043 dp043 gp043 0 0 sg13_lv_pmos w=1.12u l=0.13u
VGp044 gp044 0 -0.5150
VDp044 dp044 0 -0.1000
Xp044 dp044 gp044 0 0 sg13_lv_pmos w=1.12u l=0.13u
VGp045 gp045 0 -0.5200
VDp045 dp045 0 -0.1000
Xp045 dp045 gp045 0 0 sg13_lv_pmos w=1.12u l=0.13u
VGp046 gp046 0 -0.5250
VDp046 dp046 0 -0.1000
Xp046 dp046 gp046 0 0 sg13_lv_pmos w=1.12u l=0.13u
VGp047 gp047 0 -0.5300
VDp047 dp047 0 -0.1000
Xp047 dp047 gp047 0 0 sg13_lv_pmos w=1.12u l=0.13u
VGp048 gp048 0 -0.5350
VDp048 dp048 0 -0.1000
Xp048 dp048 gp048 0 0 sg13_lv_pmos w=1.12u l=0.13u
VGp049 gp049 0 -0.5400
VDp049 dp049 0 -0.1000
Xp049 dp049 gp049 0 0 sg13_lv_pmos w=1.12u l=0.13u
VGp050 gp050 0 -0.5450
VDp050 dp050 0 -0.1000
Xp050 dp050 gp050 0 0 sg13_lv_pmos w=1.12u l=0.13u
VGp051 gp051 0 -0.5500
VDp051 dp051 0 -0.1000
Xp051 dp051 gp051 0 0 sg13_lv_pmos w=1.12u l=0.13u
VGp052 gp052 0 -0.5550
VDp052 dp052 0 -0.1000
Xp052 dp052 gp052 0 0 sg13_lv_pmos w=1.12u l=0.13u
VGp053 gp053 0 -0.5600
VDp053 dp053 0 -0.1000
Xp053 dp053 gp053 0 0 sg13_lv_pmos w=1.12u l=0.13u
VGp054 gp054 0 -0.5650
VDp054 dp054 0 -0.1000
Xp054 dp054 gp054 0 0 sg13_lv_pmos w=1.12u l=0.13u
VGp055 gp055 0 -0.5700
VDp055 dp055 0 -0.1000
Xp055 dp055 gp055 0 0 sg13_lv_pmos w=1.12u l=0.13u
VGp056 gp056 0 -0.5750
VDp056 dp056 0 -0.1000
Xp056 dp056 gp056 0 0 sg13_lv_pmos w=1.12u l=0.13u
VGp057 gp057 0 -0.5800
VDp057 dp057 0 -0.1000
Xp057 dp057 gp057 0 0 sg13_lv_pmos w=1.12u l=0.13u
VGp058 gp058 0 -0.5850
VDp058 dp058 0 -0.1000
Xp058 dp058 gp058 0 0 sg13_lv_pmos w=1.12u l=0.13u
VGp059 gp059 0 -0.5900
VDp059 dp059 0 -0.1000
Xp059 dp059 gp059 0 0 sg13_lv_pmos w=1.12u l=0.13u
VGp060 gp060 0 -0.5950
VDp060 dp060 0 -0.1000
Xp060 dp060 gp060 0 0 sg13_lv_pmos w=1.12u l=0.13u
VGp061 gp061 0 -0.6000
VDp061 dp061 0 -0.1000
Xp061 dp061 gp061 0 0 sg13_lv_pmos w=1.12u l=0.13u
VGp062 gp062 0 -0.6050
VDp062 dp062 0 -0.1000
Xp062 dp062 gp062 0 0 sg13_lv_pmos w=1.12u l=0.13u
VGp063 gp063 0 -0.6100
VDp063 dp063 0 -0.1000
Xp063 dp063 gp063 0 0 sg13_lv_pmos w=1.12u l=0.13u
VGp064 gp064 0 -0.6150
VDp064 dp064 0 -0.1000
Xp064 dp064 gp064 0 0 sg13_lv_pmos w=1.12u l=0.13u
VGp065 gp065 0 -0.6200
VDp065 dp065 0 -0.1000
Xp065 dp065 gp065 0 0 sg13_lv_pmos w=1.12u l=0.13u
VGp066 gp066 0 -0.6250
VDp066 dp066 0 -0.1000
Xp066 dp066 gp066 0 0 sg13_lv_pmos w=1.12u l=0.13u
VGp067 gp067 0 -0.6300
VDp067 dp067 0 -0.1000
Xp067 dp067 gp067 0 0 sg13_lv_pmos w=1.12u l=0.13u
VGp068 gp068 0 -0.6350
VDp068 dp068 0 -0.1000
Xp068 dp068 gp068 0 0 sg13_lv_pmos w=1.12u l=0.13u
VGp069 gp069 0 -0.6400
VDp069 dp069 0 -0.1000
Xp069 dp069 gp069 0 0 sg13_lv_pmos w=1.12u l=0.13u
VGp070 gp070 0 -0.6450
VDp070 dp070 0 -0.1000
Xp070 dp070 gp070 0 0 sg13_lv_pmos w=1.12u l=0.13u
VGp071 gp071 0 -0.6500
VDp071 dp071 0 -0.1000
Xp071 dp071 gp071 0 0 sg13_lv_pmos w=1.12u l=0.13u
VGp072 gp072 0 -0.6550
VDp072 dp072 0 -0.1000
Xp072 dp072 gp072 0 0 sg13_lv_pmos w=1.12u l=0.13u
VGp073 gp073 0 -0.6600
VDp073 dp073 0 -0.1000
Xp073 dp073 gp073 0 0 sg13_lv_pmos w=1.12u l=0.13u
VGp074 gp074 0 -0.6650
VDp074 dp074 0 -0.1000
Xp074 dp074 gp074 0 0 sg13_lv_pmos w=1.12u l=0.13u
VGp075 gp075 0 -0.6700
VDp075 dp075 0 -0.1000
Xp075 dp075 gp075 0 0 sg13_lv_pmos w=1.12u l=0.13u
VGp076 gp076 0 -0.6750
VDp076 dp076 0 -0.1000
Xp076 dp076 gp076 0 0 sg13_lv_pmos w=1.12u l=0.13u
VGp077 gp077 0 -0.6800
VDp077 dp077 0 -0.1000
Xp077 dp077 gp077 0 0 sg13_lv_pmos w=1.12u l=0.13u
VGp078 gp078 0 -0.6850
VDp078 dp078 0 -0.1000
Xp078 dp078 gp078 0 0 sg13_lv_pmos w=1.12u l=0.13u
VGp079 gp079 0 -0.6900
VDp079 dp079 0 -0.1000
Xp079 dp079 gp079 0 0 sg13_lv_pmos w=1.12u l=0.13u
VGp080 gp080 0 -0.6950
VDp080 dp080 0 -0.1000
Xp080 dp080 gp080 0 0 sg13_lv_pmos w=1.12u l=0.13u
VGp081 gp081 0 -0.7000
VDp081 dp081 0 -0.1000
Xp081 dp081 gp081 0 0 sg13_lv_pmos w=1.12u l=0.13u
VGp082 gp082 0 -0.7050
VDp082 dp082 0 -0.1000
Xp082 dp082 gp082 0 0 sg13_lv_pmos w=1.12u l=0.13u
VGp083 gp083 0 -0.7100
VDp083 dp083 0 -0.1000
Xp083 dp083 gp083 0 0 sg13_lv_pmos w=1.12u l=0.13u
VGp084 gp084 0 -0.7150
VDp084 dp084 0 -0.1000
Xp084 dp084 gp084 0 0 sg13_lv_pmos w=1.12u l=0.13u
VGp085 gp085 0 -0.7200
VDp085 dp085 0 -0.1000
Xp085 dp085 gp085 0 0 sg13_lv_pmos w=1.12u l=0.13u
VGp086 gp086 0 -0.7250
VDp086 dp086 0 -0.1000
Xp086 dp086 gp086 0 0 sg13_lv_pmos w=1.12u l=0.13u
VGp087 gp087 0 -0.7300
VDp087 dp087 0 -0.1000
Xp087 dp087 gp087 0 0 sg13_lv_pmos w=1.12u l=0.13u
VGp088 gp088 0 -0.7350
VDp088 dp088 0 -0.1000
Xp088 dp088 gp088 0 0 sg13_lv_pmos w=1.12u l=0.13u
VGp089 gp089 0 -0.7400
VDp089 dp089 0 -0.1000
Xp089 dp089 gp089 0 0 sg13_lv_pmos w=1.12u l=0.13u
VGp090 gp090 0 -0.7450
VDp090 dp090 0 -0.1000
Xp090 dp090 gp090 0 0 sg13_lv_pmos w=1.12u l=0.13u
VGp091 gp091 0 -0.7500
VDp091 dp091 0 -0.1000
Xp091 dp091 gp091 0 0 sg13_lv_pmos w=1.12u l=0.13u
.tran 0.5n 30n 0 2n
.print tran format=noindex I(VDn001) I(VDn002) I(VDn003) I(VDn004) I(VDn005) I(VDn006) I(VDn007) I(VDn008) I(VDn009) I(VDn010) I(VDn011) I(VDn012) I(VDn013) I(VDn014) I(VDn015) I(VDn016) I(VDn017) I(VDn018) I(VDn019) I(VDn020) I(VDn021) I(VDn022) I(VDn023) I(VDn024) I(VDn025) I(VDn026) I(VDn027) I(VDn028) I(VDn029) I(VDn030) I(VDn031) I(VDn032) I(VDn033) I(VDn034) I(VDn035) I(VDn036) I(VDn037) I(VDn038) I(VDn039) I(VDn040) I(VDn041) I(VDn042) I(VDn043) I(VDn044) I(VDn045) I(VDn046) I(VDn047) I(VDn048) I(VDn049) I(VDn050) I(VDn051) I(VDn052) I(VDn053) I(VDn054) I(VDn055) I(VDn056) I(VDn057) I(VDn058) I(VDn059) I(VDn060) I(VDn061) I(VDn062) I(VDn063) I(VDn064) I(VDn065) I(VDn066) I(VDn067) I(VDn068) I(VDn069) I(VDn070) I(VDn071) I(VDn072) I(VDn073) I(VDn074) I(VDn075) I(VDn076) I(VDn077) I(VDn078) I(VDn079) I(VDn080) I(VDn081) I(VDn082) I(VDn083) I(VDn084) I(VDn085) I(VDn086) I(VDn087) I(VDn088) I(VDn089) I(VDn090) I(VDn091) I(VDp001) I(VDp002) I(VDp003) I(VDp004) I(VDp005) I(VDp006) I(VDp007) I(VDp008) I(VDp009) I(VDp010) I(VDp011) I(VDp012) I(VDp013) I(VDp014) I(VDp015) I(VDp016) I(VDp017) I(VDp018) I(VDp019) I(VDp020) I(VDp021) I(VDp022) I(VDp023) I(VDp024) I(VDp025) I(VDp026) I(VDp027) I(VDp028) I(VDp029) I(VDp030) I(VDp031) I(VDp032) I(VDp033) I(VDp034) I(VDp035) I(VDp036) I(VDp037) I(VDp038) I(VDp039) I(VDp040) I(VDp041) I(VDp042) I(VDp043) I(VDp044) I(VDp045) I(VDp046) I(VDp047) I(VDp048) I(VDp049) I(VDp050) I(VDp051) I(VDp052) I(VDp053) I(VDp054) I(VDp055) I(VDp056) I(VDp057) I(VDp058) I(VDp059) I(VDp060) I(VDp061) I(VDp062) I(VDp063) I(VDp064) I(VDp065) I(VDp066) I(VDp067) I(VDp068) I(VDp069) I(VDp070) I(VDp071) I(VDp072) I(VDp073) I(VDp074) I(VDp075) I(VDp076) I(VDp077) I(VDp078) I(VDp079) I(VDp080) I(VDp081) I(VDp082) I(VDp083) I(VDp084) I(VDp085) I(VDp086) I(VDp087) I(VDp088) I(VDp089) I(VDp090) I(VDp091)
.end
