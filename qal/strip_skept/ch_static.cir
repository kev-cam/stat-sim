* SKEPT cascade, topo=static rail=0.6077 wxc=1.12u
* ideal stiff rail: DECLARED, and deliberately generous to both arms
.hdl "/usr/local/share/xyce/verilog-a/psp103/psp103.va"
.include "/usr/local/src/kestrel/sim/models/sg13g2_psp103_tt.lib"
.include "/usr/local/src/stat-sim/qal/sg13lv_compat.sp"
.OPTIONS TIMEINT METHOD=GEAR RELTOL=1e-6 ABSTOL=1e-15 CHGTOL=1e-17
VRAIL rail 0 0.607700
RHI hi rail 0.001
* static o21ai_hb inst=sk1c0
XP0sk1c0 sk1c0n14 A1sk1c0 rail rail sg13_lv_pmos w=1.12u l=0.13u
XP1sk1c0 qsk1c0 A2sk1c0 sk1c0n14 rail sg13_lv_pmos w=1.12u l=0.13u
XP2sk1c0 qsk1c0 B1sk1c0 rail rail sg13_lv_pmos w=1.12u l=0.13u
XN0sk1c0 sk1c0n1 A2sk1c0 0 0 sg13_lv_nmos w=0.74u l=0.13u
XN2sk1c0 sk1c0n1 A1sk1c0 0 0 sg13_lv_nmos w=0.74u l=0.13u
XN1sk1c0 qsk1c0 B1sk1c0 sk1c0n1 0 sg13_lv_nmos w=0.74u l=0.13u
Cqsk1c0 qsk1c0 0 2f
RA1sk1c0 A1sk1c0 0 0.001
RA2sk1c0 A2sk1c0 hi 0.001
RB1sk1c0 B1sk1c0 0 0.001
* static o21ai_hb inst=sk1c1
XP0sk1c1 sk1c1n14 A1sk1c1 rail rail sg13_lv_pmos w=1.12u l=0.13u
XP1sk1c1 qsk1c1 A2sk1c1 sk1c1n14 rail sg13_lv_pmos w=1.12u l=0.13u
XP2sk1c1 qsk1c1 B1sk1c1 rail rail sg13_lv_pmos w=1.12u l=0.13u
XN0sk1c1 sk1c1n1 A2sk1c1 0 0 sg13_lv_nmos w=0.74u l=0.13u
XN2sk1c1 sk1c1n1 A1sk1c1 0 0 sg13_lv_nmos w=0.74u l=0.13u
XN1sk1c1 qsk1c1 B1sk1c1 sk1c1n1 0 sg13_lv_nmos w=0.74u l=0.13u
Cqsk1c1 qsk1c1 0 2f
RA1sk1c1 A1sk1c1 0 0.001
RA2sk1c1 A2sk1c1 hi 0.001
RB1sk1c1 B1sk1c1 hi 0.001
* static o21ai_hb inst=sk1c2
XP0sk1c2 sk1c2n14 A1sk1c2 rail rail sg13_lv_pmos w=1.12u l=0.13u
XP1sk1c2 qsk1c2 A2sk1c2 sk1c2n14 rail sg13_lv_pmos w=1.12u l=0.13u
XP2sk1c2 qsk1c2 B1sk1c2 rail rail sg13_lv_pmos w=1.12u l=0.13u
XN0sk1c2 sk1c2n1 A2sk1c2 0 0 sg13_lv_nmos w=0.74u l=0.13u
XN2sk1c2 sk1c2n1 A1sk1c2 0 0 sg13_lv_nmos w=0.74u l=0.13u
XN1sk1c2 qsk1c2 B1sk1c2 sk1c2n1 0 sg13_lv_nmos w=0.74u l=0.13u
Cqsk1c2 qsk1c2 0 2f
RA1sk1c2 A1sk1c2 hi 0.001
RA2sk1c2 A2sk1c2 0 0.001
RB1sk1c2 B1sk1c2 hi 0.001
* static o21ai_hb inst=sk1c3
XP0sk1c3 sk1c3n14 A1sk1c3 rail rail sg13_lv_pmos w=1.12u l=0.13u
XP1sk1c3 qsk1c3 A2sk1c3 sk1c3n14 rail sg13_lv_pmos w=1.12u l=0.13u
XP2sk1c3 qsk1c3 B1sk1c3 rail rail sg13_lv_pmos w=1.12u l=0.13u
XN0sk1c3 sk1c3n1 A2sk1c3 0 0 sg13_lv_nmos w=0.74u l=0.13u
XN2sk1c3 sk1c3n1 A1sk1c3 0 0 sg13_lv_nmos w=0.74u l=0.13u
XN1sk1c3 qsk1c3 B1sk1c3 sk1c3n1 0 sg13_lv_nmos w=0.74u l=0.13u
Cqsk1c3 qsk1c3 0 2f
RA1sk1c3 A1sk1c3 hi 0.001
RA2sk1c3 A2sk1c3 0 0.001
RB1sk1c3 B1sk1c3 0 0.001
* static o21ai_hb inst=sk2c0
XP0sk2c0 sk2c0n14 A1sk2c0 rail rail sg13_lv_pmos w=1.12u l=0.13u
XP1sk2c0 qsk2c0 A2sk2c0 sk2c0n14 rail sg13_lv_pmos w=1.12u l=0.13u
XP2sk2c0 qsk2c0 B1sk2c0 rail rail sg13_lv_pmos w=1.12u l=0.13u
XN0sk2c0 sk2c0n1 A2sk2c0 0 0 sg13_lv_nmos w=0.74u l=0.13u
XN2sk2c0 sk2c0n1 A1sk2c0 0 0 sg13_lv_nmos w=0.74u l=0.13u
XN1sk2c0 qsk2c0 B1sk2c0 sk2c0n1 0 sg13_lv_nmos w=0.74u l=0.13u
Cqsk2c0 qsk2c0 0 2f
RA1sk2c0 A1sk2c0 qsk1c0 0.001
RA2sk2c0 A2sk2c0 qsk1c2 0.001
RB1sk2c0 B1sk2c0 qsk1c1 0.001
* static o21ai_hb inst=sk2c1
XP0sk2c1 sk2c1n14 A1sk2c1 rail rail sg13_lv_pmos w=1.12u l=0.13u
XP1sk2c1 qsk2c1 A2sk2c1 sk2c1n14 rail sg13_lv_pmos w=1.12u l=0.13u
XP2sk2c1 qsk2c1 B1sk2c1 rail rail sg13_lv_pmos w=1.12u l=0.13u
XN0sk2c1 sk2c1n1 A2sk2c1 0 0 sg13_lv_nmos w=0.74u l=0.13u
XN2sk2c1 sk2c1n1 A1sk2c1 0 0 sg13_lv_nmos w=0.74u l=0.13u
XN1sk2c1 qsk2c1 B1sk2c1 sk2c1n1 0 sg13_lv_nmos w=0.74u l=0.13u
Cqsk2c1 qsk2c1 0 2f
RA1sk2c1 A1sk2c1 qsk1c1 0.001
RA2sk2c1 A2sk2c1 qsk1c3 0.001
RB1sk2c1 B1sk2c1 qsk1c2 0.001
* static o21ai_hb inst=sk2c2
XP0sk2c2 sk2c2n14 A1sk2c2 rail rail sg13_lv_pmos w=1.12u l=0.13u
XP1sk2c2 qsk2c2 A2sk2c2 sk2c2n14 rail sg13_lv_pmos w=1.12u l=0.13u
XP2sk2c2 qsk2c2 B1sk2c2 rail rail sg13_lv_pmos w=1.12u l=0.13u
XN0sk2c2 sk2c2n1 A2sk2c2 0 0 sg13_lv_nmos w=0.74u l=0.13u
XN2sk2c2 sk2c2n1 A1sk2c2 0 0 sg13_lv_nmos w=0.74u l=0.13u
XN1sk2c2 qsk2c2 B1sk2c2 sk2c2n1 0 sg13_lv_nmos w=0.74u l=0.13u
Cqsk2c2 qsk2c2 0 2f
RA1sk2c2 A1sk2c2 qsk1c2 0.001
RA2sk2c2 A2sk2c2 qsk1c0 0.001
RB1sk2c2 B1sk2c2 qsk1c3 0.001
* static o21ai_hb inst=sk2c3
XP0sk2c3 sk2c3n14 A1sk2c3 rail rail sg13_lv_pmos w=1.12u l=0.13u
XP1sk2c3 qsk2c3 A2sk2c3 sk2c3n14 rail sg13_lv_pmos w=1.12u l=0.13u
XP2sk2c3 qsk2c3 B1sk2c3 rail rail sg13_lv_pmos w=1.12u l=0.13u
XN0sk2c3 sk2c3n1 A2sk2c3 0 0 sg13_lv_nmos w=0.74u l=0.13u
XN2sk2c3 sk2c3n1 A1sk2c3 0 0 sg13_lv_nmos w=0.74u l=0.13u
XN1sk2c3 qsk2c3 B1sk2c3 sk2c3n1 0 sg13_lv_nmos w=0.74u l=0.13u
Cqsk2c3 qsk2c3 0 2f
RA1sk2c3 A1sk2c3 qsk1c3 0.001
RA2sk2c3 A2sk2c3 qsk1c1 0.001
RB1sk2c3 B1sk2c3 qsk1c0 0.001
* static o21ai_hb inst=sk3c0
XP0sk3c0 sk3c0n14 A1sk3c0 rail rail sg13_lv_pmos w=1.12u l=0.13u
XP1sk3c0 qsk3c0 A2sk3c0 sk3c0n14 rail sg13_lv_pmos w=1.12u l=0.13u
XP2sk3c0 qsk3c0 B1sk3c0 rail rail sg13_lv_pmos w=1.12u l=0.13u
XN0sk3c0 sk3c0n1 A2sk3c0 0 0 sg13_lv_nmos w=0.74u l=0.13u
XN2sk3c0 sk3c0n1 A1sk3c0 0 0 sg13_lv_nmos w=0.74u l=0.13u
XN1sk3c0 qsk3c0 B1sk3c0 sk3c0n1 0 sg13_lv_nmos w=0.74u l=0.13u
Cqsk3c0 qsk3c0 0 2f
RA1sk3c0 A1sk3c0 qsk2c0 0.001
RA2sk3c0 A2sk3c0 qsk2c2 0.001
RB1sk3c0 B1sk3c0 qsk2c1 0.001
* static o21ai_hb inst=sk3c1
XP0sk3c1 sk3c1n14 A1sk3c1 rail rail sg13_lv_pmos w=1.12u l=0.13u
XP1sk3c1 qsk3c1 A2sk3c1 sk3c1n14 rail sg13_lv_pmos w=1.12u l=0.13u
XP2sk3c1 qsk3c1 B1sk3c1 rail rail sg13_lv_pmos w=1.12u l=0.13u
XN0sk3c1 sk3c1n1 A2sk3c1 0 0 sg13_lv_nmos w=0.74u l=0.13u
XN2sk3c1 sk3c1n1 A1sk3c1 0 0 sg13_lv_nmos w=0.74u l=0.13u
XN1sk3c1 qsk3c1 B1sk3c1 sk3c1n1 0 sg13_lv_nmos w=0.74u l=0.13u
Cqsk3c1 qsk3c1 0 2f
RA1sk3c1 A1sk3c1 qsk2c1 0.001
RA2sk3c1 A2sk3c1 qsk2c3 0.001
RB1sk3c1 B1sk3c1 qsk2c2 0.001
* static o21ai_hb inst=sk3c2
XP0sk3c2 sk3c2n14 A1sk3c2 rail rail sg13_lv_pmos w=1.12u l=0.13u
XP1sk3c2 qsk3c2 A2sk3c2 sk3c2n14 rail sg13_lv_pmos w=1.12u l=0.13u
XP2sk3c2 qsk3c2 B1sk3c2 rail rail sg13_lv_pmos w=1.12u l=0.13u
XN0sk3c2 sk3c2n1 A2sk3c2 0 0 sg13_lv_nmos w=0.74u l=0.13u
XN2sk3c2 sk3c2n1 A1sk3c2 0 0 sg13_lv_nmos w=0.74u l=0.13u
XN1sk3c2 qsk3c2 B1sk3c2 sk3c2n1 0 sg13_lv_nmos w=0.74u l=0.13u
Cqsk3c2 qsk3c2 0 2f
RA1sk3c2 A1sk3c2 qsk2c2 0.001
RA2sk3c2 A2sk3c2 qsk2c0 0.001
RB1sk3c2 B1sk3c2 qsk2c3 0.001
* static o21ai_hb inst=sk3c3
XP0sk3c3 sk3c3n14 A1sk3c3 rail rail sg13_lv_pmos w=1.12u l=0.13u
XP1sk3c3 qsk3c3 A2sk3c3 sk3c3n14 rail sg13_lv_pmos w=1.12u l=0.13u
XP2sk3c3 qsk3c3 B1sk3c3 rail rail sg13_lv_pmos w=1.12u l=0.13u
XN0sk3c3 sk3c3n1 A2sk3c3 0 0 sg13_lv_nmos w=0.74u l=0.13u
XN2sk3c3 sk3c3n1 A1sk3c3 0 0 sg13_lv_nmos w=0.74u l=0.13u
XN1sk3c3 qsk3c3 B1sk3c3 sk3c3n1 0 sg13_lv_nmos w=0.74u l=0.13u
Cqsk3c3 qsk3c3 0 2f
RA1sk3c3 A1sk3c3 qsk2c3 0.001
RA2sk3c3 A2sk3c3 qsk2c1 0.001
RB1sk3c3 B1sk3c3 qsk2c0 0.001
* static o21ai_hb inst=sk4c0
XP0sk4c0 sk4c0n14 A1sk4c0 rail rail sg13_lv_pmos w=1.12u l=0.13u
XP1sk4c0 qsk4c0 A2sk4c0 sk4c0n14 rail sg13_lv_pmos w=1.12u l=0.13u
XP2sk4c0 qsk4c0 B1sk4c0 rail rail sg13_lv_pmos w=1.12u l=0.13u
XN0sk4c0 sk4c0n1 A2sk4c0 0 0 sg13_lv_nmos w=0.74u l=0.13u
XN2sk4c0 sk4c0n1 A1sk4c0 0 0 sg13_lv_nmos w=0.74u l=0.13u
XN1sk4c0 qsk4c0 B1sk4c0 sk4c0n1 0 sg13_lv_nmos w=0.74u l=0.13u
Cqsk4c0 qsk4c0 0 2f
RA1sk4c0 A1sk4c0 qsk3c0 0.001
RA2sk4c0 A2sk4c0 qsk3c2 0.001
RB1sk4c0 B1sk4c0 qsk3c1 0.001
* static o21ai_hb inst=sk4c1
XP0sk4c1 sk4c1n14 A1sk4c1 rail rail sg13_lv_pmos w=1.12u l=0.13u
XP1sk4c1 qsk4c1 A2sk4c1 sk4c1n14 rail sg13_lv_pmos w=1.12u l=0.13u
XP2sk4c1 qsk4c1 B1sk4c1 rail rail sg13_lv_pmos w=1.12u l=0.13u
XN0sk4c1 sk4c1n1 A2sk4c1 0 0 sg13_lv_nmos w=0.74u l=0.13u
XN2sk4c1 sk4c1n1 A1sk4c1 0 0 sg13_lv_nmos w=0.74u l=0.13u
XN1sk4c1 qsk4c1 B1sk4c1 sk4c1n1 0 sg13_lv_nmos w=0.74u l=0.13u
Cqsk4c1 qsk4c1 0 2f
RA1sk4c1 A1sk4c1 qsk3c1 0.001
RA2sk4c1 A2sk4c1 qsk3c3 0.001
RB1sk4c1 B1sk4c1 qsk3c2 0.001
* static o21ai_hb inst=sk4c2
XP0sk4c2 sk4c2n14 A1sk4c2 rail rail sg13_lv_pmos w=1.12u l=0.13u
XP1sk4c2 qsk4c2 A2sk4c2 sk4c2n14 rail sg13_lv_pmos w=1.12u l=0.13u
XP2sk4c2 qsk4c2 B1sk4c2 rail rail sg13_lv_pmos w=1.12u l=0.13u
XN0sk4c2 sk4c2n1 A2sk4c2 0 0 sg13_lv_nmos w=0.74u l=0.13u
XN2sk4c2 sk4c2n1 A1sk4c2 0 0 sg13_lv_nmos w=0.74u l=0.13u
XN1sk4c2 qsk4c2 B1sk4c2 sk4c2n1 0 sg13_lv_nmos w=0.74u l=0.13u
Cqsk4c2 qsk4c2 0 2f
RA1sk4c2 A1sk4c2 qsk3c2 0.001
RA2sk4c2 A2sk4c2 qsk3c0 0.001
RB1sk4c2 B1sk4c2 qsk3c3 0.001
* static o21ai_hb inst=sk4c3
XP0sk4c3 sk4c3n14 A1sk4c3 rail rail sg13_lv_pmos w=1.12u l=0.13u
XP1sk4c3 qsk4c3 A2sk4c3 sk4c3n14 rail sg13_lv_pmos w=1.12u l=0.13u
XP2sk4c3 qsk4c3 B1sk4c3 rail rail sg13_lv_pmos w=1.12u l=0.13u
XN0sk4c3 sk4c3n1 A2sk4c3 0 0 sg13_lv_nmos w=0.74u l=0.13u
XN2sk4c3 sk4c3n1 A1sk4c3 0 0 sg13_lv_nmos w=0.74u l=0.13u
XN1sk4c3 qsk4c3 B1sk4c3 sk4c3n1 0 sg13_lv_nmos w=0.74u l=0.13u
Cqsk4c3 qsk4c3 0 2f
RA1sk4c3 A1sk4c3 qsk3c3 0.001
RA2sk4c3 A2sk4c3 qsk3c1 0.001
RB1sk4c3 B1sk4c3 qsk3c0 0.001
* static o21ai_hb inst=sk5c0
XP0sk5c0 sk5c0n14 A1sk5c0 rail rail sg13_lv_pmos w=1.12u l=0.13u
XP1sk5c0 qsk5c0 A2sk5c0 sk5c0n14 rail sg13_lv_pmos w=1.12u l=0.13u
XP2sk5c0 qsk5c0 B1sk5c0 rail rail sg13_lv_pmos w=1.12u l=0.13u
XN0sk5c0 sk5c0n1 A2sk5c0 0 0 sg13_lv_nmos w=0.74u l=0.13u
XN2sk5c0 sk5c0n1 A1sk5c0 0 0 sg13_lv_nmos w=0.74u l=0.13u
XN1sk5c0 qsk5c0 B1sk5c0 sk5c0n1 0 sg13_lv_nmos w=0.74u l=0.13u
Cqsk5c0 qsk5c0 0 2f
RA1sk5c0 A1sk5c0 qsk4c0 0.001
RA2sk5c0 A2sk5c0 qsk4c2 0.001
RB1sk5c0 B1sk5c0 qsk4c1 0.001
* static o21ai_hb inst=sk5c1
XP0sk5c1 sk5c1n14 A1sk5c1 rail rail sg13_lv_pmos w=1.12u l=0.13u
XP1sk5c1 qsk5c1 A2sk5c1 sk5c1n14 rail sg13_lv_pmos w=1.12u l=0.13u
XP2sk5c1 qsk5c1 B1sk5c1 rail rail sg13_lv_pmos w=1.12u l=0.13u
XN0sk5c1 sk5c1n1 A2sk5c1 0 0 sg13_lv_nmos w=0.74u l=0.13u
XN2sk5c1 sk5c1n1 A1sk5c1 0 0 sg13_lv_nmos w=0.74u l=0.13u
XN1sk5c1 qsk5c1 B1sk5c1 sk5c1n1 0 sg13_lv_nmos w=0.74u l=0.13u
Cqsk5c1 qsk5c1 0 2f
RA1sk5c1 A1sk5c1 qsk4c1 0.001
RA2sk5c1 A2sk5c1 qsk4c3 0.001
RB1sk5c1 B1sk5c1 qsk4c2 0.001
* static o21ai_hb inst=sk5c2
XP0sk5c2 sk5c2n14 A1sk5c2 rail rail sg13_lv_pmos w=1.12u l=0.13u
XP1sk5c2 qsk5c2 A2sk5c2 sk5c2n14 rail sg13_lv_pmos w=1.12u l=0.13u
XP2sk5c2 qsk5c2 B1sk5c2 rail rail sg13_lv_pmos w=1.12u l=0.13u
XN0sk5c2 sk5c2n1 A2sk5c2 0 0 sg13_lv_nmos w=0.74u l=0.13u
XN2sk5c2 sk5c2n1 A1sk5c2 0 0 sg13_lv_nmos w=0.74u l=0.13u
XN1sk5c2 qsk5c2 B1sk5c2 sk5c2n1 0 sg13_lv_nmos w=0.74u l=0.13u
Cqsk5c2 qsk5c2 0 2f
RA1sk5c2 A1sk5c2 qsk4c2 0.001
RA2sk5c2 A2sk5c2 qsk4c0 0.001
RB1sk5c2 B1sk5c2 qsk4c3 0.001
* static o21ai_hb inst=sk5c3
XP0sk5c3 sk5c3n14 A1sk5c3 rail rail sg13_lv_pmos w=1.12u l=0.13u
XP1sk5c3 qsk5c3 A2sk5c3 sk5c3n14 rail sg13_lv_pmos w=1.12u l=0.13u
XP2sk5c3 qsk5c3 B1sk5c3 rail rail sg13_lv_pmos w=1.12u l=0.13u
XN0sk5c3 sk5c3n1 A2sk5c3 0 0 sg13_lv_nmos w=0.74u l=0.13u
XN2sk5c3 sk5c3n1 A1sk5c3 0 0 sg13_lv_nmos w=0.74u l=0.13u
XN1sk5c3 qsk5c3 B1sk5c3 sk5c3n1 0 sg13_lv_nmos w=0.74u l=0.13u
Cqsk5c3 qsk5c3 0 2f
RA1sk5c3 A1sk5c3 qsk4c3 0.001
RA2sk5c3 A2sk5c3 qsk4c1 0.001
RB1sk5c3 B1sk5c3 qsk4c0 0.001
* static o21ai_hb inst=sk6c0
XP0sk6c0 sk6c0n14 A1sk6c0 rail rail sg13_lv_pmos w=1.12u l=0.13u
XP1sk6c0 qsk6c0 A2sk6c0 sk6c0n14 rail sg13_lv_pmos w=1.12u l=0.13u
XP2sk6c0 qsk6c0 B1sk6c0 rail rail sg13_lv_pmos w=1.12u l=0.13u
XN0sk6c0 sk6c0n1 A2sk6c0 0 0 sg13_lv_nmos w=0.74u l=0.13u
XN2sk6c0 sk6c0n1 A1sk6c0 0 0 sg13_lv_nmos w=0.74u l=0.13u
XN1sk6c0 qsk6c0 B1sk6c0 sk6c0n1 0 sg13_lv_nmos w=0.74u l=0.13u
Cqsk6c0 qsk6c0 0 2f
RA1sk6c0 A1sk6c0 qsk5c0 0.001
RA2sk6c0 A2sk6c0 qsk5c2 0.001
RB1sk6c0 B1sk6c0 qsk5c1 0.001
* static o21ai_hb inst=sk6c1
XP0sk6c1 sk6c1n14 A1sk6c1 rail rail sg13_lv_pmos w=1.12u l=0.13u
XP1sk6c1 qsk6c1 A2sk6c1 sk6c1n14 rail sg13_lv_pmos w=1.12u l=0.13u
XP2sk6c1 qsk6c1 B1sk6c1 rail rail sg13_lv_pmos w=1.12u l=0.13u
XN0sk6c1 sk6c1n1 A2sk6c1 0 0 sg13_lv_nmos w=0.74u l=0.13u
XN2sk6c1 sk6c1n1 A1sk6c1 0 0 sg13_lv_nmos w=0.74u l=0.13u
XN1sk6c1 qsk6c1 B1sk6c1 sk6c1n1 0 sg13_lv_nmos w=0.74u l=0.13u
Cqsk6c1 qsk6c1 0 2f
RA1sk6c1 A1sk6c1 qsk5c1 0.001
RA2sk6c1 A2sk6c1 qsk5c3 0.001
RB1sk6c1 B1sk6c1 qsk5c2 0.001
* static o21ai_hb inst=sk6c2
XP0sk6c2 sk6c2n14 A1sk6c2 rail rail sg13_lv_pmos w=1.12u l=0.13u
XP1sk6c2 qsk6c2 A2sk6c2 sk6c2n14 rail sg13_lv_pmos w=1.12u l=0.13u
XP2sk6c2 qsk6c2 B1sk6c2 rail rail sg13_lv_pmos w=1.12u l=0.13u
XN0sk6c2 sk6c2n1 A2sk6c2 0 0 sg13_lv_nmos w=0.74u l=0.13u
XN2sk6c2 sk6c2n1 A1sk6c2 0 0 sg13_lv_nmos w=0.74u l=0.13u
XN1sk6c2 qsk6c2 B1sk6c2 sk6c2n1 0 sg13_lv_nmos w=0.74u l=0.13u
Cqsk6c2 qsk6c2 0 2f
RA1sk6c2 A1sk6c2 qsk5c2 0.001
RA2sk6c2 A2sk6c2 qsk5c0 0.001
RB1sk6c2 B1sk6c2 qsk5c3 0.001
* static o21ai_hb inst=sk6c3
XP0sk6c3 sk6c3n14 A1sk6c3 rail rail sg13_lv_pmos w=1.12u l=0.13u
XP1sk6c3 qsk6c3 A2sk6c3 sk6c3n14 rail sg13_lv_pmos w=1.12u l=0.13u
XP2sk6c3 qsk6c3 B1sk6c3 rail rail sg13_lv_pmos w=1.12u l=0.13u
XN0sk6c3 sk6c3n1 A2sk6c3 0 0 sg13_lv_nmos w=0.74u l=0.13u
XN2sk6c3 sk6c3n1 A1sk6c3 0 0 sg13_lv_nmos w=0.74u l=0.13u
XN1sk6c3 qsk6c3 B1sk6c3 sk6c3n1 0 sg13_lv_nmos w=0.74u l=0.13u
Cqsk6c3 qsk6c3 0 2f
RA1sk6c3 A1sk6c3 qsk5c3 0.001
RA2sk6c3 A2sk6c3 qsk5c1 0.001
RB1sk6c3 B1sk6c3 qsk5c0 0.001
.ic V(qsk1c0)=0 V(qsk1c1)=0 V(qsk1c2)=0 V(qsk1c3)=0 V(qsk2c0)=0 V(qsk2c1)=0 V(qsk2c2)=0 V(qsk2c3)=0 V(qsk3c0)=0 V(qsk3c1)=0 V(qsk3c2)=0 V(qsk3c3)=0 V(qsk4c0)=0 V(qsk4c1)=0 V(qsk4c2)=0 V(qsk4c3)=0 V(qsk5c0)=0 V(qsk5c1)=0 V(qsk5c2)=0 V(qsk5c3)=0 V(qsk6c0)=0 V(qsk6c1)=0 V(qsk6c2)=0 V(qsk6c3)=0
.tran 2p 8n 0 4p
.print tran format=noindex V(qsk1c0) V(qsk1c1) V(qsk1c2) V(qsk1c3) V(qsk2c0) V(qsk2c1) V(qsk2c2) V(qsk2c3) V(qsk3c0) V(qsk3c1) V(qsk3c2) V(qsk3c3) V(qsk4c0) V(qsk4c1) V(qsk4c2) V(qsk4c3) V(qsk5c0) V(qsk5c1) V(qsk5c2) V(qsk5c3) V(qsk6c0) V(qsk6c1) V(qsk6c2) V(qsk6c3)
.end
