.hdl "/usr/local/share/xyce/verilog-a/psp103/psp103.va"
.include "/usr/local/src/kestrel/sim/models/sg13g2_psp103_tt.lib"
.include "/usr/local/src/stat-sim/qal/sg13lv_compat.sp"
.OPTIONS TIMEINT METHOD=GEAR RELTOL=1e-6 ABSTOL=1e-15 CHGTOL=1e-17
VHI vhi 0 1.5
VMG1 gn1 0 0
VI1_0 in1_0 0 1.2
VI1_1 in1_1 0 1.2
VI1_2 in1_2 0 1.2
VI1_3 in1_3 0 0
VI1_4 in1_4 0 1.2
VI1_5 in1_5 0 0
VI1_6 in1_6 0 0
VI1_7 in1_7 0 1.2
XP1_0 o1_0 in1_0 rail1 rail1 sg13_lv_pmos w=1.12u l=0.13u
XN1_0 o1_0 in1_0 gn1 gn1 sg13_lv_nmos w=0.74u l=0.13u
CL1_0 o1_0 gn1 2f
XP1_1 o1_1 in1_1 rail1 rail1 sg13_lv_pmos w=1.12u l=0.13u
XN1_1 o1_1 in1_1 gn1 gn1 sg13_lv_nmos w=0.74u l=0.13u
CL1_1 o1_1 gn1 2f
XP1_2 o1_2 in1_2 rail1 rail1 sg13_lv_pmos w=1.12u l=0.13u
XN1_2 o1_2 in1_2 gn1 gn1 sg13_lv_nmos w=0.74u l=0.13u
CL1_2 o1_2 gn1 2f
XP1_3 o1_3 in1_3 rail1 rail1 sg13_lv_pmos w=1.12u l=0.13u
XN1_3 o1_3 in1_3 gn1 gn1 sg13_lv_nmos w=0.74u l=0.13u
CL1_3 o1_3 gn1 2f
XP1_4 o1_4 in1_4 rail1 rail1 sg13_lv_pmos w=1.12u l=0.13u
XN1_4 o1_4 in1_4 gn1 gn1 sg13_lv_nmos w=0.74u l=0.13u
CL1_4 o1_4 gn1 2f
XP1_5 o1_5 in1_5 rail1 rail1 sg13_lv_pmos w=1.12u l=0.13u
XN1_5 o1_5 in1_5 gn1 gn1 sg13_lv_nmos w=0.74u l=0.13u
CL1_5 o1_5 gn1 2f
XP1_6 o1_6 in1_6 rail1 rail1 sg13_lv_pmos w=1.12u l=0.13u
XN1_6 o1_6 in1_6 gn1 gn1 sg13_lv_nmos w=0.74u l=0.13u
CL1_6 o1_6 gn1 2f
XP1_7 o1_7 in1_7 rail1 rail1 sg13_lv_pmos w=1.12u l=0.13u
XN1_7 o1_7 in1_7 gn1 gn1 sg13_lv_nmos w=0.74u l=0.13u
CL1_7 o1_7 gn1 2f
VMG2 gn2 0 0
XP2_0 o2_0 o1_0 rail2 rail2 sg13_lv_pmos w=1.12u l=0.13u
XN2_0 o2_0 o1_0 gn2 gn2 sg13_lv_nmos w=0.74u l=0.13u
CL2_0 o2_0 gn2 2f
XP2_1 o2_1 o1_1 rail2 rail2 sg13_lv_pmos w=1.12u l=0.13u
XN2_1 o2_1 o1_1 gn2 gn2 sg13_lv_nmos w=0.74u l=0.13u
CL2_1 o2_1 gn2 2f
XP2_2 o2_2 o1_2 rail2 rail2 sg13_lv_pmos w=1.12u l=0.13u
XN2_2 o2_2 o1_2 gn2 gn2 sg13_lv_nmos w=0.74u l=0.13u
CL2_2 o2_2 gn2 2f
XP2_3 o2_3 o1_3 rail2 rail2 sg13_lv_pmos w=1.12u l=0.13u
XN2_3 o2_3 o1_3 gn2 gn2 sg13_lv_nmos w=0.74u l=0.13u
CL2_3 o2_3 gn2 2f
XP2_4 o2_4 o1_4 rail2 rail2 sg13_lv_pmos w=1.12u l=0.13u
XN2_4 o2_4 o1_4 gn2 gn2 sg13_lv_nmos w=0.74u l=0.13u
CL2_4 o2_4 gn2 2f
XP2_5 o2_5 o1_5 rail2 rail2 sg13_lv_pmos w=1.12u l=0.13u
XN2_5 o2_5 o1_5 gn2 gn2 sg13_lv_nmos w=0.74u l=0.13u
CL2_5 o2_5 gn2 2f
XP2_6 o2_6 o1_6 rail2 rail2 sg13_lv_pmos w=1.12u l=0.13u
XN2_6 o2_6 o1_6 gn2 gn2 sg13_lv_nmos w=0.74u l=0.13u
CL2_6 o2_6 gn2 2f
XP2_7 o2_7 o1_7 rail2 rail2 sg13_lv_pmos w=1.12u l=0.13u
XN2_7 o2_7 o1_7 gn2 gn2 sg13_lv_nmos w=0.74u l=0.13u
CL2_7 o2_7 gn2 2f
VMG3 gn3 0 0
XP3_0 o3_0 o2_0 rail3 rail3 sg13_lv_pmos w=1.12u l=0.13u
XN3_0 o3_0 o2_0 gn3 gn3 sg13_lv_nmos w=0.74u l=0.13u
CL3_0 o3_0 gn3 2f
XP3_1 o3_1 o2_1 rail3 rail3 sg13_lv_pmos w=1.12u l=0.13u
XN3_1 o3_1 o2_1 gn3 gn3 sg13_lv_nmos w=0.74u l=0.13u
CL3_1 o3_1 gn3 2f
XP3_2 o3_2 o2_2 rail3 rail3 sg13_lv_pmos w=1.12u l=0.13u
XN3_2 o3_2 o2_2 gn3 gn3 sg13_lv_nmos w=0.74u l=0.13u
CL3_2 o3_2 gn3 2f
XP3_3 o3_3 o2_3 rail3 rail3 sg13_lv_pmos w=1.12u l=0.13u
XN3_3 o3_3 o2_3 gn3 gn3 sg13_lv_nmos w=0.74u l=0.13u
CL3_3 o3_3 gn3 2f
XP3_4 o3_4 o2_4 rail3 rail3 sg13_lv_pmos w=1.12u l=0.13u
XN3_4 o3_4 o2_4 gn3 gn3 sg13_lv_nmos w=0.74u l=0.13u
CL3_4 o3_4 gn3 2f
XP3_5 o3_5 o2_5 rail3 rail3 sg13_lv_pmos w=1.12u l=0.13u
XN3_5 o3_5 o2_5 gn3 gn3 sg13_lv_nmos w=0.74u l=0.13u
CL3_5 o3_5 gn3 2f
XP3_6 o3_6 o2_6 rail3 rail3 sg13_lv_pmos w=1.12u l=0.13u
XN3_6 o3_6 o2_6 gn3 gn3 sg13_lv_nmos w=0.74u l=0.13u
CL3_6 o3_6 gn3 2f
XP3_7 o3_7 o2_7 rail3 rail3 sg13_lv_pmos w=1.12u l=0.13u
XN3_7 o3_7 o2_7 gn3 gn3 sg13_lv_nmos w=0.74u l=0.13u
CL3_7 o3_7 gn3 2f
VMG4 gn4 0 0
XP4_0 o4_0 o3_0 rail4 rail4 sg13_lv_pmos w=1.12u l=0.13u
XN4_0 o4_0 o3_0 gn4 gn4 sg13_lv_nmos w=0.74u l=0.13u
CL4_0 o4_0 gn4 2f
XP4_1 o4_1 o3_1 rail4 rail4 sg13_lv_pmos w=1.12u l=0.13u
XN4_1 o4_1 o3_1 gn4 gn4 sg13_lv_nmos w=0.74u l=0.13u
CL4_1 o4_1 gn4 2f
XP4_2 o4_2 o3_2 rail4 rail4 sg13_lv_pmos w=1.12u l=0.13u
XN4_2 o4_2 o3_2 gn4 gn4 sg13_lv_nmos w=0.74u l=0.13u
CL4_2 o4_2 gn4 2f
XP4_3 o4_3 o3_3 rail4 rail4 sg13_lv_pmos w=1.12u l=0.13u
XN4_3 o4_3 o3_3 gn4 gn4 sg13_lv_nmos w=0.74u l=0.13u
CL4_3 o4_3 gn4 2f
XP4_4 o4_4 o3_4 rail4 rail4 sg13_lv_pmos w=1.12u l=0.13u
XN4_4 o4_4 o3_4 gn4 gn4 sg13_lv_nmos w=0.74u l=0.13u
CL4_4 o4_4 gn4 2f
XP4_5 o4_5 o3_5 rail4 rail4 sg13_lv_pmos w=1.12u l=0.13u
XN4_5 o4_5 o3_5 gn4 gn4 sg13_lv_nmos w=0.74u l=0.13u
CL4_5 o4_5 gn4 2f
XP4_6 o4_6 o3_6 rail4 rail4 sg13_lv_pmos w=1.12u l=0.13u
XN4_6 o4_6 o3_6 gn4 gn4 sg13_lv_nmos w=0.74u l=0.13u
CL4_6 o4_6 gn4 2f
XP4_7 o4_7 o3_7 rail4 rail4 sg13_lv_pmos w=1.12u l=0.13u
XN4_7 o4_7 o3_7 gn4 gn4 sg13_lv_nmos w=0.74u l=0.13u
CL4_7 o4_7 gn4 2f
CT1 tnk1 0 359.79f
L1 tnk1 mid1 15n
R1 mid1 sw1 10
XSWN1 sw1 gt1 rail1 0 sg13_lv_nmos w=10u l=0.13u
XSWP1 sw1 gtp1 rail1 vhi sg13_lv_pmos w=20u l=0.13u
XPK1 sw1 pk1 tnk1 tnk1 sg13_lv_nmos w=2u l=0.13u
CT2 tnk2 0 359.79f
L2 tnk2 mid2 15n
R2 mid2 sw2 10
XSWN2 sw2 gt2 rail2 0 sg13_lv_nmos w=10u l=0.13u
XSWP2 sw2 gtp2 rail2 vhi sg13_lv_pmos w=20u l=0.13u
XPK2 sw2 pk2 tnk2 tnk2 sg13_lv_nmos w=2u l=0.13u
CT3 tnk3 0 359.79f
L3 tnk3 mid3 15n
R3 mid3 sw3 10
XSWN3 sw3 gt3 rail3 0 sg13_lv_nmos w=10u l=0.13u
XSWP3 sw3 gtp3 rail3 vhi sg13_lv_pmos w=20u l=0.13u
XPK3 sw3 pk3 tnk3 tnk3 sg13_lv_nmos w=2u l=0.13u
CT4 tnk4 0 359.79f
L4 tnk4 mid4 15n
R4 mid4 sw4 10
XSWN4 sw4 gt4 rail4 0 sg13_lv_nmos w=10u l=0.13u
XSWP4 sw4 gtp4 rail4 vhi sg13_lv_pmos w=20u l=0.13u
XPK4 sw4 pk4 tnk4 tnk4 sg13_lv_nmos w=2u l=0.13u
VGT1 gt1 0 PWL(0 0 198p 0 200p 1.5 318.184p 1.5 320.184p 0 718p 0 720p 1.5 849.295p 1.5 851.295p 0)
VGTP1 gtp1 0 PWL(0 1.5 198p 1.5 200p 0 318.184p 0 320.184p 1.5 718p 1.5 720p 0 849.295p 0 851.295p 1.5)
VPK1 pk1 0 PWL(0 1.5 198p 1.5 200p 0 318.184p 0 320.184p 1.5 718p 1.5 720p 0 849.295p 0 851.295p 1.5)
VGT2 gt2 0 PWL(0 0 328p 0 330p 1.5 448.264p 1.5 450.264p 0 848p 0 850p 1.5 996.734p 1.5 998.734p 0)
VGTP2 gtp2 0 PWL(0 1.5 328p 1.5 330p 0 448.264p 0 450.264p 1.5 848p 1.5 850p 0 996.734p 0 998.734p 1.5)
VPK2 pk2 0 PWL(0 1.5 328p 1.5 330p 0 448.264p 0 450.264p 1.5 848p 1.5 850p 0 996.734p 0 998.734p 1.5)
VGT3 gt3 0 PWL(0 0 458p 0 460p 1.5 576.324p 1.5 578.324p 0 978p 0 980p 1.5 1117.73p 1.5 1119.73p 0)
VGTP3 gtp3 0 PWL(0 1.5 458p 1.5 460p 0 576.324p 0 578.324p 1.5 978p 1.5 980p 0 1117.73p 0 1119.73p 1.5)
VPK3 pk3 0 PWL(0 1.5 458p 1.5 460p 0 576.324p 0 578.324p 1.5 978p 1.5 980p 0 1117.73p 0 1119.73p 1.5)
VGT4 gt4 0 PWL(0 0 588p 0 590p 1.5 705.759p 1.5 707.759p 0 1108p 0 1110p 1.5 1268.65p 1.5 1270.65p 0)
VGTP4 gtp4 0 PWL(0 1.5 588p 1.5 590p 0 705.759p 0 707.759p 1.5 1108p 1.5 1110p 0 1268.65p 0 1270.65p 1.5)
VPK4 pk4 0 PWL(0 1.5 588p 1.5 590p 0 705.759p 0 707.759p 1.5 1108p 1.5 1110p 0 1268.65p 0 1270.65p 1.5)
CXqlt1 xqlt1 0 1
BXqlt1 0 xqlt1 I={ I(L1) }
RXqlt1 xqlt1 0 0.01
CXea1 xea1 0 1
BXea1 0 xea1 I={ V(tnk1)*I(L1) }
RXea1 xea1 0 0.01
CXeb1 xeb1 0 1
BXeb1 0 xeb1 I={ V(rail1)*I(L1) }
RXeb1 xeb1 0 0.01
CXesw1 xesw1 0 1
BXesw1 0 xesw1 I={ V(sw1)*I(L1) }
RXesw1 xesw1 0 0.01
CXer1 xer1 0 1
BXer1 0 xer1 I={ I(L1)*I(L1)*10 }
RXer1 xer1 0 0.01
CXqg1 xqg1 0 1
BXqg1 0 xqg1 I={ I(VMG1) }
RXqg1 xqg1 0 0.01
CXqlt2 xqlt2 0 1
BXqlt2 0 xqlt2 I={ I(L2) }
RXqlt2 xqlt2 0 0.01
CXea2 xea2 0 1
BXea2 0 xea2 I={ V(tnk2)*I(L2) }
RXea2 xea2 0 0.01
CXeb2 xeb2 0 1
BXeb2 0 xeb2 I={ V(rail2)*I(L2) }
RXeb2 xeb2 0 0.01
CXesw2 xesw2 0 1
BXesw2 0 xesw2 I={ V(sw2)*I(L2) }
RXesw2 xesw2 0 0.01
CXer2 xer2 0 1
BXer2 0 xer2 I={ I(L2)*I(L2)*10 }
RXer2 xer2 0 0.01
CXqg2 xqg2 0 1
BXqg2 0 xqg2 I={ I(VMG2) }
RXqg2 xqg2 0 0.01
CXqlt3 xqlt3 0 1
BXqlt3 0 xqlt3 I={ I(L3) }
RXqlt3 xqlt3 0 0.01
CXea3 xea3 0 1
BXea3 0 xea3 I={ V(tnk3)*I(L3) }
RXea3 xea3 0 0.01
CXeb3 xeb3 0 1
BXeb3 0 xeb3 I={ V(rail3)*I(L3) }
RXeb3 xeb3 0 0.01
CXesw3 xesw3 0 1
BXesw3 0 xesw3 I={ V(sw3)*I(L3) }
RXesw3 xesw3 0 0.01
CXer3 xer3 0 1
BXer3 0 xer3 I={ I(L3)*I(L3)*10 }
RXer3 xer3 0 0.01
CXqg3 xqg3 0 1
BXqg3 0 xqg3 I={ I(VMG3) }
RXqg3 xqg3 0 0.01
CXqlt4 xqlt4 0 1
BXqlt4 0 xqlt4 I={ I(L4) }
RXqlt4 xqlt4 0 0.01
CXea4 xea4 0 1
BXea4 0 xea4 I={ V(tnk4)*I(L4) }
RXea4 xea4 0 0.01
CXeb4 xeb4 0 1
BXeb4 0 xeb4 I={ V(rail4)*I(L4) }
RXeb4 xeb4 0 0.01
CXesw4 xesw4 0 1
BXesw4 0 xesw4 I={ V(sw4)*I(L4) }
RXesw4 xesw4 0 0.01
CXer4 xer4 0 1
BXer4 0 xer4 I={ I(L4)*I(L4)*10 }
RXer4 xer4 0 0.01
CXqg4 xqg4 0 1
BXqg4 0 xqg4 I={ I(VMG4) }
RXqg4 xqg4 0 0.01
CXqi1 xqi1 0 1
BXqi1 0 xqi1 I={ -(I(VI1_0)+I(VI1_1)+I(VI1_2)+I(VI1_3)+I(VI1_4)+I(VI1_5)+I(VI1_6)+I(VI1_7)) }
RXqi1 xqi1 0 0.01
CXei1 xei1 0 1
BXei1 0 xei1 I={ -(V(in1_0)*I(VI1_0)+V(in1_1)*I(VI1_1)+V(in1_2)*I(VI1_2)+V(in1_3)*I(VI1_3)+V(in1_4)*I(VI1_4)+V(in1_5)*I(VI1_5)+V(in1_6)*I(VI1_6)+V(in1_7)*I(VI1_7)) }
RXei1 xei1 0 0.01
CXegt xegt 0 1
BXegt 0 xegt I={ -V(gt1)*I(VGT1)-V(gtp1)*I(VGTP1)-V(pk1)*I(VPK1)-V(gt2)*I(VGT2)-V(gtp2)*I(VGTP2)-V(pk2)*I(VPK2)-V(gt3)*I(VGT3)-V(gtp3)*I(VGTP3)-V(pk3)*I(VPK3)-V(gt4)*I(VGT4)-V(gtp4)*I(VGTP4)-V(pk4)*I(VPK4) }
RXegt xegt 0 0.01
CXehi xehi 0 1
BXehi 0 xehi I={ -1.5*I(VHI) }
RXehi xehi 0 0.01
.ic V(tnk1)=0.66 V(rail1)=0 V(sw1)=0.66 V(tnk2)=0.66 V(rail2)=0 V(sw2)=0.66 V(tnk3)=0.66 V(rail3)=0 V(sw3)=0.66 V(tnk4)=0.66 V(rail4)=0 V(sw4)=0.66
.tran 0.1p 1768.65p 0 0.25p
.measure tran QLT1_Z FIND V(xqlt1) AT=1.500000p
.measure tran QLT1_O1 FIND V(xqlt1) AT=319.183551p
.measure tran QLT1_B1 FIND V(xqlt1) AT=331.000000p
.measure tran QLT1_R1 FIND V(xqlt1) AT=719.000000p
.measure tran QLT1_Q1 FIND V(xqlt1) AT=850.294885p
.measure tran QLT1_D FIND V(xqlt1) AT=1764.648866p
.measure tran EA1_Z FIND V(xea1) AT=1.500000p
.measure tran EA1_O1 FIND V(xea1) AT=319.183551p
.measure tran EA1_B1 FIND V(xea1) AT=331.000000p
.measure tran EA1_R1 FIND V(xea1) AT=719.000000p
.measure tran EA1_Q1 FIND V(xea1) AT=850.294885p
.measure tran EA1_D FIND V(xea1) AT=1764.648866p
.measure tran EB1_Z FIND V(xeb1) AT=1.500000p
.measure tran EB1_O1 FIND V(xeb1) AT=319.183551p
.measure tran EB1_B1 FIND V(xeb1) AT=331.000000p
.measure tran EB1_R1 FIND V(xeb1) AT=719.000000p
.measure tran EB1_Q1 FIND V(xeb1) AT=850.294885p
.measure tran EB1_D FIND V(xeb1) AT=1764.648866p
.measure tran ESW1_Z FIND V(xesw1) AT=1.500000p
.measure tran ESW1_O1 FIND V(xesw1) AT=319.183551p
.measure tran ESW1_B1 FIND V(xesw1) AT=331.000000p
.measure tran ESW1_R1 FIND V(xesw1) AT=719.000000p
.measure tran ESW1_Q1 FIND V(xesw1) AT=850.294885p
.measure tran ESW1_D FIND V(xesw1) AT=1764.648866p
.measure tran ER1_Z FIND V(xer1) AT=1.500000p
.measure tran ER1_O1 FIND V(xer1) AT=319.183551p
.measure tran ER1_B1 FIND V(xer1) AT=331.000000p
.measure tran ER1_R1 FIND V(xer1) AT=719.000000p
.measure tran ER1_Q1 FIND V(xer1) AT=850.294885p
.measure tran ER1_D FIND V(xer1) AT=1764.648866p
.measure tran QG1_Z FIND V(xqg1) AT=1.500000p
.measure tran QG1_O1 FIND V(xqg1) AT=319.183551p
.measure tran QG1_B1 FIND V(xqg1) AT=331.000000p
.measure tran QG1_R1 FIND V(xqg1) AT=719.000000p
.measure tran QG1_Q1 FIND V(xqg1) AT=850.294885p
.measure tran QG1_D FIND V(xqg1) AT=1764.648866p
.measure tran QLT2_Z FIND V(xqlt2) AT=1.500000p
.measure tran QLT2_O2 FIND V(xqlt2) AT=449.263709p
.measure tran QLT2_B2 FIND V(xqlt2) AT=461.000000p
.measure tran QLT2_R2 FIND V(xqlt2) AT=849.000000p
.measure tran QLT2_Q2 FIND V(xqlt2) AT=997.734105p
.measure tran QLT2_D FIND V(xqlt2) AT=1764.648866p
.measure tran EA2_Z FIND V(xea2) AT=1.500000p
.measure tran EA2_O2 FIND V(xea2) AT=449.263709p
.measure tran EA2_B2 FIND V(xea2) AT=461.000000p
.measure tran EA2_R2 FIND V(xea2) AT=849.000000p
.measure tran EA2_Q2 FIND V(xea2) AT=997.734105p
.measure tran EA2_D FIND V(xea2) AT=1764.648866p
.measure tran EB2_Z FIND V(xeb2) AT=1.500000p
.measure tran EB2_O2 FIND V(xeb2) AT=449.263709p
.measure tran EB2_B2 FIND V(xeb2) AT=461.000000p
.measure tran EB2_R2 FIND V(xeb2) AT=849.000000p
.measure tran EB2_Q2 FIND V(xeb2) AT=997.734105p
.measure tran EB2_D FIND V(xeb2) AT=1764.648866p
.measure tran ESW2_Z FIND V(xesw2) AT=1.500000p
.measure tran ESW2_O2 FIND V(xesw2) AT=449.263709p
.measure tran ESW2_B2 FIND V(xesw2) AT=461.000000p
.measure tran ESW2_R2 FIND V(xesw2) AT=849.000000p
.measure tran ESW2_Q2 FIND V(xesw2) AT=997.734105p
.measure tran ESW2_D FIND V(xesw2) AT=1764.648866p
.measure tran ER2_Z FIND V(xer2) AT=1.500000p
.measure tran ER2_O2 FIND V(xer2) AT=449.263709p
.measure tran ER2_B2 FIND V(xer2) AT=461.000000p
.measure tran ER2_R2 FIND V(xer2) AT=849.000000p
.measure tran ER2_Q2 FIND V(xer2) AT=997.734105p
.measure tran ER2_D FIND V(xer2) AT=1764.648866p
.measure tran QG2_Z FIND V(xqg2) AT=1.500000p
.measure tran QG2_O2 FIND V(xqg2) AT=449.263709p
.measure tran QG2_B2 FIND V(xqg2) AT=461.000000p
.measure tran QG2_R2 FIND V(xqg2) AT=849.000000p
.measure tran QG2_Q2 FIND V(xqg2) AT=997.734105p
.measure tran QG2_D FIND V(xqg2) AT=1764.648866p
.measure tran QLT3_Z FIND V(xqlt3) AT=1.500000p
.measure tran QLT3_O3 FIND V(xqlt3) AT=577.323724p
.measure tran QLT3_B3 FIND V(xqlt3) AT=591.000000p
.measure tran QLT3_R3 FIND V(xqlt3) AT=979.000000p
.measure tran QLT3_Q3 FIND V(xqlt3) AT=1118.730418p
.measure tran QLT3_D FIND V(xqlt3) AT=1764.648866p
.measure tran EA3_Z FIND V(xea3) AT=1.500000p
.measure tran EA3_O3 FIND V(xea3) AT=577.323724p
.measure tran EA3_B3 FIND V(xea3) AT=591.000000p
.measure tran EA3_R3 FIND V(xea3) AT=979.000000p
.measure tran EA3_Q3 FIND V(xea3) AT=1118.730418p
.measure tran EA3_D FIND V(xea3) AT=1764.648866p
.measure tran EB3_Z FIND V(xeb3) AT=1.500000p
.measure tran EB3_O3 FIND V(xeb3) AT=577.323724p
.measure tran EB3_B3 FIND V(xeb3) AT=591.000000p
.measure tran EB3_R3 FIND V(xeb3) AT=979.000000p
.measure tran EB3_Q3 FIND V(xeb3) AT=1118.730418p
.measure tran EB3_D FIND V(xeb3) AT=1764.648866p
.measure tran ESW3_Z FIND V(xesw3) AT=1.500000p
.measure tran ESW3_O3 FIND V(xesw3) AT=577.323724p
.measure tran ESW3_B3 FIND V(xesw3) AT=591.000000p
.measure tran ESW3_R3 FIND V(xesw3) AT=979.000000p
.measure tran ESW3_Q3 FIND V(xesw3) AT=1118.730418p
.measure tran ESW3_D FIND V(xesw3) AT=1764.648866p
.measure tran ER3_Z FIND V(xer3) AT=1.500000p
.measure tran ER3_O3 FIND V(xer3) AT=577.323724p
.measure tran ER3_B3 FIND V(xer3) AT=591.000000p
.measure tran ER3_R3 FIND V(xer3) AT=979.000000p
.measure tran ER3_Q3 FIND V(xer3) AT=1118.730418p
.measure tran ER3_D FIND V(xer3) AT=1764.648866p
.measure tran QG3_Z FIND V(xqg3) AT=1.500000p
.measure tran QG3_O3 FIND V(xqg3) AT=577.323724p
.measure tran QG3_B3 FIND V(xqg3) AT=591.000000p
.measure tran QG3_R3 FIND V(xqg3) AT=979.000000p
.measure tran QG3_Q3 FIND V(xqg3) AT=1118.730418p
.measure tran QG3_D FIND V(xqg3) AT=1764.648866p
.measure tran QLT4_Z FIND V(xqlt4) AT=1.500000p
.measure tran QLT4_O4 FIND V(xqlt4) AT=706.759275p
.measure tran QLT4_B4 FIND V(xqlt4) AT=721.000000p
.measure tran QLT4_R4 FIND V(xqlt4) AT=1109.000000p
.measure tran QLT4_Q4 FIND V(xqlt4) AT=1269.648866p
.measure tran QLT4_D FIND V(xqlt4) AT=1764.648866p
.measure tran EA4_Z FIND V(xea4) AT=1.500000p
.measure tran EA4_O4 FIND V(xea4) AT=706.759275p
.measure tran EA4_B4 FIND V(xea4) AT=721.000000p
.measure tran EA4_R4 FIND V(xea4) AT=1109.000000p
.measure tran EA4_Q4 FIND V(xea4) AT=1269.648866p
.measure tran EA4_D FIND V(xea4) AT=1764.648866p
.measure tran EB4_Z FIND V(xeb4) AT=1.500000p
.measure tran EB4_O4 FIND V(xeb4) AT=706.759275p
.measure tran EB4_B4 FIND V(xeb4) AT=721.000000p
.measure tran EB4_R4 FIND V(xeb4) AT=1109.000000p
.measure tran EB4_Q4 FIND V(xeb4) AT=1269.648866p
.measure tran EB4_D FIND V(xeb4) AT=1764.648866p
.measure tran ESW4_Z FIND V(xesw4) AT=1.500000p
.measure tran ESW4_O4 FIND V(xesw4) AT=706.759275p
.measure tran ESW4_B4 FIND V(xesw4) AT=721.000000p
.measure tran ESW4_R4 FIND V(xesw4) AT=1109.000000p
.measure tran ESW4_Q4 FIND V(xesw4) AT=1269.648866p
.measure tran ESW4_D FIND V(xesw4) AT=1764.648866p
.measure tran ER4_Z FIND V(xer4) AT=1.500000p
.measure tran ER4_O4 FIND V(xer4) AT=706.759275p
.measure tran ER4_B4 FIND V(xer4) AT=721.000000p
.measure tran ER4_R4 FIND V(xer4) AT=1109.000000p
.measure tran ER4_Q4 FIND V(xer4) AT=1269.648866p
.measure tran ER4_D FIND V(xer4) AT=1764.648866p
.measure tran QG4_Z FIND V(xqg4) AT=1.500000p
.measure tran QG4_O4 FIND V(xqg4) AT=706.759275p
.measure tran QG4_B4 FIND V(xqg4) AT=721.000000p
.measure tran QG4_R4 FIND V(xqg4) AT=1109.000000p
.measure tran QG4_Q4 FIND V(xqg4) AT=1269.648866p
.measure tran QG4_D FIND V(xqg4) AT=1764.648866p
.measure tran QI1_Z FIND V(xqi1) AT=1.500000p
.measure tran QI1_O1 FIND V(xqi1) AT=319.183551p
.measure tran QI1_B1 FIND V(xqi1) AT=331.000000p
.measure tran QI1_R1 FIND V(xqi1) AT=719.000000p
.measure tran QI1_Q1 FIND V(xqi1) AT=850.294885p
.measure tran QI1_D FIND V(xqi1) AT=1764.648866p
.measure tran EI1_Z FIND V(xei1) AT=1.500000p
.measure tran EI1_O1 FIND V(xei1) AT=319.183551p
.measure tran EI1_B1 FIND V(xei1) AT=331.000000p
.measure tran EI1_R1 FIND V(xei1) AT=719.000000p
.measure tran EI1_Q1 FIND V(xei1) AT=850.294885p
.measure tran EI1_D FIND V(xei1) AT=1764.648866p
.measure tran EGT_Z FIND V(xegt) AT=1.500000p
.measure tran EGT_O1 FIND V(xegt) AT=319.183551p
.measure tran EGT_B1 FIND V(xegt) AT=331.000000p
.measure tran EGT_R1 FIND V(xegt) AT=719.000000p
.measure tran EGT_Q1 FIND V(xegt) AT=850.294885p
.measure tran EGT_O2 FIND V(xegt) AT=449.263709p
.measure tran EGT_B2 FIND V(xegt) AT=461.000000p
.measure tran EGT_R2 FIND V(xegt) AT=849.000000p
.measure tran EGT_Q2 FIND V(xegt) AT=997.734105p
.measure tran EGT_O3 FIND V(xegt) AT=577.323724p
.measure tran EGT_B3 FIND V(xegt) AT=591.000000p
.measure tran EGT_R3 FIND V(xegt) AT=979.000000p
.measure tran EGT_Q3 FIND V(xegt) AT=1118.730418p
.measure tran EGT_O4 FIND V(xegt) AT=706.759275p
.measure tran EGT_B4 FIND V(xegt) AT=721.000000p
.measure tran EGT_R4 FIND V(xegt) AT=1109.000000p
.measure tran EGT_Q4 FIND V(xegt) AT=1269.648866p
.measure tran EGT_D FIND V(xegt) AT=1764.648866p
.measure tran EHI_Z FIND V(xehi) AT=1.500000p
.measure tran EHI_O1 FIND V(xehi) AT=319.183551p
.measure tran EHI_B1 FIND V(xehi) AT=331.000000p
.measure tran EHI_R1 FIND V(xehi) AT=719.000000p
.measure tran EHI_Q1 FIND V(xehi) AT=850.294885p
.measure tran EHI_O2 FIND V(xehi) AT=449.263709p
.measure tran EHI_B2 FIND V(xehi) AT=461.000000p
.measure tran EHI_R2 FIND V(xehi) AT=849.000000p
.measure tran EHI_Q2 FIND V(xehi) AT=997.734105p
.measure tran EHI_O3 FIND V(xehi) AT=577.323724p
.measure tran EHI_B3 FIND V(xehi) AT=591.000000p
.measure tran EHI_R3 FIND V(xehi) AT=979.000000p
.measure tran EHI_Q3 FIND V(xehi) AT=1118.730418p
.measure tran EHI_O4 FIND V(xehi) AT=706.759275p
.measure tran EHI_B4 FIND V(xehi) AT=721.000000p
.measure tran EHI_R4 FIND V(xehi) AT=1109.000000p
.measure tran EHI_Q4 FIND V(xehi) AT=1269.648866p
.measure tran EHI_D FIND V(xehi) AT=1764.648866p
.measure tran VR1Z FIND V(rail1) AT=1.500000p
.measure tran VT1Z FIND V(tnk1) AT=1.500000p
.measure tran VR1O1 FIND V(rail1) AT=319.183551p
.measure tran VT1O1 FIND V(tnk1) AT=319.183551p
.measure tran VR1B1 FIND V(rail1) AT=331.000000p
.measure tran VT1B1 FIND V(tnk1) AT=331.000000p
.measure tran VR1R1 FIND V(rail1) AT=719.000000p
.measure tran VT1R1 FIND V(tnk1) AT=719.000000p
.measure tran VR1Q1 FIND V(rail1) AT=850.294885p
.measure tran VT1Q1 FIND V(tnk1) AT=850.294885p
.measure tran VR1O2 FIND V(rail1) AT=449.263709p
.measure tran VT1O2 FIND V(tnk1) AT=449.263709p
.measure tran VR1B2 FIND V(rail1) AT=461.000000p
.measure tran VT1B2 FIND V(tnk1) AT=461.000000p
.measure tran VR1R2 FIND V(rail1) AT=849.000000p
.measure tran VT1R2 FIND V(tnk1) AT=849.000000p
.measure tran VR1Q2 FIND V(rail1) AT=997.734105p
.measure tran VT1Q2 FIND V(tnk1) AT=997.734105p
.measure tran VR1O3 FIND V(rail1) AT=577.323724p
.measure tran VT1O3 FIND V(tnk1) AT=577.323724p
.measure tran VR1B3 FIND V(rail1) AT=591.000000p
.measure tran VT1B3 FIND V(tnk1) AT=591.000000p
.measure tran VR1R3 FIND V(rail1) AT=979.000000p
.measure tran VT1R3 FIND V(tnk1) AT=979.000000p
.measure tran VR1Q3 FIND V(rail1) AT=1118.730418p
.measure tran VT1Q3 FIND V(tnk1) AT=1118.730418p
.measure tran VR1O4 FIND V(rail1) AT=706.759275p
.measure tran VT1O4 FIND V(tnk1) AT=706.759275p
.measure tran VR1B4 FIND V(rail1) AT=721.000000p
.measure tran VT1B4 FIND V(tnk1) AT=721.000000p
.measure tran VR1R4 FIND V(rail1) AT=1109.000000p
.measure tran VT1R4 FIND V(tnk1) AT=1109.000000p
.measure tran VR1Q4 FIND V(rail1) AT=1269.648866p
.measure tran VT1Q4 FIND V(tnk1) AT=1269.648866p
.measure tran VR1D FIND V(rail1) AT=1764.648866p
.measure tran VT1D FIND V(tnk1) AT=1764.648866p
.measure tran VR1PK MAX V(rail1) FROM=200p TO=1768.65p
.measure tran IZ1 FIND I(L1) AT=319.183551p
.measure tran IZQ1 FIND I(L1) AT=850.294885p
.measure tran IPK1 MAX I(L1) FROM=200p TO=1768.65p
.measure tran O1_0B FIND V(o1_0) AT=331.000000p
.measure tran O1_0E FIND V(o1_0) AT=1764.648866p
.measure tran O1_1B FIND V(o1_1) AT=331.000000p
.measure tran O1_1E FIND V(o1_1) AT=1764.648866p
.measure tran O1_2B FIND V(o1_2) AT=331.000000p
.measure tran O1_2E FIND V(o1_2) AT=1764.648866p
.measure tran O1_3B FIND V(o1_3) AT=331.000000p
.measure tran O1_3E FIND V(o1_3) AT=1764.648866p
.measure tran O1_4B FIND V(o1_4) AT=331.000000p
.measure tran O1_4E FIND V(o1_4) AT=1764.648866p
.measure tran O1_5B FIND V(o1_5) AT=331.000000p
.measure tran O1_5E FIND V(o1_5) AT=1764.648866p
.measure tran O1_6B FIND V(o1_6) AT=331.000000p
.measure tran O1_6E FIND V(o1_6) AT=1764.648866p
.measure tran O1_7B FIND V(o1_7) AT=331.000000p
.measure tran O1_7E FIND V(o1_7) AT=1764.648866p
.measure tran VR2Z FIND V(rail2) AT=1.500000p
.measure tran VT2Z FIND V(tnk2) AT=1.500000p
.measure tran VR2O1 FIND V(rail2) AT=319.183551p
.measure tran VT2O1 FIND V(tnk2) AT=319.183551p
.measure tran VR2B1 FIND V(rail2) AT=331.000000p
.measure tran VT2B1 FIND V(tnk2) AT=331.000000p
.measure tran VR2R1 FIND V(rail2) AT=719.000000p
.measure tran VT2R1 FIND V(tnk2) AT=719.000000p
.measure tran VR2Q1 FIND V(rail2) AT=850.294885p
.measure tran VT2Q1 FIND V(tnk2) AT=850.294885p
.measure tran VR2O2 FIND V(rail2) AT=449.263709p
.measure tran VT2O2 FIND V(tnk2) AT=449.263709p
.measure tran VR2B2 FIND V(rail2) AT=461.000000p
.measure tran VT2B2 FIND V(tnk2) AT=461.000000p
.measure tran VR2R2 FIND V(rail2) AT=849.000000p
.measure tran VT2R2 FIND V(tnk2) AT=849.000000p
.measure tran VR2Q2 FIND V(rail2) AT=997.734105p
.measure tran VT2Q2 FIND V(tnk2) AT=997.734105p
.measure tran VR2O3 FIND V(rail2) AT=577.323724p
.measure tran VT2O3 FIND V(tnk2) AT=577.323724p
.measure tran VR2B3 FIND V(rail2) AT=591.000000p
.measure tran VT2B3 FIND V(tnk2) AT=591.000000p
.measure tran VR2R3 FIND V(rail2) AT=979.000000p
.measure tran VT2R3 FIND V(tnk2) AT=979.000000p
.measure tran VR2Q3 FIND V(rail2) AT=1118.730418p
.measure tran VT2Q3 FIND V(tnk2) AT=1118.730418p
.measure tran VR2O4 FIND V(rail2) AT=706.759275p
.measure tran VT2O4 FIND V(tnk2) AT=706.759275p
.measure tran VR2B4 FIND V(rail2) AT=721.000000p
.measure tran VT2B4 FIND V(tnk2) AT=721.000000p
.measure tran VR2R4 FIND V(rail2) AT=1109.000000p
.measure tran VT2R4 FIND V(tnk2) AT=1109.000000p
.measure tran VR2Q4 FIND V(rail2) AT=1269.648866p
.measure tran VT2Q4 FIND V(tnk2) AT=1269.648866p
.measure tran VR2D FIND V(rail2) AT=1764.648866p
.measure tran VT2D FIND V(tnk2) AT=1764.648866p
.measure tran VR2PK MAX V(rail2) FROM=330p TO=1768.65p
.measure tran IZ2 FIND I(L2) AT=449.263709p
.measure tran IZQ2 FIND I(L2) AT=997.734105p
.measure tran IPK2 MAX I(L2) FROM=330p TO=1768.65p
.measure tran O2_0B FIND V(o2_0) AT=461.000000p
.measure tran O2_0E FIND V(o2_0) AT=1764.648866p
.measure tran N2_0B FIND V(o1_0) AT=461.000000p
.measure tran O2_1B FIND V(o2_1) AT=461.000000p
.measure tran O2_1E FIND V(o2_1) AT=1764.648866p
.measure tran N2_1B FIND V(o1_1) AT=461.000000p
.measure tran O2_2B FIND V(o2_2) AT=461.000000p
.measure tran O2_2E FIND V(o2_2) AT=1764.648866p
.measure tran N2_2B FIND V(o1_2) AT=461.000000p
.measure tran O2_3B FIND V(o2_3) AT=461.000000p
.measure tran O2_3E FIND V(o2_3) AT=1764.648866p
.measure tran N2_3B FIND V(o1_3) AT=461.000000p
.measure tran O2_4B FIND V(o2_4) AT=461.000000p
.measure tran O2_4E FIND V(o2_4) AT=1764.648866p
.measure tran N2_4B FIND V(o1_4) AT=461.000000p
.measure tran O2_5B FIND V(o2_5) AT=461.000000p
.measure tran O2_5E FIND V(o2_5) AT=1764.648866p
.measure tran N2_5B FIND V(o1_5) AT=461.000000p
.measure tran O2_6B FIND V(o2_6) AT=461.000000p
.measure tran O2_6E FIND V(o2_6) AT=1764.648866p
.measure tran N2_6B FIND V(o1_6) AT=461.000000p
.measure tran O2_7B FIND V(o2_7) AT=461.000000p
.measure tran O2_7E FIND V(o2_7) AT=1764.648866p
.measure tran N2_7B FIND V(o1_7) AT=461.000000p
.measure tran VR3Z FIND V(rail3) AT=1.500000p
.measure tran VT3Z FIND V(tnk3) AT=1.500000p
.measure tran VR3O1 FIND V(rail3) AT=319.183551p
.measure tran VT3O1 FIND V(tnk3) AT=319.183551p
.measure tran VR3B1 FIND V(rail3) AT=331.000000p
.measure tran VT3B1 FIND V(tnk3) AT=331.000000p
.measure tran VR3R1 FIND V(rail3) AT=719.000000p
.measure tran VT3R1 FIND V(tnk3) AT=719.000000p
.measure tran VR3Q1 FIND V(rail3) AT=850.294885p
.measure tran VT3Q1 FIND V(tnk3) AT=850.294885p
.measure tran VR3O2 FIND V(rail3) AT=449.263709p
.measure tran VT3O2 FIND V(tnk3) AT=449.263709p
.measure tran VR3B2 FIND V(rail3) AT=461.000000p
.measure tran VT3B2 FIND V(tnk3) AT=461.000000p
.measure tran VR3R2 FIND V(rail3) AT=849.000000p
.measure tran VT3R2 FIND V(tnk3) AT=849.000000p
.measure tran VR3Q2 FIND V(rail3) AT=997.734105p
.measure tran VT3Q2 FIND V(tnk3) AT=997.734105p
.measure tran VR3O3 FIND V(rail3) AT=577.323724p
.measure tran VT3O3 FIND V(tnk3) AT=577.323724p
.measure tran VR3B3 FIND V(rail3) AT=591.000000p
.measure tran VT3B3 FIND V(tnk3) AT=591.000000p
.measure tran VR3R3 FIND V(rail3) AT=979.000000p
.measure tran VT3R3 FIND V(tnk3) AT=979.000000p
.measure tran VR3Q3 FIND V(rail3) AT=1118.730418p
.measure tran VT3Q3 FIND V(tnk3) AT=1118.730418p
.measure tran VR3O4 FIND V(rail3) AT=706.759275p
.measure tran VT3O4 FIND V(tnk3) AT=706.759275p
.measure tran VR3B4 FIND V(rail3) AT=721.000000p
.measure tran VT3B4 FIND V(tnk3) AT=721.000000p
.measure tran VR3R4 FIND V(rail3) AT=1109.000000p
.measure tran VT3R4 FIND V(tnk3) AT=1109.000000p
.measure tran VR3Q4 FIND V(rail3) AT=1269.648866p
.measure tran VT3Q4 FIND V(tnk3) AT=1269.648866p
.measure tran VR3D FIND V(rail3) AT=1764.648866p
.measure tran VT3D FIND V(tnk3) AT=1764.648866p
.measure tran VR3PK MAX V(rail3) FROM=460p TO=1768.65p
.measure tran IZ3 FIND I(L3) AT=577.323724p
.measure tran IZQ3 FIND I(L3) AT=1118.730418p
.measure tran IPK3 MAX I(L3) FROM=460p TO=1768.65p
.measure tran O3_0B FIND V(o3_0) AT=591.000000p
.measure tran O3_0E FIND V(o3_0) AT=1764.648866p
.measure tran N3_0B FIND V(o2_0) AT=591.000000p
.measure tran O3_1B FIND V(o3_1) AT=591.000000p
.measure tran O3_1E FIND V(o3_1) AT=1764.648866p
.measure tran N3_1B FIND V(o2_1) AT=591.000000p
.measure tran O3_2B FIND V(o3_2) AT=591.000000p
.measure tran O3_2E FIND V(o3_2) AT=1764.648866p
.measure tran N3_2B FIND V(o2_2) AT=591.000000p
.measure tran O3_3B FIND V(o3_3) AT=591.000000p
.measure tran O3_3E FIND V(o3_3) AT=1764.648866p
.measure tran N3_3B FIND V(o2_3) AT=591.000000p
.measure tran O3_4B FIND V(o3_4) AT=591.000000p
.measure tran O3_4E FIND V(o3_4) AT=1764.648866p
.measure tran N3_4B FIND V(o2_4) AT=591.000000p
.measure tran O3_5B FIND V(o3_5) AT=591.000000p
.measure tran O3_5E FIND V(o3_5) AT=1764.648866p
.measure tran N3_5B FIND V(o2_5) AT=591.000000p
.measure tran O3_6B FIND V(o3_6) AT=591.000000p
.measure tran O3_6E FIND V(o3_6) AT=1764.648866p
.measure tran N3_6B FIND V(o2_6) AT=591.000000p
.measure tran O3_7B FIND V(o3_7) AT=591.000000p
.measure tran O3_7E FIND V(o3_7) AT=1764.648866p
.measure tran N3_7B FIND V(o2_7) AT=591.000000p
.measure tran VR4Z FIND V(rail4) AT=1.500000p
.measure tran VT4Z FIND V(tnk4) AT=1.500000p
.measure tran VR4O1 FIND V(rail4) AT=319.183551p
.measure tran VT4O1 FIND V(tnk4) AT=319.183551p
.measure tran VR4B1 FIND V(rail4) AT=331.000000p
.measure tran VT4B1 FIND V(tnk4) AT=331.000000p
.measure tran VR4R1 FIND V(rail4) AT=719.000000p
.measure tran VT4R1 FIND V(tnk4) AT=719.000000p
.measure tran VR4Q1 FIND V(rail4) AT=850.294885p
.measure tran VT4Q1 FIND V(tnk4) AT=850.294885p
.measure tran VR4O2 FIND V(rail4) AT=449.263709p
.measure tran VT4O2 FIND V(tnk4) AT=449.263709p
.measure tran VR4B2 FIND V(rail4) AT=461.000000p
.measure tran VT4B2 FIND V(tnk4) AT=461.000000p
.measure tran VR4R2 FIND V(rail4) AT=849.000000p
.measure tran VT4R2 FIND V(tnk4) AT=849.000000p
.measure tran VR4Q2 FIND V(rail4) AT=997.734105p
.measure tran VT4Q2 FIND V(tnk4) AT=997.734105p
.measure tran VR4O3 FIND V(rail4) AT=577.323724p
.measure tran VT4O3 FIND V(tnk4) AT=577.323724p
.measure tran VR4B3 FIND V(rail4) AT=591.000000p
.measure tran VT4B3 FIND V(tnk4) AT=591.000000p
.measure tran VR4R3 FIND V(rail4) AT=979.000000p
.measure tran VT4R3 FIND V(tnk4) AT=979.000000p
.measure tran VR4Q3 FIND V(rail4) AT=1118.730418p
.measure tran VT4Q3 FIND V(tnk4) AT=1118.730418p
.measure tran VR4O4 FIND V(rail4) AT=706.759275p
.measure tran VT4O4 FIND V(tnk4) AT=706.759275p
.measure tran VR4B4 FIND V(rail4) AT=721.000000p
.measure tran VT4B4 FIND V(tnk4) AT=721.000000p
.measure tran VR4R4 FIND V(rail4) AT=1109.000000p
.measure tran VT4R4 FIND V(tnk4) AT=1109.000000p
.measure tran VR4Q4 FIND V(rail4) AT=1269.648866p
.measure tran VT4Q4 FIND V(tnk4) AT=1269.648866p
.measure tran VR4D FIND V(rail4) AT=1764.648866p
.measure tran VT4D FIND V(tnk4) AT=1764.648866p
.measure tran VR4PK MAX V(rail4) FROM=590p TO=1768.65p
.measure tran IZ4 FIND I(L4) AT=706.759275p
.measure tran IZQ4 FIND I(L4) AT=1269.648866p
.measure tran IPK4 MAX I(L4) FROM=590p TO=1768.65p
.measure tran O4_0B FIND V(o4_0) AT=721.000000p
.measure tran O4_0E FIND V(o4_0) AT=1764.648866p
.measure tran N4_0B FIND V(o3_0) AT=721.000000p
.measure tran O4_1B FIND V(o4_1) AT=721.000000p
.measure tran O4_1E FIND V(o4_1) AT=1764.648866p
.measure tran N4_1B FIND V(o3_1) AT=721.000000p
.measure tran O4_2B FIND V(o4_2) AT=721.000000p
.measure tran O4_2E FIND V(o4_2) AT=1764.648866p
.measure tran N4_2B FIND V(o3_2) AT=721.000000p
.measure tran O4_3B FIND V(o4_3) AT=721.000000p
.measure tran O4_3E FIND V(o4_3) AT=1764.648866p
.measure tran N4_3B FIND V(o3_3) AT=721.000000p
.measure tran O4_4B FIND V(o4_4) AT=721.000000p
.measure tran O4_4E FIND V(o4_4) AT=1764.648866p
.measure tran N4_4B FIND V(o3_4) AT=721.000000p
.measure tran O4_5B FIND V(o4_5) AT=721.000000p
.measure tran O4_5E FIND V(o4_5) AT=1764.648866p
.measure tran N4_5B FIND V(o3_5) AT=721.000000p
.measure tran O4_6B FIND V(o4_6) AT=721.000000p
.measure tran O4_6E FIND V(o4_6) AT=1764.648866p
.measure tran N4_6B FIND V(o3_6) AT=721.000000p
.measure tran O4_7B FIND V(o4_7) AT=721.000000p
.measure tran O4_7E FIND V(o4_7) AT=1764.648866p
.measure tran N4_7B FIND V(o3_7) AT=721.000000p
.print tran V(rail1) V(rail2) V(rail3) V(rail4) V(tnk1) V(tnk2) V(tnk3) V(tnk4) I(L1) I(L2) I(L3) I(L4) V(sw1) V(sw2) V(sw3) V(sw4) V(o1_0) V(o1_1) V(o1_2) V(o1_3) V(o1_4) V(o1_5) V(o1_6) V(o1_7) V(o2_0) V(o2_1) V(o2_2) V(o2_3) V(o2_4) V(o2_5) V(o2_6) V(o2_7) V(o3_0) V(o3_1) V(o3_2) V(o3_3) V(o3_4) V(o3_5) V(o3_6) V(o3_7) V(o4_0) V(o4_1) V(o4_2) V(o4_3) V(o4_4) V(o4_5) V(o4_6) V(o4_7)
.end
