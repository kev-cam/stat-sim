.hdl "/usr/local/share/xyce/verilog-a/psp103/psp103.va"
.include "/usr/local/src/kestrel/sim/models/sg13g2_psp103_tt.lib"
.include "/usr/local/src/stat-sim/qal/sg13lv_compat.sp"
.OPTIONS TIMEINT METHOD=GEAR RELTOL=1e-6 ABSTOL=1e-15 CHGTOL=1e-17
VS rail3 0 PWL(0 0 8000p 1.65)
VHI vhi 0 2.4
VMG3 gn3 0 0
VMGD gnd4 0 0
VRD rail4 0 0
VW0 wsrc0 gn3 1.2
VW1 wsrc1 gn3 0
VW2 wsrc2 gn3 1.2
VW3 wsrc3 gn3 1.2
XPIA3_0 ab3_0 wsrc0 rail3 rail3 sg13_lv_pmos w=1.12u l=0.13u
XNIA3_0 ab3_0 wsrc0 gn3 gn3 sg13_lv_nmos w=0.74u l=0.13u
XPIB3_0 bb3_0 wsrc2 rail3 rail3 sg13_lv_pmos w=1.12u l=0.13u
XNIB3_0 bb3_0 wsrc2 gn3 gn3 sg13_lv_nmos w=0.74u l=0.13u
XTN13_0 ab3_0 bb3_0 yi3_0 gn3 sg13_lv_nmos w=0.74u l=0.13u
XTP13_0 ab3_0 wsrc2 yi3_0 vhi sg13_lv_pmos w=1.12u l=0.13u
XTN23_0 wsrc0 wsrc2 yi3_0 gn3 sg13_lv_nmos w=0.74u l=0.13u
XTP23_0 wsrc0 bb3_0 yi3_0 vhi sg13_lv_pmos w=1.12u l=0.13u
CL3_0 yi3_0 gn3 2f
XPOR3_0 y3_0 yi3_0 rail3 rail3 sg13_lv_pmos w=1.12u l=0.13u
XNOR3_0 y3_0 yi3_0 gn3 gn3 sg13_lv_nmos w=0.74u l=0.13u
CLO3_0 y3_0 gn3 2f
XPIA3_1 ab3_1 wsrc1 rail3 rail3 sg13_lv_pmos w=1.12u l=0.13u
XNIA3_1 ab3_1 wsrc1 gn3 gn3 sg13_lv_nmos w=0.74u l=0.13u
XPIB3_1 bb3_1 wsrc3 rail3 rail3 sg13_lv_pmos w=1.12u l=0.13u
XNIB3_1 bb3_1 wsrc3 gn3 gn3 sg13_lv_nmos w=0.74u l=0.13u
XTN13_1 ab3_1 bb3_1 yi3_1 gn3 sg13_lv_nmos w=0.74u l=0.13u
XTP13_1 ab3_1 wsrc3 yi3_1 vhi sg13_lv_pmos w=1.12u l=0.13u
XTN23_1 wsrc1 wsrc3 yi3_1 gn3 sg13_lv_nmos w=0.74u l=0.13u
XTP23_1 wsrc1 bb3_1 yi3_1 vhi sg13_lv_pmos w=1.12u l=0.13u
CL3_1 yi3_1 gn3 2f
XPOR3_1 y3_1 yi3_1 rail3 rail3 sg13_lv_pmos w=1.12u l=0.13u
XNOR3_1 y3_1 yi3_1 gn3 gn3 sg13_lv_nmos w=0.74u l=0.13u
CLO3_1 y3_1 gn3 2f
XPIA3_2 ab3_2 wsrc2 rail3 rail3 sg13_lv_pmos w=1.12u l=0.13u
XNIA3_2 ab3_2 wsrc2 gn3 gn3 sg13_lv_nmos w=0.74u l=0.13u
XPIB3_2 bb3_2 wsrc0 rail3 rail3 sg13_lv_pmos w=1.12u l=0.13u
XNIB3_2 bb3_2 wsrc0 gn3 gn3 sg13_lv_nmos w=0.74u l=0.13u
XTN13_2 wsrc2 bb3_2 yi3_2 gn3 sg13_lv_nmos w=0.74u l=0.13u
XTP13_2 wsrc2 wsrc0 yi3_2 vhi sg13_lv_pmos w=1.12u l=0.13u
XTN23_2 ab3_2 wsrc0 yi3_2 gn3 sg13_lv_nmos w=0.74u l=0.13u
XTP23_2 ab3_2 bb3_2 yi3_2 vhi sg13_lv_pmos w=1.12u l=0.13u
CL3_2 yi3_2 gn3 2f
XPOR3_2 y3_2 yi3_2 rail3 rail3 sg13_lv_pmos w=1.12u l=0.13u
XNOR3_2 y3_2 yi3_2 gn3 gn3 sg13_lv_nmos w=0.74u l=0.13u
CLO3_2 y3_2 gn3 2f
XPIA3_3 ab3_3 wsrc3 rail3 rail3 sg13_lv_pmos w=1.12u l=0.13u
XNIA3_3 ab3_3 wsrc3 gn3 gn3 sg13_lv_nmos w=0.74u l=0.13u
XPIB3_3 bb3_3 wsrc1 rail3 rail3 sg13_lv_pmos w=1.12u l=0.13u
XNIB3_3 bb3_3 wsrc1 gn3 gn3 sg13_lv_nmos w=0.74u l=0.13u
XTN13_3 wsrc3 bb3_3 yi3_3 gn3 sg13_lv_nmos w=0.74u l=0.13u
XTP13_3 wsrc3 wsrc1 yi3_3 vhi sg13_lv_pmos w=1.12u l=0.13u
XTN23_3 ab3_3 wsrc1 yi3_3 gn3 sg13_lv_nmos w=0.74u l=0.13u
XTP23_3 ab3_3 bb3_3 yi3_3 vhi sg13_lv_pmos w=1.12u l=0.13u
CL3_3 yi3_3 gn3 2f
XPOR3_3 y3_3 yi3_3 rail3 rail3 sg13_lv_pmos w=1.12u l=0.13u
XNOR3_3 y3_3 yi3_3 gn3 gn3 sg13_lv_nmos w=0.74u l=0.13u
CLO3_3 y3_3 gn3 2f
XPIA4_0 ab4_0 y3_0 rail4 rail4 sg13_lv_pmos w=1.12u l=0.13u
XNIA4_0 ab4_0 y3_0 gnd4 gnd4 sg13_lv_nmos w=0.74u l=0.13u
XPIB4_0 bb4_0 y3_3 rail4 rail4 sg13_lv_pmos w=1.12u l=0.13u
XNIB4_0 bb4_0 y3_3 gnd4 gnd4 sg13_lv_nmos w=0.74u l=0.13u
XTN14_0 ab4_0 bb4_0 yi4_0 gnd4 sg13_lv_nmos w=0.74u l=0.13u
XTP14_0 ab4_0 y3_3 yi4_0 vhi sg13_lv_pmos w=1.12u l=0.13u
XTN24_0 y3_0 y3_3 yi4_0 gnd4 sg13_lv_nmos w=0.74u l=0.13u
XTP24_0 y3_0 bb4_0 yi4_0 vhi sg13_lv_pmos w=1.12u l=0.13u
CL4_0 yi4_0 gnd4 2f
XPOR4_0 y4_0 yi4_0 rail4 rail4 sg13_lv_pmos w=1.12u l=0.13u
XNOR4_0 y4_0 yi4_0 gnd4 gnd4 sg13_lv_nmos w=0.74u l=0.13u
CLO4_0 y4_0 gnd4 2f
XPIA4_1 ab4_1 y3_1 rail4 rail4 sg13_lv_pmos w=1.12u l=0.13u
XNIA4_1 ab4_1 y3_1 gnd4 gnd4 sg13_lv_nmos w=0.74u l=0.13u
XPIB4_1 bb4_1 y3_0 rail4 rail4 sg13_lv_pmos w=1.12u l=0.13u
XNIB4_1 bb4_1 y3_0 gnd4 gnd4 sg13_lv_nmos w=0.74u l=0.13u
XTN14_1 y3_1 bb4_1 yi4_1 gnd4 sg13_lv_nmos w=0.74u l=0.13u
XTP14_1 y3_1 y3_0 yi4_1 vhi sg13_lv_pmos w=1.12u l=0.13u
XTN24_1 ab4_1 y3_0 yi4_1 gnd4 sg13_lv_nmos w=0.74u l=0.13u
XTP24_1 ab4_1 bb4_1 yi4_1 vhi sg13_lv_pmos w=1.12u l=0.13u
CL4_1 yi4_1 gnd4 2f
XPOR4_1 y4_1 yi4_1 rail4 rail4 sg13_lv_pmos w=1.12u l=0.13u
XNOR4_1 y4_1 yi4_1 gnd4 gnd4 sg13_lv_nmos w=0.74u l=0.13u
CLO4_1 y4_1 gnd4 2f
XPIA4_2 ab4_2 y3_2 rail4 rail4 sg13_lv_pmos w=1.12u l=0.13u
XNIA4_2 ab4_2 y3_2 gnd4 gnd4 sg13_lv_nmos w=0.74u l=0.13u
XPIB4_2 bb4_2 y3_1 rail4 rail4 sg13_lv_pmos w=1.12u l=0.13u
XNIB4_2 bb4_2 y3_1 gnd4 gnd4 sg13_lv_nmos w=0.74u l=0.13u
XTN14_2 ab4_2 bb4_2 yi4_2 gnd4 sg13_lv_nmos w=0.74u l=0.13u
XTP14_2 ab4_2 y3_1 yi4_2 vhi sg13_lv_pmos w=1.12u l=0.13u
XTN24_2 y3_2 y3_1 yi4_2 gnd4 sg13_lv_nmos w=0.74u l=0.13u
XTP24_2 y3_2 bb4_2 yi4_2 vhi sg13_lv_pmos w=1.12u l=0.13u
CL4_2 yi4_2 gnd4 2f
XPOR4_2 y4_2 yi4_2 rail4 rail4 sg13_lv_pmos w=1.12u l=0.13u
XNOR4_2 y4_2 yi4_2 gnd4 gnd4 sg13_lv_nmos w=0.74u l=0.13u
CLO4_2 y4_2 gnd4 2f
XPIA4_3 ab4_3 y3_3 rail4 rail4 sg13_lv_pmos w=1.12u l=0.13u
XNIA4_3 ab4_3 y3_3 gnd4 gnd4 sg13_lv_nmos w=0.74u l=0.13u
XPIB4_3 bb4_3 y3_2 rail4 rail4 sg13_lv_pmos w=1.12u l=0.13u
XNIB4_3 bb4_3 y3_2 gnd4 gnd4 sg13_lv_nmos w=0.74u l=0.13u
XTN14_3 ab4_3 bb4_3 yi4_3 gnd4 sg13_lv_nmos w=0.74u l=0.13u
XTP14_3 ab4_3 y3_2 yi4_3 vhi sg13_lv_pmos w=1.12u l=0.13u
XTN24_3 y3_3 y3_2 yi4_3 gnd4 sg13_lv_nmos w=0.74u l=0.13u
XTP24_3 y3_3 bb4_3 yi4_3 vhi sg13_lv_pmos w=1.12u l=0.13u
CL4_3 yi4_3 gnd4 2f
XPOR4_3 y4_3 yi4_3 rail4 rail4 sg13_lv_pmos w=1.12u l=0.13u
XNOR4_3 y4_3 yi4_3 gnd4 gnd4 sg13_lv_nmos w=0.74u l=0.13u
CLO4_3 y4_3 gnd4 2f
CXqvs xqvs 0 1
BXqvs 0 xqvs I={ -I(VS) }
RXqvs xqvs 0 0.01
CXqmg xqmg 0 1
BXqmg 0 xqmg I={ I(VMG3) }
RXqmg xqmg 0 0.01
CXqmgd xqmgd 0 1
BXqmgd 0 xqmgd I={ I(VMGD) }
RXqmgd xqmgd 0 0.01
CXqrd xqrd 0 1
BXqrd 0 xqrd I={ -I(VRD) }
RXqrd xqrd 0 0.01
CXqin xqin 0 1
BXqin 0 xqin I={ I(VW0)+I(VW1)+I(VW2)+I(VW3) }
RXqin xqin 0 0.01
.print tran V(rail3) V(xqvs) V(xqmg) V(xqmgd) V(xqrd) V(xqin) V(y3_0) V(y3_1) V(y3_2) V(y3_3) V(y4_0) V(y4_1) V(y4_2) V(y4_3)
.tran 4p 8000p 0 8p
.end
