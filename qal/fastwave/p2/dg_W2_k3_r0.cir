.hdl "/usr/local/share/xyce/verilog-a/psp103/psp103.va"
.include "/usr/local/src/kestrel/sim/models/sg13g2_psp103_tt.lib"
.include "/usr/local/src/stat-sim/qal/sg13lv_compat.sp"
.OPTIONS TIMEINT METHOD=GEAR RELTOL=1e-6 ABSTOL=1e-15 CHGTOL=1e-17
VS rail3 0 PWL(0 0 200p 0 700p 1.65 6000p 1.65)
VHI vhi 0 2.4
VMG3 gn3 0 0
VMGD gnd4 0 0
VRD rail4 0 0
VW0 wsrc0 gn3 1.2
VW1 wsrc1 gn3 0
VW2 wsrc2 gn3 1.2
VW3 wsrc3 gn3 1.2
XPIA3_0 ab3_0 wsrc0 rail3 rail3 sg13_lv_pmos w=1.12u l=0.13u
XNIA3_0 ab3_0 wsrc0 gn3 gn3 sg13_lv_nmos w=0.74u l=0.13u
XPIB3_0 bb3_0 wsrc2 rail3 rail3 sg13_lv_pmos w=1.12u l=0.13u
XNIB3_0 bb3_0 wsrc2 gn3 gn3 sg13_lv_nmos w=0.74u l=0.13u
XTN13_0 wsrc0 bb3_0 y3_0 gn3 sg13_lv_nmos w=0.74u l=0.13u
XTP13_0 wsrc0 wsrc2 y3_0 vhi sg13_lv_pmos w=1.12u l=0.13u
XTN23_0 ab3_0 wsrc2 y3_0 gn3 sg13_lv_nmos w=0.74u l=0.13u
XTP23_0 ab3_0 bb3_0 y3_0 vhi sg13_lv_pmos w=1.12u l=0.13u
CL3_0 y3_0 gn3 2f
XPIA3_1 ab3_1 wsrc1 rail3 rail3 sg13_lv_pmos w=1.12u l=0.13u
XNIA3_1 ab3_1 wsrc1 gn3 gn3 sg13_lv_nmos w=0.74u l=0.13u
XPIB3_1 bb3_1 wsrc3 rail3 rail3 sg13_lv_pmos w=1.12u l=0.13u
XNIB3_1 bb3_1 wsrc3 gn3 gn3 sg13_lv_nmos w=0.74u l=0.13u
XTN13_1 wsrc1 bb3_1 y3_1 gn3 sg13_lv_nmos w=0.74u l=0.13u
XTP13_1 wsrc1 wsrc3 y3_1 vhi sg13_lv_pmos w=1.12u l=0.13u
XTN23_1 ab3_1 wsrc3 y3_1 gn3 sg13_lv_nmos w=0.74u l=0.13u
XTP23_1 ab3_1 bb3_1 y3_1 vhi sg13_lv_pmos w=1.12u l=0.13u
CL3_1 y3_1 gn3 2f
XPIA3_2 ab3_2 wsrc2 rail3 rail3 sg13_lv_pmos w=1.12u l=0.13u
XNIA3_2 ab3_2 wsrc2 gn3 gn3 sg13_lv_nmos w=0.74u l=0.13u
XPIB3_2 bb3_2 wsrc0 rail3 rail3 sg13_lv_pmos w=1.12u l=0.13u
XNIB3_2 bb3_2 wsrc0 gn3 gn3 sg13_lv_nmos w=0.74u l=0.13u
XTN13_2 ab3_2 bb3_2 y3_2 gn3 sg13_lv_nmos w=0.74u l=0.13u
XTP13_2 ab3_2 wsrc0 y3_2 vhi sg13_lv_pmos w=1.12u l=0.13u
XTN23_2 wsrc2 wsrc0 y3_2 gn3 sg13_lv_nmos w=0.74u l=0.13u
XTP23_2 wsrc2 bb3_2 y3_2 vhi sg13_lv_pmos w=1.12u l=0.13u
CL3_2 y3_2 gn3 2f
XPIA3_3 ab3_3 wsrc3 rail3 rail3 sg13_lv_pmos w=1.12u l=0.13u
XNIA3_3 ab3_3 wsrc3 gn3 gn3 sg13_lv_nmos w=0.74u l=0.13u
XPIB3_3 bb3_3 wsrc1 rail3 rail3 sg13_lv_pmos w=1.12u l=0.13u
XNIB3_3 bb3_3 wsrc1 gn3 gn3 sg13_lv_nmos w=0.74u l=0.13u
XTN13_3 ab3_3 bb3_3 y3_3 gn3 sg13_lv_nmos w=0.74u l=0.13u
XTP13_3 ab3_3 wsrc1 y3_3 vhi sg13_lv_pmos w=1.12u l=0.13u
XTN23_3 wsrc3 wsrc1 y3_3 gn3 sg13_lv_nmos w=0.74u l=0.13u
XTP23_3 wsrc3 bb3_3 y3_3 vhi sg13_lv_pmos w=1.12u l=0.13u
CL3_3 y3_3 gn3 2f
VAM0 ytap0 y3_0 0
VAM1 ytap1 y3_1 0
VAM2 ytap2 y3_2 0
VAM3 ytap3 y3_3 0
CWs4_0d ytap0 0 0.418700f
RWs4_0 ytap0 a4_0 1.977600
CWs4_0r a4_0 0 0.418700f
CWr4_0d ytap3 0 5.645650f
RWr4_0 ytap3 b4_0 26.666700
CWr4_0r b4_0 0 5.645650f
XPIA4_0 ab4_0 a4_0 rail4 rail4 sg13_lv_pmos w=1.12u l=0.13u
XNIA4_0 ab4_0 a4_0 gnd4 gnd4 sg13_lv_nmos w=0.74u l=0.13u
XPIB4_0 bb4_0 b4_0 rail4 rail4 sg13_lv_pmos w=1.12u l=0.13u
XNIB4_0 bb4_0 b4_0 gnd4 gnd4 sg13_lv_nmos w=0.74u l=0.13u
XTN14_0 a4_0 bb4_0 y4_0 gnd4 sg13_lv_nmos w=0.74u l=0.13u
XTP14_0 a4_0 b4_0 y4_0 vhi sg13_lv_pmos w=1.12u l=0.13u
XTN24_0 ab4_0 b4_0 y4_0 gnd4 sg13_lv_nmos w=0.74u l=0.13u
XTP24_0 ab4_0 bb4_0 y4_0 vhi sg13_lv_pmos w=1.12u l=0.13u
CL4_0 y4_0 gnd4 2f
CWs4_1d ytap1 0 0.418700f
RWs4_1 ytap1 a4_1 1.977600
CWs4_1r a4_1 0 0.418700f
CWr4_1d ytap0 0 5.645650f
RWr4_1 ytap0 b4_1 26.666700
CWr4_1r b4_1 0 5.645650f
XPIA4_1 ab4_1 a4_1 rail4 rail4 sg13_lv_pmos w=1.12u l=0.13u
XNIA4_1 ab4_1 a4_1 gnd4 gnd4 sg13_lv_nmos w=0.74u l=0.13u
XPIB4_1 bb4_1 b4_1 rail4 rail4 sg13_lv_pmos w=1.12u l=0.13u
XNIB4_1 bb4_1 b4_1 gnd4 gnd4 sg13_lv_nmos w=0.74u l=0.13u
XTN14_1 ab4_1 bb4_1 y4_1 gnd4 sg13_lv_nmos w=0.74u l=0.13u
XTP14_1 ab4_1 b4_1 y4_1 vhi sg13_lv_pmos w=1.12u l=0.13u
XTN24_1 a4_1 b4_1 y4_1 gnd4 sg13_lv_nmos w=0.74u l=0.13u
XTP24_1 a4_1 bb4_1 y4_1 vhi sg13_lv_pmos w=1.12u l=0.13u
CL4_1 y4_1 gnd4 2f
CWs4_2d ytap2 0 0.418700f
RWs4_2 ytap2 a4_2 1.977600
CWs4_2r a4_2 0 0.418700f
CWr4_2d ytap1 0 5.645650f
RWr4_2 ytap1 b4_2 26.666700
CWr4_2r b4_2 0 5.645650f
XPIA4_2 ab4_2 a4_2 rail4 rail4 sg13_lv_pmos w=1.12u l=0.13u
XNIA4_2 ab4_2 a4_2 gnd4 gnd4 sg13_lv_nmos w=0.74u l=0.13u
XPIB4_2 bb4_2 b4_2 rail4 rail4 sg13_lv_pmos w=1.12u l=0.13u
XNIB4_2 bb4_2 b4_2 gnd4 gnd4 sg13_lv_nmos w=0.74u l=0.13u
XTN14_2 a4_2 bb4_2 y4_2 gnd4 sg13_lv_nmos w=0.74u l=0.13u
XTP14_2 a4_2 b4_2 y4_2 vhi sg13_lv_pmos w=1.12u l=0.13u
XTN24_2 ab4_2 b4_2 y4_2 gnd4 sg13_lv_nmos w=0.74u l=0.13u
XTP24_2 ab4_2 bb4_2 y4_2 vhi sg13_lv_pmos w=1.12u l=0.13u
CL4_2 y4_2 gnd4 2f
CWs4_3d ytap3 0 0.418700f
RWs4_3 ytap3 a4_3 1.977600
CWs4_3r a4_3 0 0.418700f
CWr4_3d ytap2 0 5.645650f
RWr4_3 ytap2 b4_3 26.666700
CWr4_3r b4_3 0 5.645650f
XPIA4_3 ab4_3 a4_3 rail4 rail4 sg13_lv_pmos w=1.12u l=0.13u
XNIA4_3 ab4_3 a4_3 gnd4 gnd4 sg13_lv_nmos w=0.74u l=0.13u
XPIB4_3 bb4_3 b4_3 rail4 rail4 sg13_lv_pmos w=1.12u l=0.13u
XNIB4_3 bb4_3 b4_3 gnd4 gnd4 sg13_lv_nmos w=0.74u l=0.13u
XTN14_3 a4_3 bb4_3 y4_3 gnd4 sg13_lv_nmos w=0.74u l=0.13u
XTP14_3 a4_3 b4_3 y4_3 vhi sg13_lv_pmos w=1.12u l=0.13u
XTN24_3 ab4_3 b4_3 y4_3 gnd4 sg13_lv_nmos w=0.74u l=0.13u
XTP24_3 ab4_3 bb4_3 y4_3 vhi sg13_lv_pmos w=1.12u l=0.13u
CL4_3 y4_3 gnd4 2f
.print tran V(rail3) V(y3_0) V(y3_1) V(y3_2) V(y3_3) I(VAM0) I(VAM1) I(VAM2) I(VAM3) V(ab4_0) V(ab4_1) V(ab4_2) V(ab4_3) V(bb4_0) V(bb4_1) V(bb4_2) V(bb4_3) V(y4_0) V(y4_1) V(y4_2) V(y4_3)
.tran 2p 3000p 0 4p
.end
