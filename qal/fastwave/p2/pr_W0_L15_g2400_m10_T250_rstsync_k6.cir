.hdl "/usr/local/share/xyce/verilog-a/psp103/psp103.va"
.include "/usr/local/src/kestrel/sim/models/sg13g2_psp103_tt.lib"
.include "/usr/local/src/stat-sim/qal/sg13lv_compat.sp"
.OPTIONS TIMEINT METHOD=GEAR RELTOL=1e-6 ABSTOL=1e-15 CHGTOL=1e-17
VHI vhi 0 2.4
VH0 h0 0 0
VH1 h1 0 0
VH2 h2 0 1.2
VH3 h3 0 0
VMG1 gn1 0 0
XPIA1_0 ab1_0 h0 rail1 rail1 sg13_lv_pmos w=1.12u l=0.13u
XNIA1_0 ab1_0 h0 gn1 gn1 sg13_lv_nmos w=0.74u l=0.13u
XPIB1_0 bb1_0 h2 rail1 rail1 sg13_lv_pmos w=1.12u l=0.13u
XNIB1_0 bb1_0 h2 gn1 gn1 sg13_lv_nmos w=0.74u l=0.13u
XTN11_0 ab1_0 bb1_0 yi1_0 gn1 sg13_lv_nmos w=0.74u l=0.13u
XTP11_0 ab1_0 h2 yi1_0 vhi sg13_lv_pmos w=1.12u l=0.13u
XTN21_0 h0 h2 yi1_0 gn1 sg13_lv_nmos w=0.74u l=0.13u
XTP21_0 h0 bb1_0 yi1_0 vhi sg13_lv_pmos w=1.12u l=0.13u
CL1_0 yi1_0 gn1 2f
XPOR1_0 y1_0 yi1_0 rail1 rail1 sg13_lv_pmos w=1.12u l=0.13u
XNOR1_0 y1_0 yi1_0 gn1 gn1 sg13_lv_nmos w=0.74u l=0.13u
CLO1_0 y1_0 gn1 2f
XPIA1_1 ab1_1 h1 rail1 rail1 sg13_lv_pmos w=1.12u l=0.13u
XNIA1_1 ab1_1 h1 gn1 gn1 sg13_lv_nmos w=0.74u l=0.13u
XPIB1_1 bb1_1 h3 rail1 rail1 sg13_lv_pmos w=1.12u l=0.13u
XNIB1_1 bb1_1 h3 gn1 gn1 sg13_lv_nmos w=0.74u l=0.13u
XTN11_1 h1 bb1_1 yi1_1 gn1 sg13_lv_nmos w=0.74u l=0.13u
XTP11_1 h1 h3 yi1_1 vhi sg13_lv_pmos w=1.12u l=0.13u
XTN21_1 ab1_1 h3 yi1_1 gn1 sg13_lv_nmos w=0.74u l=0.13u
XTP21_1 ab1_1 bb1_1 yi1_1 vhi sg13_lv_pmos w=1.12u l=0.13u
CL1_1 yi1_1 gn1 2f
XPOR1_1 y1_1 yi1_1 rail1 rail1 sg13_lv_pmos w=1.12u l=0.13u
XNOR1_1 y1_1 yi1_1 gn1 gn1 sg13_lv_nmos w=0.74u l=0.13u
CLO1_1 y1_1 gn1 2f
XPIA1_2 ab1_2 h2 rail1 rail1 sg13_lv_pmos w=1.12u l=0.13u
XNIA1_2 ab1_2 h2 gn1 gn1 sg13_lv_nmos w=0.74u l=0.13u
XPIB1_2 bb1_2 h0 rail1 rail1 sg13_lv_pmos w=1.12u l=0.13u
XNIB1_2 bb1_2 h0 gn1 gn1 sg13_lv_nmos w=0.74u l=0.13u
XTN11_2 h2 bb1_2 yi1_2 gn1 sg13_lv_nmos w=0.74u l=0.13u
XTP11_2 h2 h0 yi1_2 vhi sg13_lv_pmos w=1.12u l=0.13u
XTN21_2 ab1_2 h0 yi1_2 gn1 sg13_lv_nmos w=0.74u l=0.13u
XTP21_2 ab1_2 bb1_2 yi1_2 vhi sg13_lv_pmos w=1.12u l=0.13u
CL1_2 yi1_2 gn1 2f
XPOR1_2 y1_2 yi1_2 rail1 rail1 sg13_lv_pmos w=1.12u l=0.13u
XNOR1_2 y1_2 yi1_2 gn1 gn1 sg13_lv_nmos w=0.74u l=0.13u
CLO1_2 y1_2 gn1 2f
XPIA1_3 ab1_3 h3 rail1 rail1 sg13_lv_pmos w=1.12u l=0.13u
XNIA1_3 ab1_3 h3 gn1 gn1 sg13_lv_nmos w=0.74u l=0.13u
XPIB1_3 bb1_3 h1 rail1 rail1 sg13_lv_pmos w=1.12u l=0.13u
XNIB1_3 bb1_3 h1 gn1 gn1 sg13_lv_nmos w=0.74u l=0.13u
XTN11_3 ab1_3 bb1_3 yi1_3 gn1 sg13_lv_nmos w=0.74u l=0.13u
XTP11_3 ab1_3 h1 yi1_3 vhi sg13_lv_pmos w=1.12u l=0.13u
XTN21_3 h3 h1 yi1_3 gn1 sg13_lv_nmos w=0.74u l=0.13u
XTP21_3 h3 bb1_3 yi1_3 vhi sg13_lv_pmos w=1.12u l=0.13u
CL1_3 yi1_3 gn1 2f
XPOR1_3 y1_3 yi1_3 rail1 rail1 sg13_lv_pmos w=1.12u l=0.13u
XNOR1_3 y1_3 yi1_3 gn1 gn1 sg13_lv_nmos w=0.74u l=0.13u
CLO1_3 y1_3 gn1 2f
VMG2 gn2 0 0
XPIA2_0 ab2_0 y1_0 rail2 rail2 sg13_lv_pmos w=1.12u l=0.13u
XNIA2_0 ab2_0 y1_0 gn2 gn2 sg13_lv_nmos w=0.74u l=0.13u
XPIB2_0 bb2_0 y1_3 rail2 rail2 sg13_lv_pmos w=1.12u l=0.13u
XNIB2_0 bb2_0 y1_3 gn2 gn2 sg13_lv_nmos w=0.74u l=0.13u
XTN12_0 ab2_0 bb2_0 yi2_0 gn2 sg13_lv_nmos w=0.74u l=0.13u
XTP12_0 ab2_0 y1_3 yi2_0 vhi sg13_lv_pmos w=1.12u l=0.13u
XTN22_0 y1_0 y1_3 yi2_0 gn2 sg13_lv_nmos w=0.74u l=0.13u
XTP22_0 y1_0 bb2_0 yi2_0 vhi sg13_lv_pmos w=1.12u l=0.13u
CL2_0 yi2_0 gn2 2f
XPOR2_0 y2_0 yi2_0 rail2 rail2 sg13_lv_pmos w=1.12u l=0.13u
XNOR2_0 y2_0 yi2_0 gn2 gn2 sg13_lv_nmos w=0.74u l=0.13u
CLO2_0 y2_0 gn2 2f
XPIA2_1 ab2_1 y1_1 rail2 rail2 sg13_lv_pmos w=1.12u l=0.13u
XNIA2_1 ab2_1 y1_1 gn2 gn2 sg13_lv_nmos w=0.74u l=0.13u
XPIB2_1 bb2_1 y1_0 rail2 rail2 sg13_lv_pmos w=1.12u l=0.13u
XNIB2_1 bb2_1 y1_0 gn2 gn2 sg13_lv_nmos w=0.74u l=0.13u
XTN12_1 ab2_1 bb2_1 yi2_1 gn2 sg13_lv_nmos w=0.74u l=0.13u
XTP12_1 ab2_1 y1_0 yi2_1 vhi sg13_lv_pmos w=1.12u l=0.13u
XTN22_1 y1_1 y1_0 yi2_1 gn2 sg13_lv_nmos w=0.74u l=0.13u
XTP22_1 y1_1 bb2_1 yi2_1 vhi sg13_lv_pmos w=1.12u l=0.13u
CL2_1 yi2_1 gn2 2f
XPOR2_1 y2_1 yi2_1 rail2 rail2 sg13_lv_pmos w=1.12u l=0.13u
XNOR2_1 y2_1 yi2_1 gn2 gn2 sg13_lv_nmos w=0.74u l=0.13u
CLO2_1 y2_1 gn2 2f
XPIA2_2 ab2_2 y1_2 rail2 rail2 sg13_lv_pmos w=1.12u l=0.13u
XNIA2_2 ab2_2 y1_2 gn2 gn2 sg13_lv_nmos w=0.74u l=0.13u
XPIB2_2 bb2_2 y1_1 rail2 rail2 sg13_lv_pmos w=1.12u l=0.13u
XNIB2_2 bb2_2 y1_1 gn2 gn2 sg13_lv_nmos w=0.74u l=0.13u
XTN12_2 ab2_2 bb2_2 yi2_2 gn2 sg13_lv_nmos w=0.74u l=0.13u
XTP12_2 ab2_2 y1_1 yi2_2 vhi sg13_lv_pmos w=1.12u l=0.13u
XTN22_2 y1_2 y1_1 yi2_2 gn2 sg13_lv_nmos w=0.74u l=0.13u
XTP22_2 y1_2 bb2_2 yi2_2 vhi sg13_lv_pmos w=1.12u l=0.13u
CL2_2 yi2_2 gn2 2f
XPOR2_2 y2_2 yi2_2 rail2 rail2 sg13_lv_pmos w=1.12u l=0.13u
XNOR2_2 y2_2 yi2_2 gn2 gn2 sg13_lv_nmos w=0.74u l=0.13u
CLO2_2 y2_2 gn2 2f
XPIA2_3 ab2_3 y1_3 rail2 rail2 sg13_lv_pmos w=1.12u l=0.13u
XNIA2_3 ab2_3 y1_3 gn2 gn2 sg13_lv_nmos w=0.74u l=0.13u
XPIB2_3 bb2_3 y1_2 rail2 rail2 sg13_lv_pmos w=1.12u l=0.13u
XNIB2_3 bb2_3 y1_2 gn2 gn2 sg13_lv_nmos w=0.74u l=0.13u
XTN12_3 y1_3 bb2_3 yi2_3 gn2 sg13_lv_nmos w=0.74u l=0.13u
XTP12_3 y1_3 y1_2 yi2_3 vhi sg13_lv_pmos w=1.12u l=0.13u
XTN22_3 ab2_3 y1_2 yi2_3 gn2 sg13_lv_nmos w=0.74u l=0.13u
XTP22_3 ab2_3 bb2_3 yi2_3 vhi sg13_lv_pmos w=1.12u l=0.13u
CL2_3 yi2_3 gn2 2f
XPOR2_3 y2_3 yi2_3 rail2 rail2 sg13_lv_pmos w=1.12u l=0.13u
XNOR2_3 y2_3 yi2_3 gn2 gn2 sg13_lv_nmos w=0.74u l=0.13u
CLO2_3 y2_3 gn2 2f
VMG3 gn3 0 0
XPIA3_0 ab3_0 y2_0 rail3 rail3 sg13_lv_pmos w=1.12u l=0.13u
XNIA3_0 ab3_0 y2_0 gn3 gn3 sg13_lv_nmos w=0.74u l=0.13u
XPIB3_0 bb3_0 y2_2 rail3 rail3 sg13_lv_pmos w=1.12u l=0.13u
XNIB3_0 bb3_0 y2_2 gn3 gn3 sg13_lv_nmos w=0.74u l=0.13u
XTN13_0 ab3_0 bb3_0 yi3_0 gn3 sg13_lv_nmos w=0.74u l=0.13u
XTP13_0 ab3_0 y2_2 yi3_0 vhi sg13_lv_pmos w=1.12u l=0.13u
XTN23_0 y2_0 y2_2 yi3_0 gn3 sg13_lv_nmos w=0.74u l=0.13u
XTP23_0 y2_0 bb3_0 yi3_0 vhi sg13_lv_pmos w=1.12u l=0.13u
CL3_0 yi3_0 gn3 2f
XPOR3_0 y3_0 yi3_0 rail3 rail3 sg13_lv_pmos w=1.12u l=0.13u
XNOR3_0 y3_0 yi3_0 gn3 gn3 sg13_lv_nmos w=0.74u l=0.13u
CLO3_0 y3_0 gn3 2f
XPIA3_1 ab3_1 y2_1 rail3 rail3 sg13_lv_pmos w=1.12u l=0.13u
XNIA3_1 ab3_1 y2_1 gn3 gn3 sg13_lv_nmos w=0.74u l=0.13u
XPIB3_1 bb3_1 y2_3 rail3 rail3 sg13_lv_pmos w=1.12u l=0.13u
XNIB3_1 bb3_1 y2_3 gn3 gn3 sg13_lv_nmos w=0.74u l=0.13u
XTN13_1 ab3_1 bb3_1 yi3_1 gn3 sg13_lv_nmos w=0.74u l=0.13u
XTP13_1 ab3_1 y2_3 yi3_1 vhi sg13_lv_pmos w=1.12u l=0.13u
XTN23_1 y2_1 y2_3 yi3_1 gn3 sg13_lv_nmos w=0.74u l=0.13u
XTP23_1 y2_1 bb3_1 yi3_1 vhi sg13_lv_pmos w=1.12u l=0.13u
CL3_1 yi3_1 gn3 2f
XPOR3_1 y3_1 yi3_1 rail3 rail3 sg13_lv_pmos w=1.12u l=0.13u
XNOR3_1 y3_1 yi3_1 gn3 gn3 sg13_lv_nmos w=0.74u l=0.13u
CLO3_1 y3_1 gn3 2f
XPIA3_2 ab3_2 y2_2 rail3 rail3 sg13_lv_pmos w=1.12u l=0.13u
XNIA3_2 ab3_2 y2_2 gn3 gn3 sg13_lv_nmos w=0.74u l=0.13u
XPIB3_2 bb3_2 y2_0 rail3 rail3 sg13_lv_pmos w=1.12u l=0.13u
XNIB3_2 bb3_2 y2_0 gn3 gn3 sg13_lv_nmos w=0.74u l=0.13u
XTN13_2 y2_2 bb3_2 yi3_2 gn3 sg13_lv_nmos w=0.74u l=0.13u
XTP13_2 y2_2 y2_0 yi3_2 vhi sg13_lv_pmos w=1.12u l=0.13u
XTN23_2 ab3_2 y2_0 yi3_2 gn3 sg13_lv_nmos w=0.74u l=0.13u
XTP23_2 ab3_2 bb3_2 yi3_2 vhi sg13_lv_pmos w=1.12u l=0.13u
CL3_2 yi3_2 gn3 2f
XPOR3_2 y3_2 yi3_2 rail3 rail3 sg13_lv_pmos w=1.12u l=0.13u
XNOR3_2 y3_2 yi3_2 gn3 gn3 sg13_lv_nmos w=0.74u l=0.13u
CLO3_2 y3_2 gn3 2f
XPIA3_3 ab3_3 y2_3 rail3 rail3 sg13_lv_pmos w=1.12u l=0.13u
XNIA3_3 ab3_3 y2_3 gn3 gn3 sg13_lv_nmos w=0.74u l=0.13u
XPIB3_3 bb3_3 y2_1 rail3 rail3 sg13_lv_pmos w=1.12u l=0.13u
XNIB3_3 bb3_3 y2_1 gn3 gn3 sg13_lv_nmos w=0.74u l=0.13u
XTN13_3 y2_3 bb3_3 yi3_3 gn3 sg13_lv_nmos w=0.74u l=0.13u
XTP13_3 y2_3 y2_1 yi3_3 vhi sg13_lv_pmos w=1.12u l=0.13u
XTN23_3 ab3_3 y2_1 yi3_3 gn3 sg13_lv_nmos w=0.74u l=0.13u
XTP23_3 ab3_3 bb3_3 yi3_3 vhi sg13_lv_pmos w=1.12u l=0.13u
CL3_3 yi3_3 gn3 2f
XPOR3_3 y3_3 yi3_3 rail3 rail3 sg13_lv_pmos w=1.12u l=0.13u
XNOR3_3 y3_3 yi3_3 gn3 gn3 sg13_lv_nmos w=0.74u l=0.13u
CLO3_3 y3_3 gn3 2f
VMG4 gn4 0 0
XPIA4_0 ab4_0 y3_0 rail4 rail4 sg13_lv_pmos w=1.12u l=0.13u
XNIA4_0 ab4_0 y3_0 gn4 gn4 sg13_lv_nmos w=0.74u l=0.13u
XPIB4_0 bb4_0 y3_3 rail4 rail4 sg13_lv_pmos w=1.12u l=0.13u
XNIB4_0 bb4_0 y3_3 gn4 gn4 sg13_lv_nmos w=0.74u l=0.13u
XTN14_0 ab4_0 bb4_0 yi4_0 gn4 sg13_lv_nmos w=0.74u l=0.13u
XTP14_0 ab4_0 y3_3 yi4_0 vhi sg13_lv_pmos w=1.12u l=0.13u
XTN24_0 y3_0 y3_3 yi4_0 gn4 sg13_lv_nmos w=0.74u l=0.13u
XTP24_0 y3_0 bb4_0 yi4_0 vhi sg13_lv_pmos w=1.12u l=0.13u
CL4_0 yi4_0 gn4 2f
XPOR4_0 y4_0 yi4_0 rail4 rail4 sg13_lv_pmos w=1.12u l=0.13u
XNOR4_0 y4_0 yi4_0 gn4 gn4 sg13_lv_nmos w=0.74u l=0.13u
CLO4_0 y4_0 gn4 2f
XPIA4_1 ab4_1 y3_1 rail4 rail4 sg13_lv_pmos w=1.12u l=0.13u
XNIA4_1 ab4_1 y3_1 gn4 gn4 sg13_lv_nmos w=0.74u l=0.13u
XPIB4_1 bb4_1 y3_0 rail4 rail4 sg13_lv_pmos w=1.12u l=0.13u
XNIB4_1 bb4_1 y3_0 gn4 gn4 sg13_lv_nmos w=0.74u l=0.13u
XTN14_1 y3_1 bb4_1 yi4_1 gn4 sg13_lv_nmos w=0.74u l=0.13u
XTP14_1 y3_1 y3_0 yi4_1 vhi sg13_lv_pmos w=1.12u l=0.13u
XTN24_1 ab4_1 y3_0 yi4_1 gn4 sg13_lv_nmos w=0.74u l=0.13u
XTP24_1 ab4_1 bb4_1 yi4_1 vhi sg13_lv_pmos w=1.12u l=0.13u
CL4_1 yi4_1 gn4 2f
XPOR4_1 y4_1 yi4_1 rail4 rail4 sg13_lv_pmos w=1.12u l=0.13u
XNOR4_1 y4_1 yi4_1 gn4 gn4 sg13_lv_nmos w=0.74u l=0.13u
CLO4_1 y4_1 gn4 2f
XPIA4_2 ab4_2 y3_2 rail4 rail4 sg13_lv_pmos w=1.12u l=0.13u
XNIA4_2 ab4_2 y3_2 gn4 gn4 sg13_lv_nmos w=0.74u l=0.13u
XPIB4_2 bb4_2 y3_1 rail4 rail4 sg13_lv_pmos w=1.12u l=0.13u
XNIB4_2 bb4_2 y3_1 gn4 gn4 sg13_lv_nmos w=0.74u l=0.13u
XTN14_2 ab4_2 bb4_2 yi4_2 gn4 sg13_lv_nmos w=0.74u l=0.13u
XTP14_2 ab4_2 y3_1 yi4_2 vhi sg13_lv_pmos w=1.12u l=0.13u
XTN24_2 y3_2 y3_1 yi4_2 gn4 sg13_lv_nmos w=0.74u l=0.13u
XTP24_2 y3_2 bb4_2 yi4_2 vhi sg13_lv_pmos w=1.12u l=0.13u
CL4_2 yi4_2 gn4 2f
XPOR4_2 y4_2 yi4_2 rail4 rail4 sg13_lv_pmos w=1.12u l=0.13u
XNOR4_2 y4_2 yi4_2 gn4 gn4 sg13_lv_nmos w=0.74u l=0.13u
CLO4_2 y4_2 gn4 2f
XPIA4_3 ab4_3 y3_3 rail4 rail4 sg13_lv_pmos w=1.12u l=0.13u
XNIA4_3 ab4_3 y3_3 gn4 gn4 sg13_lv_nmos w=0.74u l=0.13u
XPIB4_3 bb4_3 y3_2 rail4 rail4 sg13_lv_pmos w=1.12u l=0.13u
XNIB4_3 bb4_3 y3_2 gn4 gn4 sg13_lv_nmos w=0.74u l=0.13u
XTN14_3 ab4_3 bb4_3 yi4_3 gn4 sg13_lv_nmos w=0.74u l=0.13u
XTP14_3 ab4_3 y3_2 yi4_3 vhi sg13_lv_pmos w=1.12u l=0.13u
XTN24_3 y3_3 y3_2 yi4_3 gn4 sg13_lv_nmos w=0.74u l=0.13u
XTP24_3 y3_3 bb4_3 yi4_3 vhi sg13_lv_pmos w=1.12u l=0.13u
CL4_3 yi4_3 gn4 2f
XPOR4_3 y4_3 yi4_3 rail4 rail4 sg13_lv_pmos w=1.12u l=0.13u
XNOR4_3 y4_3 yi4_3 gn4 gn4 sg13_lv_nmos w=0.74u l=0.13u
CLO4_3 y4_3 gn4 2f
VMG5 gn5 0 0
XPIA5_0 ab5_0 y4_0 rail5 rail5 sg13_lv_pmos w=1.12u l=0.13u
XNIA5_0 ab5_0 y4_0 gn5 gn5 sg13_lv_nmos w=0.74u l=0.13u
XPIB5_0 bb5_0 y4_1 rail5 rail5 sg13_lv_pmos w=1.12u l=0.13u
XNIB5_0 bb5_0 y4_1 gn5 gn5 sg13_lv_nmos w=0.74u l=0.13u
XTN15_0 y4_0 bb5_0 yi5_0 gn5 sg13_lv_nmos w=0.74u l=0.13u
XTP15_0 y4_0 y4_1 yi5_0 vhi sg13_lv_pmos w=1.12u l=0.13u
XTN25_0 ab5_0 y4_1 yi5_0 gn5 sg13_lv_nmos w=0.74u l=0.13u
XTP25_0 ab5_0 bb5_0 yi5_0 vhi sg13_lv_pmos w=1.12u l=0.13u
CL5_0 yi5_0 gn5 2f
XPOR5_0 y5_0 yi5_0 rail5 rail5 sg13_lv_pmos w=1.12u l=0.13u
XNOR5_0 y5_0 yi5_0 gn5 gn5 sg13_lv_nmos w=0.74u l=0.13u
CLO5_0 y5_0 gn5 2f
XPIA5_1 ab5_1 y4_1 rail5 rail5 sg13_lv_pmos w=1.12u l=0.13u
XNIA5_1 ab5_1 y4_1 gn5 gn5 sg13_lv_nmos w=0.74u l=0.13u
XPIB5_1 bb5_1 y4_2 rail5 rail5 sg13_lv_pmos w=1.12u l=0.13u
XNIB5_1 bb5_1 y4_2 gn5 gn5 sg13_lv_nmos w=0.74u l=0.13u
XTN15_1 ab5_1 bb5_1 yi5_1 gn5 sg13_lv_nmos w=0.74u l=0.13u
XTP15_1 ab5_1 y4_2 yi5_1 vhi sg13_lv_pmos w=1.12u l=0.13u
XTN25_1 y4_1 y4_2 yi5_1 gn5 sg13_lv_nmos w=0.74u l=0.13u
XTP25_1 y4_1 bb5_1 yi5_1 vhi sg13_lv_pmos w=1.12u l=0.13u
CL5_1 yi5_1 gn5 2f
XPOR5_1 y5_1 yi5_1 rail5 rail5 sg13_lv_pmos w=1.12u l=0.13u
XNOR5_1 y5_1 yi5_1 gn5 gn5 sg13_lv_nmos w=0.74u l=0.13u
CLO5_1 y5_1 gn5 2f
XPIA5_2 ab5_2 y4_2 rail5 rail5 sg13_lv_pmos w=1.12u l=0.13u
XNIA5_2 ab5_2 y4_2 gn5 gn5 sg13_lv_nmos w=0.74u l=0.13u
XPIB5_2 bb5_2 y4_3 rail5 rail5 sg13_lv_pmos w=1.12u l=0.13u
XNIB5_2 bb5_2 y4_3 gn5 gn5 sg13_lv_nmos w=0.74u l=0.13u
XTN15_2 ab5_2 bb5_2 yi5_2 gn5 sg13_lv_nmos w=0.74u l=0.13u
XTP15_2 ab5_2 y4_3 yi5_2 vhi sg13_lv_pmos w=1.12u l=0.13u
XTN25_2 y4_2 y4_3 yi5_2 gn5 sg13_lv_nmos w=0.74u l=0.13u
XTP25_2 y4_2 bb5_2 yi5_2 vhi sg13_lv_pmos w=1.12u l=0.13u
CL5_2 yi5_2 gn5 2f
XPOR5_2 y5_2 yi5_2 rail5 rail5 sg13_lv_pmos w=1.12u l=0.13u
XNOR5_2 y5_2 yi5_2 gn5 gn5 sg13_lv_nmos w=0.74u l=0.13u
CLO5_2 y5_2 gn5 2f
XPIA5_3 ab5_3 y4_3 rail5 rail5 sg13_lv_pmos w=1.12u l=0.13u
XNIA5_3 ab5_3 y4_3 gn5 gn5 sg13_lv_nmos w=0.74u l=0.13u
XPIB5_3 bb5_3 y4_0 rail5 rail5 sg13_lv_pmos w=1.12u l=0.13u
XNIB5_3 bb5_3 y4_0 gn5 gn5 sg13_lv_nmos w=0.74u l=0.13u
XTN15_3 y4_3 bb5_3 yi5_3 gn5 sg13_lv_nmos w=0.74u l=0.13u
XTP15_3 y4_3 y4_0 yi5_3 vhi sg13_lv_pmos w=1.12u l=0.13u
XTN25_3 ab5_3 y4_0 yi5_3 gn5 sg13_lv_nmos w=0.74u l=0.13u
XTP25_3 ab5_3 bb5_3 yi5_3 vhi sg13_lv_pmos w=1.12u l=0.13u
CL5_3 yi5_3 gn5 2f
XPOR5_3 y5_3 yi5_3 rail5 rail5 sg13_lv_pmos w=1.12u l=0.13u
XNOR5_3 y5_3 yi5_3 gn5 gn5 sg13_lv_nmos w=0.74u l=0.13u
CLO5_3 y5_3 gn5 2f
VMG6 gn6 0 0
XPIA6_0 ab6_0 y5_0 rail6 rail6 sg13_lv_pmos w=1.12u l=0.13u
XNIA6_0 ab6_0 y5_0 gn6 gn6 sg13_lv_nmos w=0.74u l=0.13u
XPIB6_0 bb6_0 y5_3 rail6 rail6 sg13_lv_pmos w=1.12u l=0.13u
XNIB6_0 bb6_0 y5_3 gn6 gn6 sg13_lv_nmos w=0.74u l=0.13u
XTN16_0 y5_0 bb6_0 yi6_0 gn6 sg13_lv_nmos w=0.74u l=0.13u
XTP16_0 y5_0 y5_3 yi6_0 vhi sg13_lv_pmos w=1.12u l=0.13u
XTN26_0 ab6_0 y5_3 yi6_0 gn6 sg13_lv_nmos w=0.74u l=0.13u
XTP26_0 ab6_0 bb6_0 yi6_0 vhi sg13_lv_pmos w=1.12u l=0.13u
CL6_0 yi6_0 gn6 2f
XPOR6_0 y6_0 yi6_0 rail6 rail6 sg13_lv_pmos w=1.12u l=0.13u
XNOR6_0 y6_0 yi6_0 gn6 gn6 sg13_lv_nmos w=0.74u l=0.13u
CLO6_0 y6_0 gn6 2f
XPIA6_1 ab6_1 y5_1 rail6 rail6 sg13_lv_pmos w=1.12u l=0.13u
XNIA6_1 ab6_1 y5_1 gn6 gn6 sg13_lv_nmos w=0.74u l=0.13u
XPIB6_1 bb6_1 y5_0 rail6 rail6 sg13_lv_pmos w=1.12u l=0.13u
XNIB6_1 bb6_1 y5_0 gn6 gn6 sg13_lv_nmos w=0.74u l=0.13u
XTN16_1 ab6_1 bb6_1 yi6_1 gn6 sg13_lv_nmos w=0.74u l=0.13u
XTP16_1 ab6_1 y5_0 yi6_1 vhi sg13_lv_pmos w=1.12u l=0.13u
XTN26_1 y5_1 y5_0 yi6_1 gn6 sg13_lv_nmos w=0.74u l=0.13u
XTP26_1 y5_1 bb6_1 yi6_1 vhi sg13_lv_pmos w=1.12u l=0.13u
CL6_1 yi6_1 gn6 2f
XPOR6_1 y6_1 yi6_1 rail6 rail6 sg13_lv_pmos w=1.12u l=0.13u
XNOR6_1 y6_1 yi6_1 gn6 gn6 sg13_lv_nmos w=0.74u l=0.13u
CLO6_1 y6_1 gn6 2f
XPIA6_2 ab6_2 y5_2 rail6 rail6 sg13_lv_pmos w=1.12u l=0.13u
XNIA6_2 ab6_2 y5_2 gn6 gn6 sg13_lv_nmos w=0.74u l=0.13u
XPIB6_2 bb6_2 y5_1 rail6 rail6 sg13_lv_pmos w=1.12u l=0.13u
XNIB6_2 bb6_2 y5_1 gn6 gn6 sg13_lv_nmos w=0.74u l=0.13u
XTN16_2 ab6_2 bb6_2 yi6_2 gn6 sg13_lv_nmos w=0.74u l=0.13u
XTP16_2 ab6_2 y5_1 yi6_2 vhi sg13_lv_pmos w=1.12u l=0.13u
XTN26_2 y5_2 y5_1 yi6_2 gn6 sg13_lv_nmos w=0.74u l=0.13u
XTP26_2 y5_2 bb6_2 yi6_2 vhi sg13_lv_pmos w=1.12u l=0.13u
CL6_2 yi6_2 gn6 2f
XPOR6_2 y6_2 yi6_2 rail6 rail6 sg13_lv_pmos w=1.12u l=0.13u
XNOR6_2 y6_2 yi6_2 gn6 gn6 sg13_lv_nmos w=0.74u l=0.13u
CLO6_2 y6_2 gn6 2f
XPIA6_3 ab6_3 y5_3 rail6 rail6 sg13_lv_pmos w=1.12u l=0.13u
XNIA6_3 ab6_3 y5_3 gn6 gn6 sg13_lv_nmos w=0.74u l=0.13u
XPIB6_3 bb6_3 y5_2 rail6 rail6 sg13_lv_pmos w=1.12u l=0.13u
XNIB6_3 bb6_3 y5_2 gn6 gn6 sg13_lv_nmos w=0.74u l=0.13u
XTN16_3 ab6_3 bb6_3 yi6_3 gn6 sg13_lv_nmos w=0.74u l=0.13u
XTP16_3 ab6_3 y5_2 yi6_3 vhi sg13_lv_pmos w=1.12u l=0.13u
XTN26_3 y5_3 y5_2 yi6_3 gn6 sg13_lv_nmos w=0.74u l=0.13u
XTP26_3 y5_3 bb6_3 yi6_3 vhi sg13_lv_pmos w=1.12u l=0.13u
CL6_3 yi6_3 gn6 2f
XPOR6_3 y6_3 yi6_3 rail6 rail6 sg13_lv_pmos w=1.12u l=0.13u
XNOR6_3 y6_3 yi6_3 gn6 gn6 sg13_lv_nmos w=0.74u l=0.13u
CLO6_3 y6_3 gn6 2f
VMG7 gn7 0 0
XPIA7_0 ab7_0 y6_0 rail7 rail7 sg13_lv_pmos w=1.12u l=0.13u
XNIA7_0 ab7_0 y6_0 gn7 gn7 sg13_lv_nmos w=0.74u l=0.13u
XPIB7_0 bb7_0 y6_2 rail7 rail7 sg13_lv_pmos w=1.12u l=0.13u
XNIB7_0 bb7_0 y6_2 gn7 gn7 sg13_lv_nmos w=0.74u l=0.13u
XTN17_0 ab7_0 bb7_0 yi7_0 gn7 sg13_lv_nmos w=0.74u l=0.13u
XTP17_0 ab7_0 y6_2 yi7_0 vhi sg13_lv_pmos w=1.12u l=0.13u
XTN27_0 y6_0 y6_2 yi7_0 gn7 sg13_lv_nmos w=0.74u l=0.13u
XTP27_0 y6_0 bb7_0 yi7_0 vhi sg13_lv_pmos w=1.12u l=0.13u
CL7_0 yi7_0 gn7 2f
XPOR7_0 y7_0 yi7_0 rail7 rail7 sg13_lv_pmos w=1.12u l=0.13u
XNOR7_0 y7_0 yi7_0 gn7 gn7 sg13_lv_nmos w=0.74u l=0.13u
CLO7_0 y7_0 gn7 2f
XPIA7_1 ab7_1 y6_1 rail7 rail7 sg13_lv_pmos w=1.12u l=0.13u
XNIA7_1 ab7_1 y6_1 gn7 gn7 sg13_lv_nmos w=0.74u l=0.13u
XPIB7_1 bb7_1 y6_3 rail7 rail7 sg13_lv_pmos w=1.12u l=0.13u
XNIB7_1 bb7_1 y6_3 gn7 gn7 sg13_lv_nmos w=0.74u l=0.13u
XTN17_1 y6_1 bb7_1 yi7_1 gn7 sg13_lv_nmos w=0.74u l=0.13u
XTP17_1 y6_1 y6_3 yi7_1 vhi sg13_lv_pmos w=1.12u l=0.13u
XTN27_1 ab7_1 y6_3 yi7_1 gn7 sg13_lv_nmos w=0.74u l=0.13u
XTP27_1 ab7_1 bb7_1 yi7_1 vhi sg13_lv_pmos w=1.12u l=0.13u
CL7_1 yi7_1 gn7 2f
XPOR7_1 y7_1 yi7_1 rail7 rail7 sg13_lv_pmos w=1.12u l=0.13u
XNOR7_1 y7_1 yi7_1 gn7 gn7 sg13_lv_nmos w=0.74u l=0.13u
CLO7_1 y7_1 gn7 2f
XPIA7_2 ab7_2 y6_2 rail7 rail7 sg13_lv_pmos w=1.12u l=0.13u
XNIA7_2 ab7_2 y6_2 gn7 gn7 sg13_lv_nmos w=0.74u l=0.13u
XPIB7_2 bb7_2 y6_0 rail7 rail7 sg13_lv_pmos w=1.12u l=0.13u
XNIB7_2 bb7_2 y6_0 gn7 gn7 sg13_lv_nmos w=0.74u l=0.13u
XTN17_2 y6_2 bb7_2 yi7_2 gn7 sg13_lv_nmos w=0.74u l=0.13u
XTP17_2 y6_2 y6_0 yi7_2 vhi sg13_lv_pmos w=1.12u l=0.13u
XTN27_2 ab7_2 y6_0 yi7_2 gn7 sg13_lv_nmos w=0.74u l=0.13u
XTP27_2 ab7_2 bb7_2 yi7_2 vhi sg13_lv_pmos w=1.12u l=0.13u
CL7_2 yi7_2 gn7 2f
XPOR7_2 y7_2 yi7_2 rail7 rail7 sg13_lv_pmos w=1.12u l=0.13u
XNOR7_2 y7_2 yi7_2 gn7 gn7 sg13_lv_nmos w=0.74u l=0.13u
CLO7_2 y7_2 gn7 2f
XPIA7_3 ab7_3 y6_3 rail7 rail7 sg13_lv_pmos w=1.12u l=0.13u
XNIA7_3 ab7_3 y6_3 gn7 gn7 sg13_lv_nmos w=0.74u l=0.13u
XPIB7_3 bb7_3 y6_1 rail7 rail7 sg13_lv_pmos w=1.12u l=0.13u
XNIB7_3 bb7_3 y6_1 gn7 gn7 sg13_lv_nmos w=0.74u l=0.13u
XTN17_3 ab7_3 bb7_3 yi7_3 gn7 sg13_lv_nmos w=0.74u l=0.13u
XTP17_3 ab7_3 y6_1 yi7_3 vhi sg13_lv_pmos w=1.12u l=0.13u
XTN27_3 y6_3 y6_1 yi7_3 gn7 sg13_lv_nmos w=0.74u l=0.13u
XTP27_3 y6_3 bb7_3 yi7_3 vhi sg13_lv_pmos w=1.12u l=0.13u
CL7_3 yi7_3 gn7 2f
XPOR7_3 y7_3 yi7_3 rail7 rail7 sg13_lv_pmos w=1.12u l=0.13u
XNOR7_3 y7_3 yi7_3 gn7 gn7 sg13_lv_nmos w=0.74u l=0.13u
CLO7_3 y7_3 gn7 2f
CT1 tnk1 0 1093.403292f
L1 tnk1 mid1 15n
R1 mid1 sw1 10
XSWN1 sw1 gt1 rail1 0 sg13_lv_nmos w=10u l=0.13u
XSWP1 sw1 gtp1 rail1 vhi sg13_lv_pmos w=20u l=0.13u
XPK1 sw1 pk1 tnk1 tnk1 sg13_lv_nmos w=1u l=0.13u
CT2 tnk2 0 1120.359093f
L2 tnk2 mid2 15n
R2 mid2 sw2 10
XSWN2 sw2 gt2 rail2 0 sg13_lv_nmos w=10u l=0.13u
XSWP2 sw2 gtp2 rail2 vhi sg13_lv_pmos w=20u l=0.13u
XPK2 sw2 pk2 tnk2 tnk2 sg13_lv_nmos w=1u l=0.13u
CT3 tnk3 0 859.410173f
L3 tnk3 mid3 15n
R3 mid3 sw3 10
XSWN3 sw3 gt3 rail3 0 sg13_lv_nmos w=10u l=0.13u
XSWP3 sw3 gtp3 rail3 vhi sg13_lv_pmos w=20u l=0.13u
XPK3 sw3 pk3 tnk3 tnk3 sg13_lv_nmos w=1u l=0.13u
CT4 tnk4 0 766.690300f
L4 tnk4 mid4 15n
R4 mid4 sw4 10
XSWN4 sw4 gt4 rail4 0 sg13_lv_nmos w=10u l=0.13u
XSWP4 sw4 gtp4 rail4 vhi sg13_lv_pmos w=20u l=0.13u
XPK4 sw4 pk4 tnk4 tnk4 sg13_lv_nmos w=1u l=0.13u
CT5 tnk5 0 999.786728f
L5 tnk5 mid5 15n
R5 mid5 sw5 10
XSWN5 sw5 gt5 rail5 0 sg13_lv_nmos w=10u l=0.13u
XSWP5 sw5 gtp5 rail5 vhi sg13_lv_pmos w=20u l=0.13u
XPK5 sw5 pk5 tnk5 tnk5 sg13_lv_nmos w=1u l=0.13u
CT6 tnk6 0 1098.110203f
L6 tnk6 mid6 15n
R6 mid6 sw6 10
XSWN6 sw6 gt6 rail6 0 sg13_lv_nmos w=10u l=0.13u
XSWP6 sw6 gtp6 rail6 vhi sg13_lv_pmos w=20u l=0.13u
XPK6 sw6 pk6 tnk6 tnk6 sg13_lv_nmos w=1u l=0.13u
CT7 tnk7 0 732.019986f
L7 tnk7 mid7 15n
R7 mid7 sw7 10
XSWN7 sw7 gt7 rail7 0 sg13_lv_nmos w=10u l=0.13u
XSWP7 sw7 gtp7 rail7 vhi sg13_lv_pmos w=20u l=0.13u
XPK7 sw7 pk7 tnk7 tnk7 sg13_lv_nmos w=1u l=0.13u
VGT1 gt1 0 PWL(0 0 198p 0 200p 2.4 359.206p 2.4 361.206p 0)
VGTP1 gtp1 0 PWL(0 2.4 198p 2.4 200p 0 359.206p 0 361.206p 2.4)
VPK1 pk1 0 PWL(0 2.4 198p 2.4 200p 0 359.206p 0 361.206p 2.4)
VGT2 gt2 0 PWL(0 0 203p 0 205p 2.4 352.027p 2.4 354.027p 0)
VGTP2 gtp2 0 PWL(0 2.4 203p 2.4 205p 0 352.027p 0 354.027p 2.4)
VPK2 pk2 0 PWL(0 2.4 203p 2.4 205p 0 352.027p 0 354.027p 2.4)
VGT3 gt3 0 PWL(0 0 208p 0 210p 2.4 348.744p 2.4 350.744p 0)
VGTP3 gtp3 0 PWL(0 2.4 208p 2.4 210p 0 348.744p 0 350.744p 2.4)
VPK3 pk3 0 PWL(0 2.4 208p 2.4 210p 0 348.744p 0 350.744p 2.4)
VGT4 gt4 0 PWL(0 0 213p 0 215p 2.4 351.976p 2.4 353.976p 0)
VGTP4 gtp4 0 PWL(0 2.4 213p 2.4 215p 0 351.976p 0 353.976p 2.4)
VPK4 pk4 0 PWL(0 2.4 213p 2.4 215p 0 351.976p 0 353.976p 2.4)
VGT5 gt5 0 PWL(0 0 218p 0 220p 2.4 360.575p 2.4 362.575p 0)
VGTP5 gtp5 0 PWL(0 2.4 218p 2.4 220p 0 360.575p 0 362.575p 2.4)
VPK5 pk5 0 PWL(0 2.4 218p 2.4 220p 0 360.575p 0 362.575p 2.4)
VGT6 gt6 0 PWL(0 0 223p 0 225p 2.4 2164.32p 2.4)
VGTP6 gtp6 0 PWL(0 2.4 223p 2.4 225p 0 2164.32p 0)
VPK6 pk6 0 PWL(0 2.4 223p 2.4 225p 0 2164.32p 0)
VGT7 gt7 0 0
VGTP7 gtp7 0 2.4
VPK7 pk7 0 2.4
VSzc s_zc 0 1.2
VIzc i_zc 0 PWL(0 1.2 200p 1.2 202p 0)
XPzc o_zc i_zc s_zc s_zc sg13_lv_pmos w=1.12u l=0.13u
XNzc o_zc i_zc 0 0 sg13_lv_nmos w=0.74u l=0.13u
CLzc o_zc 0 2f
.ic V(tnk1)=0.9075 V(rail1)=0 V(sw1)=0.9075 V(tnk2)=0.9075 V(rail2)=0 V(sw2)=0.9075 V(tnk3)=0.9075 V(rail3)=0 V(sw3)=0.9075 V(tnk4)=0.9075 V(rail4)=0 V(sw4)=0.9075 V(tnk5)=0.9075 V(rail5)=0 V(sw5)=0.9075 V(tnk6)=0.9075 V(rail6)=0 V(sw6)=0.9075 V(tnk7)=0.9075 V(rail7)=0 V(sw7)=0.9075
.tran 0.25p 541.079p 0 0.25p
.measure tran T90ZC WHEN V(o_zc)=1.08 RISE=1
.print tran V(rail1) V(rail2) V(rail3) V(rail4) V(rail5) V(rail6) V(rail7) V(tnk1) V(tnk2) V(tnk3) V(tnk4) V(tnk5) V(tnk6) V(tnk7) V(sw1) V(sw2) V(sw3) V(sw4) V(sw5) V(sw6) V(sw7) I(L1) I(L2) I(L3) I(L4) I(L5) I(L6) I(L7) V(y1_0) V(y1_1) V(y1_2) V(y1_3) V(y2_0) V(y2_1) V(y2_2) V(y2_3) V(y3_0) V(y3_1) V(y3_2) V(y3_3) V(y4_0) V(y4_1) V(y4_2) V(y4_3) V(y5_0) V(y5_1) V(y5_2) V(y5_3) V(y6_0) V(y6_1) V(y6_2) V(y6_3) V(y7_0) V(y7_1) V(y7_2) V(y7_3) V(o_zc)
.end
