.hdl "/usr/local/share/xyce/verilog-a/psp103/psp103.va"
.include "/usr/local/src/kestrel/sim/models/sg13g2_psp103_tt.lib"
.include "/usr/local/src/stat-sim/qal/sg13lv_compat.sp"
.OPTIONS TIMEINT METHOD=GEAR RELTOL=1e-6 ABSTOL=1e-15 CHGTOL=1e-17
VHI vhi 0 2.4
VH0 h0 0 0
VH1 h1 0 0
VH2 h2 0 1.2
VH3 h3 0 0
VMG1 gn1 0 0
CWs1_0d h0 0 0.418700f
RWs1_0 h0 a1_0 1.977600
CWs1_0r a1_0 0 0.418700f
CWr1_0d h2 0 5.645650f
RWr1_0 h2 b1_0 26.666700
CWr1_0r b1_0 0 5.645650f
XPIA1_0 ab1_0 a1_0 rail1 rail1 sg13_lv_pmos w=1.12u l=0.13u
XNIA1_0 ab1_0 a1_0 gn1 gn1 sg13_lv_nmos w=0.74u l=0.13u
XPIB1_0 bb1_0 b1_0 rail1 rail1 sg13_lv_pmos w=1.12u l=0.13u
XNIB1_0 bb1_0 b1_0 gn1 gn1 sg13_lv_nmos w=0.74u l=0.13u
XTN11_0 ab1_0 bb1_0 yi1_0 gn1 sg13_lv_nmos w=0.74u l=0.13u
XTP11_0 ab1_0 b1_0 yi1_0 vhi sg13_lv_pmos w=1.12u l=0.13u
XTN21_0 a1_0 b1_0 yi1_0 gn1 sg13_lv_nmos w=0.74u l=0.13u
XTP21_0 a1_0 bb1_0 yi1_0 vhi sg13_lv_pmos w=1.12u l=0.13u
CL1_0 yi1_0 gn1 2f
XPOR1_0 y1_0 yi1_0 rail1 rail1 sg13_lv_pmos w=1.12u l=0.13u
XNOR1_0 y1_0 yi1_0 gn1 gn1 sg13_lv_nmos w=0.74u l=0.13u
CLO1_0 y1_0 gn1 2f
CWs1_1d h1 0 0.418700f
RWs1_1 h1 a1_1 1.977600
CWs1_1r a1_1 0 0.418700f
CWr1_1d h3 0 5.645650f
RWr1_1 h3 b1_1 26.666700
CWr1_1r b1_1 0 5.645650f
XPIA1_1 ab1_1 a1_1 rail1 rail1 sg13_lv_pmos w=1.12u l=0.13u
XNIA1_1 ab1_1 a1_1 gn1 gn1 sg13_lv_nmos w=0.74u l=0.13u
XPIB1_1 bb1_1 b1_1 rail1 rail1 sg13_lv_pmos w=1.12u l=0.13u
XNIB1_1 bb1_1 b1_1 gn1 gn1 sg13_lv_nmos w=0.74u l=0.13u
XTN11_1 a1_1 bb1_1 yi1_1 gn1 sg13_lv_nmos w=0.74u l=0.13u
XTP11_1 a1_1 b1_1 yi1_1 vhi sg13_lv_pmos w=1.12u l=0.13u
XTN21_1 ab1_1 b1_1 yi1_1 gn1 sg13_lv_nmos w=0.74u l=0.13u
XTP21_1 ab1_1 bb1_1 yi1_1 vhi sg13_lv_pmos w=1.12u l=0.13u
CL1_1 yi1_1 gn1 2f
XPOR1_1 y1_1 yi1_1 rail1 rail1 sg13_lv_pmos w=1.12u l=0.13u
XNOR1_1 y1_1 yi1_1 gn1 gn1 sg13_lv_nmos w=0.74u l=0.13u
CLO1_1 y1_1 gn1 2f
CWs1_2d h2 0 0.418700f
RWs1_2 h2 a1_2 1.977600
CWs1_2r a1_2 0 0.418700f
CWr1_2d h0 0 5.645650f
RWr1_2 h0 b1_2 26.666700
CWr1_2r b1_2 0 5.645650f
XPIA1_2 ab1_2 a1_2 rail1 rail1 sg13_lv_pmos w=1.12u l=0.13u
XNIA1_2 ab1_2 a1_2 gn1 gn1 sg13_lv_nmos w=0.74u l=0.13u
XPIB1_2 bb1_2 b1_2 rail1 rail1 sg13_lv_pmos w=1.12u l=0.13u
XNIB1_2 bb1_2 b1_2 gn1 gn1 sg13_lv_nmos w=0.74u l=0.13u
XTN11_2 a1_2 bb1_2 yi1_2 gn1 sg13_lv_nmos w=0.74u l=0.13u
XTP11_2 a1_2 b1_2 yi1_2 vhi sg13_lv_pmos w=1.12u l=0.13u
XTN21_2 ab1_2 b1_2 yi1_2 gn1 sg13_lv_nmos w=0.74u l=0.13u
XTP21_2 ab1_2 bb1_2 yi1_2 vhi sg13_lv_pmos w=1.12u l=0.13u
CL1_2 yi1_2 gn1 2f
XPOR1_2 y1_2 yi1_2 rail1 rail1 sg13_lv_pmos w=1.12u l=0.13u
XNOR1_2 y1_2 yi1_2 gn1 gn1 sg13_lv_nmos w=0.74u l=0.13u
CLO1_2 y1_2 gn1 2f
CWs1_3d h3 0 0.418700f
RWs1_3 h3 a1_3 1.977600
CWs1_3r a1_3 0 0.418700f
CWr1_3d h1 0 5.645650f
RWr1_3 h1 b1_3 26.666700
CWr1_3r b1_3 0 5.645650f
XPIA1_3 ab1_3 a1_3 rail1 rail1 sg13_lv_pmos w=1.12u l=0.13u
XNIA1_3 ab1_3 a1_3 gn1 gn1 sg13_lv_nmos w=0.74u l=0.13u
XPIB1_3 bb1_3 b1_3 rail1 rail1 sg13_lv_pmos w=1.12u l=0.13u
XNIB1_3 bb1_3 b1_3 gn1 gn1 sg13_lv_nmos w=0.74u l=0.13u
XTN11_3 ab1_3 bb1_3 yi1_3 gn1 sg13_lv_nmos w=0.74u l=0.13u
XTP11_3 ab1_3 b1_3 yi1_3 vhi sg13_lv_pmos w=1.12u l=0.13u
XTN21_3 a1_3 b1_3 yi1_3 gn1 sg13_lv_nmos w=0.74u l=0.13u
XTP21_3 a1_3 bb1_3 yi1_3 vhi sg13_lv_pmos w=1.12u l=0.13u
CL1_3 yi1_3 gn1 2f
XPOR1_3 y1_3 yi1_3 rail1 rail1 sg13_lv_pmos w=1.12u l=0.13u
XNOR1_3 y1_3 yi1_3 gn1 gn1 sg13_lv_nmos w=0.74u l=0.13u
CLO1_3 y1_3 gn1 2f
VMG2 gn2 0 0
CWs2_0d y1_0 0 0.418700f
RWs2_0 y1_0 a2_0 1.977600
CWs2_0r a2_0 0 0.418700f
CWr2_0d y1_3 0 5.645650f
RWr2_0 y1_3 b2_0 26.666700
CWr2_0r b2_0 0 5.645650f
XPIA2_0 ab2_0 a2_0 rail2 rail2 sg13_lv_pmos w=1.12u l=0.13u
XNIA2_0 ab2_0 a2_0 gn2 gn2 sg13_lv_nmos w=0.74u l=0.13u
XPIB2_0 bb2_0 b2_0 rail2 rail2 sg13_lv_pmos w=1.12u l=0.13u
XNIB2_0 bb2_0 b2_0 gn2 gn2 sg13_lv_nmos w=0.74u l=0.13u
XTN12_0 ab2_0 bb2_0 yi2_0 gn2 sg13_lv_nmos w=0.74u l=0.13u
XTP12_0 ab2_0 b2_0 yi2_0 vhi sg13_lv_pmos w=1.12u l=0.13u
XTN22_0 a2_0 b2_0 yi2_0 gn2 sg13_lv_nmos w=0.74u l=0.13u
XTP22_0 a2_0 bb2_0 yi2_0 vhi sg13_lv_pmos w=1.12u l=0.13u
CL2_0 yi2_0 gn2 2f
XPOR2_0 y2_0 yi2_0 rail2 rail2 sg13_lv_pmos w=1.12u l=0.13u
XNOR2_0 y2_0 yi2_0 gn2 gn2 sg13_lv_nmos w=0.74u l=0.13u
CLO2_0 y2_0 gn2 2f
CWs2_1d y1_1 0 0.418700f
RWs2_1 y1_1 a2_1 1.977600
CWs2_1r a2_1 0 0.418700f
CWr2_1d y1_0 0 5.645650f
RWr2_1 y1_0 b2_1 26.666700
CWr2_1r b2_1 0 5.645650f
XPIA2_1 ab2_1 a2_1 rail2 rail2 sg13_lv_pmos w=1.12u l=0.13u
XNIA2_1 ab2_1 a2_1 gn2 gn2 sg13_lv_nmos w=0.74u l=0.13u
XPIB2_1 bb2_1 b2_1 rail2 rail2 sg13_lv_pmos w=1.12u l=0.13u
XNIB2_1 bb2_1 b2_1 gn2 gn2 sg13_lv_nmos w=0.74u l=0.13u
XTN12_1 ab2_1 bb2_1 yi2_1 gn2 sg13_lv_nmos w=0.74u l=0.13u
XTP12_1 ab2_1 b2_1 yi2_1 vhi sg13_lv_pmos w=1.12u l=0.13u
XTN22_1 a2_1 b2_1 yi2_1 gn2 sg13_lv_nmos w=0.74u l=0.13u
XTP22_1 a2_1 bb2_1 yi2_1 vhi sg13_lv_pmos w=1.12u l=0.13u
CL2_1 yi2_1 gn2 2f
XPOR2_1 y2_1 yi2_1 rail2 rail2 sg13_lv_pmos w=1.12u l=0.13u
XNOR2_1 y2_1 yi2_1 gn2 gn2 sg13_lv_nmos w=0.74u l=0.13u
CLO2_1 y2_1 gn2 2f
CWs2_2d y1_2 0 0.418700f
RWs2_2 y1_2 a2_2 1.977600
CWs2_2r a2_2 0 0.418700f
CWr2_2d y1_1 0 5.645650f
RWr2_2 y1_1 b2_2 26.666700
CWr2_2r b2_2 0 5.645650f
XPIA2_2 ab2_2 a2_2 rail2 rail2 sg13_lv_pmos w=1.12u l=0.13u
XNIA2_2 ab2_2 a2_2 gn2 gn2 sg13_lv_nmos w=0.74u l=0.13u
XPIB2_2 bb2_2 b2_2 rail2 rail2 sg13_lv_pmos w=1.12u l=0.13u
XNIB2_2 bb2_2 b2_2 gn2 gn2 sg13_lv_nmos w=0.74u l=0.13u
XTN12_2 ab2_2 bb2_2 yi2_2 gn2 sg13_lv_nmos w=0.74u l=0.13u
XTP12_2 ab2_2 b2_2 yi2_2 vhi sg13_lv_pmos w=1.12u l=0.13u
XTN22_2 a2_2 b2_2 yi2_2 gn2 sg13_lv_nmos w=0.74u l=0.13u
XTP22_2 a2_2 bb2_2 yi2_2 vhi sg13_lv_pmos w=1.12u l=0.13u
CL2_2 yi2_2 gn2 2f
XPOR2_2 y2_2 yi2_2 rail2 rail2 sg13_lv_pmos w=1.12u l=0.13u
XNOR2_2 y2_2 yi2_2 gn2 gn2 sg13_lv_nmos w=0.74u l=0.13u
CLO2_2 y2_2 gn2 2f
CWs2_3d y1_3 0 0.418700f
RWs2_3 y1_3 a2_3 1.977600
CWs2_3r a2_3 0 0.418700f
CWr2_3d y1_2 0 5.645650f
RWr2_3 y1_2 b2_3 26.666700
CWr2_3r b2_3 0 5.645650f
XPIA2_3 ab2_3 a2_3 rail2 rail2 sg13_lv_pmos w=1.12u l=0.13u
XNIA2_3 ab2_3 a2_3 gn2 gn2 sg13_lv_nmos w=0.74u l=0.13u
XPIB2_3 bb2_3 b2_3 rail2 rail2 sg13_lv_pmos w=1.12u l=0.13u
XNIB2_3 bb2_3 b2_3 gn2 gn2 sg13_lv_nmos w=0.74u l=0.13u
XTN12_3 a2_3 bb2_3 yi2_3 gn2 sg13_lv_nmos w=0.74u l=0.13u
XTP12_3 a2_3 b2_3 yi2_3 vhi sg13_lv_pmos w=1.12u l=0.13u
XTN22_3 ab2_3 b2_3 yi2_3 gn2 sg13_lv_nmos w=0.74u l=0.13u
XTP22_3 ab2_3 bb2_3 yi2_3 vhi sg13_lv_pmos w=1.12u l=0.13u
CL2_3 yi2_3 gn2 2f
XPOR2_3 y2_3 yi2_3 rail2 rail2 sg13_lv_pmos w=1.12u l=0.13u
XNOR2_3 y2_3 yi2_3 gn2 gn2 sg13_lv_nmos w=0.74u l=0.13u
CLO2_3 y2_3 gn2 2f
VMG3 gn3 0 0
CWs3_0d y2_0 0 0.418700f
RWs3_0 y2_0 a3_0 1.977600
CWs3_0r a3_0 0 0.418700f
CWr3_0d y2_2 0 5.645650f
RWr3_0 y2_2 b3_0 26.666700
CWr3_0r b3_0 0 5.645650f
XPIA3_0 ab3_0 a3_0 rail3 rail3 sg13_lv_pmos w=1.12u l=0.13u
XNIA3_0 ab3_0 a3_0 gn3 gn3 sg13_lv_nmos w=0.74u l=0.13u
XPIB3_0 bb3_0 b3_0 rail3 rail3 sg13_lv_pmos w=1.12u l=0.13u
XNIB3_0 bb3_0 b3_0 gn3 gn3 sg13_lv_nmos w=0.74u l=0.13u
XTN13_0 ab3_0 bb3_0 yi3_0 gn3 sg13_lv_nmos w=0.74u l=0.13u
XTP13_0 ab3_0 b3_0 yi3_0 vhi sg13_lv_pmos w=1.12u l=0.13u
XTN23_0 a3_0 b3_0 yi3_0 gn3 sg13_lv_nmos w=0.74u l=0.13u
XTP23_0 a3_0 bb3_0 yi3_0 vhi sg13_lv_pmos w=1.12u l=0.13u
CL3_0 yi3_0 gn3 2f
XPOR3_0 y3_0 yi3_0 rail3 rail3 sg13_lv_pmos w=1.12u l=0.13u
XNOR3_0 y3_0 yi3_0 gn3 gn3 sg13_lv_nmos w=0.74u l=0.13u
CLO3_0 y3_0 gn3 2f
CWs3_1d y2_1 0 0.418700f
RWs3_1 y2_1 a3_1 1.977600
CWs3_1r a3_1 0 0.418700f
CWr3_1d y2_3 0 5.645650f
RWr3_1 y2_3 b3_1 26.666700
CWr3_1r b3_1 0 5.645650f
XPIA3_1 ab3_1 a3_1 rail3 rail3 sg13_lv_pmos w=1.12u l=0.13u
XNIA3_1 ab3_1 a3_1 gn3 gn3 sg13_lv_nmos w=0.74u l=0.13u
XPIB3_1 bb3_1 b3_1 rail3 rail3 sg13_lv_pmos w=1.12u l=0.13u
XNIB3_1 bb3_1 b3_1 gn3 gn3 sg13_lv_nmos w=0.74u l=0.13u
XTN13_1 ab3_1 bb3_1 yi3_1 gn3 sg13_lv_nmos w=0.74u l=0.13u
XTP13_1 ab3_1 b3_1 yi3_1 vhi sg13_lv_pmos w=1.12u l=0.13u
XTN23_1 a3_1 b3_1 yi3_1 gn3 sg13_lv_nmos w=0.74u l=0.13u
XTP23_1 a3_1 bb3_1 yi3_1 vhi sg13_lv_pmos w=1.12u l=0.13u
CL3_1 yi3_1 gn3 2f
XPOR3_1 y3_1 yi3_1 rail3 rail3 sg13_lv_pmos w=1.12u l=0.13u
XNOR3_1 y3_1 yi3_1 gn3 gn3 sg13_lv_nmos w=0.74u l=0.13u
CLO3_1 y3_1 gn3 2f
CWs3_2d y2_2 0 0.418700f
RWs3_2 y2_2 a3_2 1.977600
CWs3_2r a3_2 0 0.418700f
CWr3_2d y2_0 0 5.645650f
RWr3_2 y2_0 b3_2 26.666700
CWr3_2r b3_2 0 5.645650f
XPIA3_2 ab3_2 a3_2 rail3 rail3 sg13_lv_pmos w=1.12u l=0.13u
XNIA3_2 ab3_2 a3_2 gn3 gn3 sg13_lv_nmos w=0.74u l=0.13u
XPIB3_2 bb3_2 b3_2 rail3 rail3 sg13_lv_pmos w=1.12u l=0.13u
XNIB3_2 bb3_2 b3_2 gn3 gn3 sg13_lv_nmos w=0.74u l=0.13u
XTN13_2 a3_2 bb3_2 yi3_2 gn3 sg13_lv_nmos w=0.74u l=0.13u
XTP13_2 a3_2 b3_2 yi3_2 vhi sg13_lv_pmos w=1.12u l=0.13u
XTN23_2 ab3_2 b3_2 yi3_2 gn3 sg13_lv_nmos w=0.74u l=0.13u
XTP23_2 ab3_2 bb3_2 yi3_2 vhi sg13_lv_pmos w=1.12u l=0.13u
CL3_2 yi3_2 gn3 2f
XPOR3_2 y3_2 yi3_2 rail3 rail3 sg13_lv_pmos w=1.12u l=0.13u
XNOR3_2 y3_2 yi3_2 gn3 gn3 sg13_lv_nmos w=0.74u l=0.13u
CLO3_2 y3_2 gn3 2f
CWs3_3d y2_3 0 0.418700f
RWs3_3 y2_3 a3_3 1.977600
CWs3_3r a3_3 0 0.418700f
CWr3_3d y2_1 0 5.645650f
RWr3_3 y2_1 b3_3 26.666700
CWr3_3r b3_3 0 5.645650f
XPIA3_3 ab3_3 a3_3 rail3 rail3 sg13_lv_pmos w=1.12u l=0.13u
XNIA3_3 ab3_3 a3_3 gn3 gn3 sg13_lv_nmos w=0.74u l=0.13u
XPIB3_3 bb3_3 b3_3 rail3 rail3 sg13_lv_pmos w=1.12u l=0.13u
XNIB3_3 bb3_3 b3_3 gn3 gn3 sg13_lv_nmos w=0.74u l=0.13u
XTN13_3 a3_3 bb3_3 yi3_3 gn3 sg13_lv_nmos w=0.74u l=0.13u
XTP13_3 a3_3 b3_3 yi3_3 vhi sg13_lv_pmos w=1.12u l=0.13u
XTN23_3 ab3_3 b3_3 yi3_3 gn3 sg13_lv_nmos w=0.74u l=0.13u
XTP23_3 ab3_3 bb3_3 yi3_3 vhi sg13_lv_pmos w=1.12u l=0.13u
CL3_3 yi3_3 gn3 2f
XPOR3_3 y3_3 yi3_3 rail3 rail3 sg13_lv_pmos w=1.12u l=0.13u
XNOR3_3 y3_3 yi3_3 gn3 gn3 sg13_lv_nmos w=0.74u l=0.13u
CLO3_3 y3_3 gn3 2f
VMG4 gn4 0 0
CWs4_0d y3_0 0 0.418700f
RWs4_0 y3_0 a4_0 1.977600
CWs4_0r a4_0 0 0.418700f
CWr4_0d y3_3 0 5.645650f
RWr4_0 y3_3 b4_0 26.666700
CWr4_0r b4_0 0 5.645650f
XPIA4_0 ab4_0 a4_0 rail4 rail4 sg13_lv_pmos w=1.12u l=0.13u
XNIA4_0 ab4_0 a4_0 gn4 gn4 sg13_lv_nmos w=0.74u l=0.13u
XPIB4_0 bb4_0 b4_0 rail4 rail4 sg13_lv_pmos w=1.12u l=0.13u
XNIB4_0 bb4_0 b4_0 gn4 gn4 sg13_lv_nmos w=0.74u l=0.13u
XTN14_0 ab4_0 bb4_0 yi4_0 gn4 sg13_lv_nmos w=0.74u l=0.13u
XTP14_0 ab4_0 b4_0 yi4_0 vhi sg13_lv_pmos w=1.12u l=0.13u
XTN24_0 a4_0 b4_0 yi4_0 gn4 sg13_lv_nmos w=0.74u l=0.13u
XTP24_0 a4_0 bb4_0 yi4_0 vhi sg13_lv_pmos w=1.12u l=0.13u
CL4_0 yi4_0 gn4 2f
XPOR4_0 y4_0 yi4_0 rail4 rail4 sg13_lv_pmos w=1.12u l=0.13u
XNOR4_0 y4_0 yi4_0 gn4 gn4 sg13_lv_nmos w=0.74u l=0.13u
CLO4_0 y4_0 gn4 2f
CWs4_1d y3_1 0 0.418700f
RWs4_1 y3_1 a4_1 1.977600
CWs4_1r a4_1 0 0.418700f
CWr4_1d y3_0 0 5.645650f
RWr4_1 y3_0 b4_1 26.666700
CWr4_1r b4_1 0 5.645650f
XPIA4_1 ab4_1 a4_1 rail4 rail4 sg13_lv_pmos w=1.12u l=0.13u
XNIA4_1 ab4_1 a4_1 gn4 gn4 sg13_lv_nmos w=0.74u l=0.13u
XPIB4_1 bb4_1 b4_1 rail4 rail4 sg13_lv_pmos w=1.12u l=0.13u
XNIB4_1 bb4_1 b4_1 gn4 gn4 sg13_lv_nmos w=0.74u l=0.13u
XTN14_1 a4_1 bb4_1 yi4_1 gn4 sg13_lv_nmos w=0.74u l=0.13u
XTP14_1 a4_1 b4_1 yi4_1 vhi sg13_lv_pmos w=1.12u l=0.13u
XTN24_1 ab4_1 b4_1 yi4_1 gn4 sg13_lv_nmos w=0.74u l=0.13u
XTP24_1 ab4_1 bb4_1 yi4_1 vhi sg13_lv_pmos w=1.12u l=0.13u
CL4_1 yi4_1 gn4 2f
XPOR4_1 y4_1 yi4_1 rail4 rail4 sg13_lv_pmos w=1.12u l=0.13u
XNOR4_1 y4_1 yi4_1 gn4 gn4 sg13_lv_nmos w=0.74u l=0.13u
CLO4_1 y4_1 gn4 2f
CWs4_2d y3_2 0 0.418700f
RWs4_2 y3_2 a4_2 1.977600
CWs4_2r a4_2 0 0.418700f
CWr4_2d y3_1 0 5.645650f
RWr4_2 y3_1 b4_2 26.666700
CWr4_2r b4_2 0 5.645650f
XPIA4_2 ab4_2 a4_2 rail4 rail4 sg13_lv_pmos w=1.12u l=0.13u
XNIA4_2 ab4_2 a4_2 gn4 gn4 sg13_lv_nmos w=0.74u l=0.13u
XPIB4_2 bb4_2 b4_2 rail4 rail4 sg13_lv_pmos w=1.12u l=0.13u
XNIB4_2 bb4_2 b4_2 gn4 gn4 sg13_lv_nmos w=0.74u l=0.13u
XTN14_2 ab4_2 bb4_2 yi4_2 gn4 sg13_lv_nmos w=0.74u l=0.13u
XTP14_2 ab4_2 b4_2 yi4_2 vhi sg13_lv_pmos w=1.12u l=0.13u
XTN24_2 a4_2 b4_2 yi4_2 gn4 sg13_lv_nmos w=0.74u l=0.13u
XTP24_2 a4_2 bb4_2 yi4_2 vhi sg13_lv_pmos w=1.12u l=0.13u
CL4_2 yi4_2 gn4 2f
XPOR4_2 y4_2 yi4_2 rail4 rail4 sg13_lv_pmos w=1.12u l=0.13u
XNOR4_2 y4_2 yi4_2 gn4 gn4 sg13_lv_nmos w=0.74u l=0.13u
CLO4_2 y4_2 gn4 2f
CWs4_3d y3_3 0 0.418700f
RWs4_3 y3_3 a4_3 1.977600
CWs4_3r a4_3 0 0.418700f
CWr4_3d y3_2 0 5.645650f
RWr4_3 y3_2 b4_3 26.666700
CWr4_3r b4_3 0 5.645650f
XPIA4_3 ab4_3 a4_3 rail4 rail4 sg13_lv_pmos w=1.12u l=0.13u
XNIA4_3 ab4_3 a4_3 gn4 gn4 sg13_lv_nmos w=0.74u l=0.13u
XPIB4_3 bb4_3 b4_3 rail4 rail4 sg13_lv_pmos w=1.12u l=0.13u
XNIB4_3 bb4_3 b4_3 gn4 gn4 sg13_lv_nmos w=0.74u l=0.13u
XTN14_3 ab4_3 bb4_3 yi4_3 gn4 sg13_lv_nmos w=0.74u l=0.13u
XTP14_3 ab4_3 b4_3 yi4_3 vhi sg13_lv_pmos w=1.12u l=0.13u
XTN24_3 a4_3 b4_3 yi4_3 gn4 sg13_lv_nmos w=0.74u l=0.13u
XTP24_3 a4_3 bb4_3 yi4_3 vhi sg13_lv_pmos w=1.12u l=0.13u
CL4_3 yi4_3 gn4 2f
XPOR4_3 y4_3 yi4_3 rail4 rail4 sg13_lv_pmos w=1.12u l=0.13u
XNOR4_3 y4_3 yi4_3 gn4 gn4 sg13_lv_nmos w=0.74u l=0.13u
CLO4_3 y4_3 gn4 2f
VMG5 gn5 0 0
CWs5_0d y4_0 0 0.418700f
RWs5_0 y4_0 a5_0 1.977600
CWs5_0r a5_0 0 0.418700f
CWr5_0d y4_1 0 5.645650f
RWr5_0 y4_1 b5_0 26.666700
CWr5_0r b5_0 0 5.645650f
XPIA5_0 ab5_0 a5_0 rail5 rail5 sg13_lv_pmos w=1.12u l=0.13u
XNIA5_0 ab5_0 a5_0 gn5 gn5 sg13_lv_nmos w=0.74u l=0.13u
XPIB5_0 bb5_0 b5_0 rail5 rail5 sg13_lv_pmos w=1.12u l=0.13u
XNIB5_0 bb5_0 b5_0 gn5 gn5 sg13_lv_nmos w=0.74u l=0.13u
XTN15_0 a5_0 bb5_0 yi5_0 gn5 sg13_lv_nmos w=0.74u l=0.13u
XTP15_0 a5_0 b5_0 yi5_0 vhi sg13_lv_pmos w=1.12u l=0.13u
XTN25_0 ab5_0 b5_0 yi5_0 gn5 sg13_lv_nmos w=0.74u l=0.13u
XTP25_0 ab5_0 bb5_0 yi5_0 vhi sg13_lv_pmos w=1.12u l=0.13u
CL5_0 yi5_0 gn5 2f
XPOR5_0 y5_0 yi5_0 rail5 rail5 sg13_lv_pmos w=1.12u l=0.13u
XNOR5_0 y5_0 yi5_0 gn5 gn5 sg13_lv_nmos w=0.74u l=0.13u
CLO5_0 y5_0 gn5 2f
CWs5_1d y4_1 0 0.418700f
RWs5_1 y4_1 a5_1 1.977600
CWs5_1r a5_1 0 0.418700f
CWr5_1d y4_2 0 5.645650f
RWr5_1 y4_2 b5_1 26.666700
CWr5_1r b5_1 0 5.645650f
XPIA5_1 ab5_1 a5_1 rail5 rail5 sg13_lv_pmos w=1.12u l=0.13u
XNIA5_1 ab5_1 a5_1 gn5 gn5 sg13_lv_nmos w=0.74u l=0.13u
XPIB5_1 bb5_1 b5_1 rail5 rail5 sg13_lv_pmos w=1.12u l=0.13u
XNIB5_1 bb5_1 b5_1 gn5 gn5 sg13_lv_nmos w=0.74u l=0.13u
XTN15_1 ab5_1 bb5_1 yi5_1 gn5 sg13_lv_nmos w=0.74u l=0.13u
XTP15_1 ab5_1 b5_1 yi5_1 vhi sg13_lv_pmos w=1.12u l=0.13u
XTN25_1 a5_1 b5_1 yi5_1 gn5 sg13_lv_nmos w=0.74u l=0.13u
XTP25_1 a5_1 bb5_1 yi5_1 vhi sg13_lv_pmos w=1.12u l=0.13u
CL5_1 yi5_1 gn5 2f
XPOR5_1 y5_1 yi5_1 rail5 rail5 sg13_lv_pmos w=1.12u l=0.13u
XNOR5_1 y5_1 yi5_1 gn5 gn5 sg13_lv_nmos w=0.74u l=0.13u
CLO5_1 y5_1 gn5 2f
CWs5_2d y4_2 0 0.418700f
RWs5_2 y4_2 a5_2 1.977600
CWs5_2r a5_2 0 0.418700f
CWr5_2d y4_3 0 5.645650f
RWr5_2 y4_3 b5_2 26.666700
CWr5_2r b5_2 0 5.645650f
XPIA5_2 ab5_2 a5_2 rail5 rail5 sg13_lv_pmos w=1.12u l=0.13u
XNIA5_2 ab5_2 a5_2 gn5 gn5 sg13_lv_nmos w=0.74u l=0.13u
XPIB5_2 bb5_2 b5_2 rail5 rail5 sg13_lv_pmos w=1.12u l=0.13u
XNIB5_2 bb5_2 b5_2 gn5 gn5 sg13_lv_nmos w=0.74u l=0.13u
XTN15_2 ab5_2 bb5_2 yi5_2 gn5 sg13_lv_nmos w=0.74u l=0.13u
XTP15_2 ab5_2 b5_2 yi5_2 vhi sg13_lv_pmos w=1.12u l=0.13u
XTN25_2 a5_2 b5_2 yi5_2 gn5 sg13_lv_nmos w=0.74u l=0.13u
XTP25_2 a5_2 bb5_2 yi5_2 vhi sg13_lv_pmos w=1.12u l=0.13u
CL5_2 yi5_2 gn5 2f
XPOR5_2 y5_2 yi5_2 rail5 rail5 sg13_lv_pmos w=1.12u l=0.13u
XNOR5_2 y5_2 yi5_2 gn5 gn5 sg13_lv_nmos w=0.74u l=0.13u
CLO5_2 y5_2 gn5 2f
CWs5_3d y4_3 0 0.418700f
RWs5_3 y4_3 a5_3 1.977600
CWs5_3r a5_3 0 0.418700f
CWr5_3d y4_0 0 5.645650f
RWr5_3 y4_0 b5_3 26.666700
CWr5_3r b5_3 0 5.645650f
XPIA5_3 ab5_3 a5_3 rail5 rail5 sg13_lv_pmos w=1.12u l=0.13u
XNIA5_3 ab5_3 a5_3 gn5 gn5 sg13_lv_nmos w=0.74u l=0.13u
XPIB5_3 bb5_3 b5_3 rail5 rail5 sg13_lv_pmos w=1.12u l=0.13u
XNIB5_3 bb5_3 b5_3 gn5 gn5 sg13_lv_nmos w=0.74u l=0.13u
XTN15_3 a5_3 bb5_3 yi5_3 gn5 sg13_lv_nmos w=0.74u l=0.13u
XTP15_3 a5_3 b5_3 yi5_3 vhi sg13_lv_pmos w=1.12u l=0.13u
XTN25_3 ab5_3 b5_3 yi5_3 gn5 sg13_lv_nmos w=0.74u l=0.13u
XTP25_3 ab5_3 bb5_3 yi5_3 vhi sg13_lv_pmos w=1.12u l=0.13u
CL5_3 yi5_3 gn5 2f
XPOR5_3 y5_3 yi5_3 rail5 rail5 sg13_lv_pmos w=1.12u l=0.13u
XNOR5_3 y5_3 yi5_3 gn5 gn5 sg13_lv_nmos w=0.74u l=0.13u
CLO5_3 y5_3 gn5 2f
VMG6 gn6 0 0
CWs6_0d y5_0 0 0.418700f
RWs6_0 y5_0 a6_0 1.977600
CWs6_0r a6_0 0 0.418700f
CWr6_0d y5_3 0 5.645650f
RWr6_0 y5_3 b6_0 26.666700
CWr6_0r b6_0 0 5.645650f
XPIA6_0 ab6_0 a6_0 rail6 rail6 sg13_lv_pmos w=1.12u l=0.13u
XNIA6_0 ab6_0 a6_0 gn6 gn6 sg13_lv_nmos w=0.74u l=0.13u
XPIB6_0 bb6_0 b6_0 rail6 rail6 sg13_lv_pmos w=1.12u l=0.13u
XNIB6_0 bb6_0 b6_0 gn6 gn6 sg13_lv_nmos w=0.74u l=0.13u
XTN16_0 a6_0 bb6_0 yi6_0 gn6 sg13_lv_nmos w=0.74u l=0.13u
XTP16_0 a6_0 b6_0 yi6_0 vhi sg13_lv_pmos w=1.12u l=0.13u
XTN26_0 ab6_0 b6_0 yi6_0 gn6 sg13_lv_nmos w=0.74u l=0.13u
XTP26_0 ab6_0 bb6_0 yi6_0 vhi sg13_lv_pmos w=1.12u l=0.13u
CL6_0 yi6_0 gn6 2f
XPOR6_0 y6_0 yi6_0 rail6 rail6 sg13_lv_pmos w=1.12u l=0.13u
XNOR6_0 y6_0 yi6_0 gn6 gn6 sg13_lv_nmos w=0.74u l=0.13u
CLO6_0 y6_0 gn6 2f
CWs6_1d y5_1 0 0.418700f
RWs6_1 y5_1 a6_1 1.977600
CWs6_1r a6_1 0 0.418700f
CWr6_1d y5_0 0 5.645650f
RWr6_1 y5_0 b6_1 26.666700
CWr6_1r b6_1 0 5.645650f
XPIA6_1 ab6_1 a6_1 rail6 rail6 sg13_lv_pmos w=1.12u l=0.13u
XNIA6_1 ab6_1 a6_1 gn6 gn6 sg13_lv_nmos w=0.74u l=0.13u
XPIB6_1 bb6_1 b6_1 rail6 rail6 sg13_lv_pmos w=1.12u l=0.13u
XNIB6_1 bb6_1 b6_1 gn6 gn6 sg13_lv_nmos w=0.74u l=0.13u
XTN16_1 ab6_1 bb6_1 yi6_1 gn6 sg13_lv_nmos w=0.74u l=0.13u
XTP16_1 ab6_1 b6_1 yi6_1 vhi sg13_lv_pmos w=1.12u l=0.13u
XTN26_1 a6_1 b6_1 yi6_1 gn6 sg13_lv_nmos w=0.74u l=0.13u
XTP26_1 a6_1 bb6_1 yi6_1 vhi sg13_lv_pmos w=1.12u l=0.13u
CL6_1 yi6_1 gn6 2f
XPOR6_1 y6_1 yi6_1 rail6 rail6 sg13_lv_pmos w=1.12u l=0.13u
XNOR6_1 y6_1 yi6_1 gn6 gn6 sg13_lv_nmos w=0.74u l=0.13u
CLO6_1 y6_1 gn6 2f
CWs6_2d y5_2 0 0.418700f
RWs6_2 y5_2 a6_2 1.977600
CWs6_2r a6_2 0 0.418700f
CWr6_2d y5_1 0 5.645650f
RWr6_2 y5_1 b6_2 26.666700
CWr6_2r b6_2 0 5.645650f
XPIA6_2 ab6_2 a6_2 rail6 rail6 sg13_lv_pmos w=1.12u l=0.13u
XNIA6_2 ab6_2 a6_2 gn6 gn6 sg13_lv_nmos w=0.74u l=0.13u
XPIB6_2 bb6_2 b6_2 rail6 rail6 sg13_lv_pmos w=1.12u l=0.13u
XNIB6_2 bb6_2 b6_2 gn6 gn6 sg13_lv_nmos w=0.74u l=0.13u
XTN16_2 ab6_2 bb6_2 yi6_2 gn6 sg13_lv_nmos w=0.74u l=0.13u
XTP16_2 ab6_2 b6_2 yi6_2 vhi sg13_lv_pmos w=1.12u l=0.13u
XTN26_2 a6_2 b6_2 yi6_2 gn6 sg13_lv_nmos w=0.74u l=0.13u
XTP26_2 a6_2 bb6_2 yi6_2 vhi sg13_lv_pmos w=1.12u l=0.13u
CL6_2 yi6_2 gn6 2f
XPOR6_2 y6_2 yi6_2 rail6 rail6 sg13_lv_pmos w=1.12u l=0.13u
XNOR6_2 y6_2 yi6_2 gn6 gn6 sg13_lv_nmos w=0.74u l=0.13u
CLO6_2 y6_2 gn6 2f
CWs6_3d y5_3 0 0.418700f
RWs6_3 y5_3 a6_3 1.977600
CWs6_3r a6_3 0 0.418700f
CWr6_3d y5_2 0 5.645650f
RWr6_3 y5_2 b6_3 26.666700
CWr6_3r b6_3 0 5.645650f
XPIA6_3 ab6_3 a6_3 rail6 rail6 sg13_lv_pmos w=1.12u l=0.13u
XNIA6_3 ab6_3 a6_3 gn6 gn6 sg13_lv_nmos w=0.74u l=0.13u
XPIB6_3 bb6_3 b6_3 rail6 rail6 sg13_lv_pmos w=1.12u l=0.13u
XNIB6_3 bb6_3 b6_3 gn6 gn6 sg13_lv_nmos w=0.74u l=0.13u
XTN16_3 ab6_3 bb6_3 yi6_3 gn6 sg13_lv_nmos w=0.74u l=0.13u
XTP16_3 ab6_3 b6_3 yi6_3 vhi sg13_lv_pmos w=1.12u l=0.13u
XTN26_3 a6_3 b6_3 yi6_3 gn6 sg13_lv_nmos w=0.74u l=0.13u
XTP26_3 a6_3 bb6_3 yi6_3 vhi sg13_lv_pmos w=1.12u l=0.13u
CL6_3 yi6_3 gn6 2f
XPOR6_3 y6_3 yi6_3 rail6 rail6 sg13_lv_pmos w=1.12u l=0.13u
XNOR6_3 y6_3 yi6_3 gn6 gn6 sg13_lv_nmos w=0.74u l=0.13u
CLO6_3 y6_3 gn6 2f
VMG7 gn7 0 0
CWs7_0d y6_0 0 0.418700f
RWs7_0 y6_0 a7_0 1.977600
CWs7_0r a7_0 0 0.418700f
CWr7_0d y6_2 0 5.645650f
RWr7_0 y6_2 b7_0 26.666700
CWr7_0r b7_0 0 5.645650f
XPIA7_0 ab7_0 a7_0 rail7 rail7 sg13_lv_pmos w=1.12u l=0.13u
XNIA7_0 ab7_0 a7_0 gn7 gn7 sg13_lv_nmos w=0.74u l=0.13u
XPIB7_0 bb7_0 b7_0 rail7 rail7 sg13_lv_pmos w=1.12u l=0.13u
XNIB7_0 bb7_0 b7_0 gn7 gn7 sg13_lv_nmos w=0.74u l=0.13u
XTN17_0 ab7_0 bb7_0 yi7_0 gn7 sg13_lv_nmos w=0.74u l=0.13u
XTP17_0 ab7_0 b7_0 yi7_0 vhi sg13_lv_pmos w=1.12u l=0.13u
XTN27_0 a7_0 b7_0 yi7_0 gn7 sg13_lv_nmos w=0.74u l=0.13u
XTP27_0 a7_0 bb7_0 yi7_0 vhi sg13_lv_pmos w=1.12u l=0.13u
CL7_0 yi7_0 gn7 2f
XPOR7_0 y7_0 yi7_0 rail7 rail7 sg13_lv_pmos w=1.12u l=0.13u
XNOR7_0 y7_0 yi7_0 gn7 gn7 sg13_lv_nmos w=0.74u l=0.13u
CLO7_0 y7_0 gn7 2f
CWs7_1d y6_1 0 0.418700f
RWs7_1 y6_1 a7_1 1.977600
CWs7_1r a7_1 0 0.418700f
CWr7_1d y6_3 0 5.645650f
RWr7_1 y6_3 b7_1 26.666700
CWr7_1r b7_1 0 5.645650f
XPIA7_1 ab7_1 a7_1 rail7 rail7 sg13_lv_pmos w=1.12u l=0.13u
XNIA7_1 ab7_1 a7_1 gn7 gn7 sg13_lv_nmos w=0.74u l=0.13u
XPIB7_1 bb7_1 b7_1 rail7 rail7 sg13_lv_pmos w=1.12u l=0.13u
XNIB7_1 bb7_1 b7_1 gn7 gn7 sg13_lv_nmos w=0.74u l=0.13u
XTN17_1 a7_1 bb7_1 yi7_1 gn7 sg13_lv_nmos w=0.74u l=0.13u
XTP17_1 a7_1 b7_1 yi7_1 vhi sg13_lv_pmos w=1.12u l=0.13u
XTN27_1 ab7_1 b7_1 yi7_1 gn7 sg13_lv_nmos w=0.74u l=0.13u
XTP27_1 ab7_1 bb7_1 yi7_1 vhi sg13_lv_pmos w=1.12u l=0.13u
CL7_1 yi7_1 gn7 2f
XPOR7_1 y7_1 yi7_1 rail7 rail7 sg13_lv_pmos w=1.12u l=0.13u
XNOR7_1 y7_1 yi7_1 gn7 gn7 sg13_lv_nmos w=0.74u l=0.13u
CLO7_1 y7_1 gn7 2f
CWs7_2d y6_2 0 0.418700f
RWs7_2 y6_2 a7_2 1.977600
CWs7_2r a7_2 0 0.418700f
CWr7_2d y6_0 0 5.645650f
RWr7_2 y6_0 b7_2 26.666700
CWr7_2r b7_2 0 5.645650f
XPIA7_2 ab7_2 a7_2 rail7 rail7 sg13_lv_pmos w=1.12u l=0.13u
XNIA7_2 ab7_2 a7_2 gn7 gn7 sg13_lv_nmos w=0.74u l=0.13u
XPIB7_2 bb7_2 b7_2 rail7 rail7 sg13_lv_pmos w=1.12u l=0.13u
XNIB7_2 bb7_2 b7_2 gn7 gn7 sg13_lv_nmos w=0.74u l=0.13u
XTN17_2 a7_2 bb7_2 yi7_2 gn7 sg13_lv_nmos w=0.74u l=0.13u
XTP17_2 a7_2 b7_2 yi7_2 vhi sg13_lv_pmos w=1.12u l=0.13u
XTN27_2 ab7_2 b7_2 yi7_2 gn7 sg13_lv_nmos w=0.74u l=0.13u
XTP27_2 ab7_2 bb7_2 yi7_2 vhi sg13_lv_pmos w=1.12u l=0.13u
CL7_2 yi7_2 gn7 2f
XPOR7_2 y7_2 yi7_2 rail7 rail7 sg13_lv_pmos w=1.12u l=0.13u
XNOR7_2 y7_2 yi7_2 gn7 gn7 sg13_lv_nmos w=0.74u l=0.13u
CLO7_2 y7_2 gn7 2f
CWs7_3d y6_3 0 0.418700f
RWs7_3 y6_3 a7_3 1.977600
CWs7_3r a7_3 0 0.418700f
CWr7_3d y6_1 0 5.645650f
RWr7_3 y6_1 b7_3 26.666700
CWr7_3r b7_3 0 5.645650f
XPIA7_3 ab7_3 a7_3 rail7 rail7 sg13_lv_pmos w=1.12u l=0.13u
XNIA7_3 ab7_3 a7_3 gn7 gn7 sg13_lv_nmos w=0.74u l=0.13u
XPIB7_3 bb7_3 b7_3 rail7 rail7 sg13_lv_pmos w=1.12u l=0.13u
XNIB7_3 bb7_3 b7_3 gn7 gn7 sg13_lv_nmos w=0.74u l=0.13u
XTN17_3 ab7_3 bb7_3 yi7_3 gn7 sg13_lv_nmos w=0.74u l=0.13u
XTP17_3 ab7_3 b7_3 yi7_3 vhi sg13_lv_pmos w=1.12u l=0.13u
XTN27_3 a7_3 b7_3 yi7_3 gn7 sg13_lv_nmos w=0.74u l=0.13u
XTP27_3 a7_3 bb7_3 yi7_3 vhi sg13_lv_pmos w=1.12u l=0.13u
CL7_3 yi7_3 gn7 2f
XPOR7_3 y7_3 yi7_3 rail7 rail7 sg13_lv_pmos w=1.12u l=0.13u
XNOR7_3 y7_3 yi7_3 gn7 gn7 sg13_lv_nmos w=0.74u l=0.13u
CLO7_3 y7_3 gn7 2f
CT1 tnk1 0 1306.936528f
L1 tnk1 mid1 15n
R1 mid1 sw1 10
XSWN1 sw1 gt1 rail1 0 sg13_lv_nmos w=10u l=0.13u
XSWP1 sw1 gtp1 rail1 vhi sg13_lv_pmos w=20u l=0.13u
XPK1 sw1 pk1 tnk1 tnk1 sg13_lv_nmos w=1u l=0.13u
CT2 tnk2 0 1434.302408f
L2 tnk2 mid2 15n
R2 mid2 sw2 10
XSWN2 sw2 gt2 rail2 0 sg13_lv_nmos w=10u l=0.13u
XSWP2 sw2 gtp2 rail2 vhi sg13_lv_pmos w=20u l=0.13u
XPK2 sw2 pk2 tnk2 tnk2 sg13_lv_nmos w=1u l=0.13u
CT3 tnk3 0 1065.551743f
L3 tnk3 mid3 15n
R3 mid3 sw3 10
XSWN3 sw3 gt3 rail3 0 sg13_lv_nmos w=10u l=0.13u
XSWP3 sw3 gtp3 rail3 vhi sg13_lv_pmos w=20u l=0.13u
XPK3 sw3 pk3 tnk3 tnk3 sg13_lv_nmos w=1u l=0.13u
CT4 tnk4 0 871.237882f
L4 tnk4 mid4 15n
R4 mid4 sw4 10
XSWN4 sw4 gt4 rail4 0 sg13_lv_nmos w=10u l=0.13u
XSWP4 sw4 gtp4 rail4 vhi sg13_lv_pmos w=20u l=0.13u
XPK4 sw4 pk4 tnk4 tnk4 sg13_lv_nmos w=1u l=0.13u
CT5 tnk5 0 1185.008376f
L5 tnk5 mid5 15n
R5 mid5 sw5 10
XSWN5 sw5 gt5 rail5 0 sg13_lv_nmos w=10u l=0.13u
XSWP5 sw5 gtp5 rail5 vhi sg13_lv_pmos w=20u l=0.13u
XPK5 sw5 pk5 tnk5 tnk5 sg13_lv_nmos w=1u l=0.13u
CT6 tnk6 0 1418.571893f
L6 tnk6 mid6 15n
R6 mid6 sw6 10
XSWN6 sw6 gt6 rail6 0 sg13_lv_nmos w=10u l=0.13u
XSWP6 sw6 gtp6 rail6 vhi sg13_lv_pmos w=20u l=0.13u
XPK6 sw6 pk6 tnk6 tnk6 sg13_lv_nmos w=1u l=0.13u
CT7 tnk7 0 912.078520f
L7 tnk7 mid7 15n
R7 mid7 sw7 10
XSWN7 sw7 gt7 rail7 0 sg13_lv_nmos w=10u l=0.13u
XSWP7 sw7 gtp7 rail7 vhi sg13_lv_pmos w=20u l=0.13u
XPK7 sw7 pk7 tnk7 tnk7 sg13_lv_nmos w=1u l=0.13u
VGT1 gt1 0 PWL(0 0 198p 0 200p 2.4 363.552p 2.4 365.552p 0)
VGTP1 gtp1 0 PWL(0 2.4 198p 2.4 200p 0 363.552p 0 365.552p 2.4)
VPK1 pk1 0 PWL(0 2.4 198p 2.4 200p 0 363.552p 0 365.552p 2.4)
VGT2 gt2 0 PWL(0 0 398p 0 400p 2.4 555.784p 2.4 557.784p 0)
VGTP2 gtp2 0 PWL(0 2.4 398p 2.4 400p 0 555.784p 0 557.784p 2.4)
VPK2 pk2 0 PWL(0 2.4 398p 2.4 400p 0 555.784p 0 557.784p 2.4)
VGT3 gt3 0 PWL(0 0 598p 0 600p 2.4 744.871p 2.4 746.871p 0)
VGTP3 gtp3 0 PWL(0 2.4 598p 2.4 600p 0 744.871p 0 746.871p 2.4)
VPK3 pk3 0 PWL(0 2.4 598p 2.4 600p 0 744.871p 0 746.871p 2.4)
VGT4 gt4 0 PWL(0 0 798p 0 800p 2.4 940.82p 2.4 942.82p 0)
VGTP4 gtp4 0 PWL(0 2.4 798p 2.4 800p 0 940.82p 0 942.82p 2.4)
VPK4 pk4 0 PWL(0 2.4 798p 2.4 800p 0 940.82p 0 942.82p 2.4)
VGT5 gt5 0 PWL(0 0 998p 0 1000p 2.4 5313.39p 2.4)
VGTP5 gtp5 0 PWL(0 2.4 998p 2.4 1000p 0 5313.39p 0)
VPK5 pk5 0 PWL(0 2.4 998p 2.4 1000p 0 5313.39p 0)
VGT6 gt6 0 0
VGTP6 gtp6 0 2.4
VPK6 pk6 0 2.4
VGT7 gt7 0 0
VGTP7 gtp7 0 2.4
VPK7 pk7 0 2.4
VSzc s_zc 0 1.2
VIzc i_zc 0 PWL(0 1.2 200p 1.2 202p 0)
XPzc o_zc i_zc s_zc s_zc sg13_lv_pmos w=1.12u l=0.13u
XNzc o_zc i_zc 0 0 sg13_lv_nmos w=0.74u l=0.13u
CLzc o_zc 0 2f
.ic V(tnk1)=0.9075 V(rail1)=0 V(sw1)=0.9075 V(tnk2)=0.9075 V(rail2)=0 V(sw2)=0.9075 V(tnk3)=0.9075 V(rail3)=0 V(sw3)=0.9075 V(tnk4)=0.9075 V(rail4)=0 V(sw4)=0.9075 V(tnk5)=0.9075 V(rail5)=0 V(sw5)=0.9075 V(tnk6)=0.9075 V(rail6)=0 V(sw6)=0.9075 V(tnk7)=0.9075 V(rail7)=0 V(sw7)=0.9075
.tran 0.25p 1328.35p 0 0.25p
.measure tran T90ZC WHEN V(o_zc)=1.08 RISE=1
.print tran V(rail1) V(rail2) V(rail3) V(rail4) V(rail5) V(rail6) V(rail7) V(tnk1) V(tnk2) V(tnk3) V(tnk4) V(tnk5) V(tnk6) V(tnk7) V(sw1) V(sw2) V(sw3) V(sw4) V(sw5) V(sw6) V(sw7) I(L1) I(L2) I(L3) I(L4) I(L5) I(L6) I(L7) V(y1_0) V(y1_1) V(y1_2) V(y1_3) V(y2_0) V(y2_1) V(y2_2) V(y2_3) V(y3_0) V(y3_1) V(y3_2) V(y3_3) V(y4_0) V(y4_1) V(y4_2) V(y4_3) V(y5_0) V(y5_1) V(y5_2) V(y5_3) V(y6_0) V(y6_1) V(y6_2) V(y6_3) V(y7_0) V(y7_1) V(y7_2) V(y7_3) V(o_zc)
.end
