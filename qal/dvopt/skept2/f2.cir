.hdl "/usr/local/share/xyce/verilog-a/psp103/psp103.va"
.include "/usr/local/src/kestrel/sim/models/sg13g2_psp103_tt.lib"
.include "/usr/local/src/stat-sim/qal/sg13lv_compat.sp"
.OPTIONS TIMEINT METHOD=GEAR RELTOL=1e-6 ABSTOL=1e-15 CHGTOL=1e-17
VSp009919970_e020 s_p009919970_e020 0 PWL(0 0 100p 0 102p 0.9919970)
VIp009919970_e020 i_p009919970_e020 0 0
XPp009919970_e020 o_p009919970_e020 i_p009919970_e020 s_p009919970_e020 s_p009919970_e020 sg13_lv_pmos w=1.12u l=0.13u
XNp009919970_e020 o_p009919970_e020 i_p009919970_e020 0 0 sg13_lv_nmos w=0.74u l=0.13u
CLp009919970_e020 o_p009919970_e020 0 2f
VSp009919970_e100 s_p009919970_e100 0 PWL(0 0 100p 0 110p 0.9919970)
VIp009919970_e100 i_p009919970_e100 0 0
XPp009919970_e100 o_p009919970_e100 i_p009919970_e100 s_p009919970_e100 s_p009919970_e100 sg13_lv_pmos w=1.12u l=0.13u
XNp009919970_e100 o_p009919970_e100 i_p009919970_e100 0 0 sg13_lv_nmos w=0.74u l=0.13u
CLp009919970_e100 o_p009919970_e100 0 2f
VSp009919970_e250 s_p009919970_e250 0 PWL(0 0 100p 0 125p 0.9919970)
VIp009919970_e250 i_p009919970_e250 0 0
XPp009919970_e250 o_p009919970_e250 i_p009919970_e250 s_p009919970_e250 s_p009919970_e250 sg13_lv_pmos w=1.12u l=0.13u
XNp009919970_e250 o_p009919970_e250 i_p009919970_e250 0 0 sg13_lv_nmos w=0.74u l=0.13u
CLp009919970_e250 o_p009919970_e250 0 2f
VSp009919970_e500 s_p009919970_e500 0 PWL(0 0 100p 0 150p 0.9919970)
VIp009919970_e500 i_p009919970_e500 0 0
XPp009919970_e500 o_p009919970_e500 i_p009919970_e500 s_p009919970_e500 s_p009919970_e500 sg13_lv_pmos w=1.12u l=0.13u
XNp009919970_e500 o_p009919970_e500 i_p009919970_e500 0 0 sg13_lv_nmos w=0.74u l=0.13u
CLp009919970_e500 o_p009919970_e500 0 2f
VSp009301740_e020 s_p009301740_e020 0 PWL(0 0 100p 0 102p 0.9301740)
VIp009301740_e020 i_p009301740_e020 0 0
XPp009301740_e020 o_p009301740_e020 i_p009301740_e020 s_p009301740_e020 s_p009301740_e020 sg13_lv_pmos w=1.12u l=0.13u
XNp009301740_e020 o_p009301740_e020 i_p009301740_e020 0 0 sg13_lv_nmos w=0.74u l=0.13u
CLp009301740_e020 o_p009301740_e020 0 2f
VSp009301740_e100 s_p009301740_e100 0 PWL(0 0 100p 0 110p 0.9301740)
VIp009301740_e100 i_p009301740_e100 0 0
XPp009301740_e100 o_p009301740_e100 i_p009301740_e100 s_p009301740_e100 s_p009301740_e100 sg13_lv_pmos w=1.12u l=0.13u
XNp009301740_e100 o_p009301740_e100 i_p009301740_e100 0 0 sg13_lv_nmos w=0.74u l=0.13u
CLp009301740_e100 o_p009301740_e100 0 2f
VSp009301740_e250 s_p009301740_e250 0 PWL(0 0 100p 0 125p 0.9301740)
VIp009301740_e250 i_p009301740_e250 0 0
XPp009301740_e250 o_p009301740_e250 i_p009301740_e250 s_p009301740_e250 s_p009301740_e250 sg13_lv_pmos w=1.12u l=0.13u
XNp009301740_e250 o_p009301740_e250 i_p009301740_e250 0 0 sg13_lv_nmos w=0.74u l=0.13u
CLp009301740_e250 o_p009301740_e250 0 2f
VSp009301740_e500 s_p009301740_e500 0 PWL(0 0 100p 0 150p 0.9301740)
VIp009301740_e500 i_p009301740_e500 0 0
XPp009301740_e500 o_p009301740_e500 i_p009301740_e500 s_p009301740_e500 s_p009301740_e500 sg13_lv_pmos w=1.12u l=0.13u
XNp009301740_e500 o_p009301740_e500 i_p009301740_e500 0 0 sg13_lv_nmos w=0.74u l=0.13u
CLp009301740_e500 o_p009301740_e500 0 2f
VSzc s_zc 0 1.2000000
VIzc i_zc 0 PWL(0 1.2000000 100p 1.2000000 102p 0)
XPzc o_zc i_zc s_zc s_zc sg13_lv_pmos w=1.12u l=0.13u
XNzc o_zc i_zc 0 0 sg13_lv_nmos w=0.74u l=0.13u
CLzc o_zc 0 2f
.tran 0.05p 600p 0 0.2p
.measure tran T50p009919970_e020 WHEN V(o_p009919970_e020)=0.49599850 RISE=1
.measure tran T80p009919970_e020 WHEN V(o_p009919970_e020)=0.79359760 RISE=1
.measure tran T90p009919970_e020 WHEN V(o_p009919970_e020)=0.89279730 RISE=1
.measure tran T95p009919970_e020 WHEN V(o_p009919970_e020)=0.94239715 RISE=1
.measure tran T50p009919970_e100 WHEN V(o_p009919970_e100)=0.49599850 RISE=1
.measure tran T80p009919970_e100 WHEN V(o_p009919970_e100)=0.79359760 RISE=1
.measure tran T90p009919970_e100 WHEN V(o_p009919970_e100)=0.89279730 RISE=1
.measure tran T95p009919970_e100 WHEN V(o_p009919970_e100)=0.94239715 RISE=1
.measure tran T50p009919970_e250 WHEN V(o_p009919970_e250)=0.49599850 RISE=1
.measure tran T80p009919970_e250 WHEN V(o_p009919970_e250)=0.79359760 RISE=1
.measure tran T90p009919970_e250 WHEN V(o_p009919970_e250)=0.89279730 RISE=1
.measure tran T95p009919970_e250 WHEN V(o_p009919970_e250)=0.94239715 RISE=1
.measure tran T50p009919970_e500 WHEN V(o_p009919970_e500)=0.49599850 RISE=1
.measure tran T80p009919970_e500 WHEN V(o_p009919970_e500)=0.79359760 RISE=1
.measure tran T90p009919970_e500 WHEN V(o_p009919970_e500)=0.89279730 RISE=1
.measure tran T95p009919970_e500 WHEN V(o_p009919970_e500)=0.94239715 RISE=1
.measure tran T50p009301740_e020 WHEN V(o_p009301740_e020)=0.46508700 RISE=1
.measure tran T80p009301740_e020 WHEN V(o_p009301740_e020)=0.74413920 RISE=1
.measure tran T90p009301740_e020 WHEN V(o_p009301740_e020)=0.83715660 RISE=1
.measure tran T95p009301740_e020 WHEN V(o_p009301740_e020)=0.88366530 RISE=1
.measure tran T50p009301740_e100 WHEN V(o_p009301740_e100)=0.46508700 RISE=1
.measure tran T80p009301740_e100 WHEN V(o_p009301740_e100)=0.74413920 RISE=1
.measure tran T90p009301740_e100 WHEN V(o_p009301740_e100)=0.83715660 RISE=1
.measure tran T95p009301740_e100 WHEN V(o_p009301740_e100)=0.88366530 RISE=1
.measure tran T50p009301740_e250 WHEN V(o_p009301740_e250)=0.46508700 RISE=1
.measure tran T80p009301740_e250 WHEN V(o_p009301740_e250)=0.74413920 RISE=1
.measure tran T90p009301740_e250 WHEN V(o_p009301740_e250)=0.83715660 RISE=1
.measure tran T95p009301740_e250 WHEN V(o_p009301740_e250)=0.88366530 RISE=1
.measure tran T50p009301740_e500 WHEN V(o_p009301740_e500)=0.46508700 RISE=1
.measure tran T80p009301740_e500 WHEN V(o_p009301740_e500)=0.74413920 RISE=1
.measure tran T90p009301740_e500 WHEN V(o_p009301740_e500)=0.83715660 RISE=1
.measure tran T95p009301740_e500 WHEN V(o_p009301740_e500)=0.88366530 RISE=1
.measure tran T50zc WHEN V(o_zc)=0.60000000 RISE=1
.measure tran T80zc WHEN V(o_zc)=0.96000000 RISE=1
.measure tran T90zc WHEN V(o_zc)=1.08000000 RISE=1
.measure tran T95zc WHEN V(o_zc)=1.14000000 RISE=1
.print tran V(o_p009919970_e020) V(o_p009919970_e100) V(o_p009919970_e250) V(o_p009919970_e500) V(o_p009301740_e020) V(o_p009301740_e100) V(o_p009301740_e250) V(o_p009301740_e500)
+ V(o_zc)
.end
