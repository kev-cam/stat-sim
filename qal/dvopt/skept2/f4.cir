.hdl "/usr/local/share/xyce/verilog-a/psp103/psp103.va"
.include "/usr/local/src/kestrel/sim/models/sg13g2_psp103_tt.lib"
.include "/usr/local/src/stat-sim/qal/sg13lv_compat.sp"
.OPTIONS TIMEINT METHOD=GEAR RELTOL=1e-6 ABSTOL=1e-15 CHGTOL=1e-17
VSv009197100 s_v009197100 0 PWL(0 0 100p 0 102p 0.9197100)
VIv009197100 i_v009197100 0 0
XPv009197100 o_v009197100 i_v009197100 s_v009197100 s_v009197100 sg13_lv_pmos w=1.12u l=0.13u
XNv009197100 o_v009197100 i_v009197100 0 0 sg13_lv_nmos w=0.74u l=0.13u
CLv009197100 o_v009197100 0 2f
VSv009225240 s_v009225240 0 PWL(0 0 100p 0 102p 0.9225240)
VIv009225240 i_v009225240 0 0
XPv009225240 o_v009225240 i_v009225240 s_v009225240 s_v009225240 sg13_lv_pmos w=1.12u l=0.13u
XNv009225240 o_v009225240 i_v009225240 0 0 sg13_lv_nmos w=0.74u l=0.13u
CLv009225240 o_v009225240 0 2f
VSv009373640 s_v009373640 0 PWL(0 0 100p 0 102p 0.9373640)
VIv009373640 i_v009373640 0 0
XPv009373640 o_v009373640 i_v009373640 s_v009373640 s_v009373640 sg13_lv_pmos w=1.12u l=0.13u
XNv009373640 o_v009373640 i_v009373640 0 0 sg13_lv_nmos w=0.74u l=0.13u
CLv009373640 o_v009373640 0 2f
VSv009402800 s_v009402800 0 PWL(0 0 100p 0 102p 0.9402800)
VIv009402800 i_v009402800 0 0
XPv009402800 o_v009402800 i_v009402800 s_v009402800 s_v009402800 sg13_lv_pmos w=1.12u l=0.13u
XNv009402800 o_v009402800 i_v009402800 0 0 sg13_lv_nmos w=0.74u l=0.13u
CLv009402800 o_v009402800 0 2f
VSv009592330 s_v009592330 0 PWL(0 0 100p 0 102p 0.9592330)
VIv009592330 i_v009592330 0 0
XPv009592330 o_v009592330 i_v009592330 s_v009592330 s_v009592330 sg13_lv_pmos w=1.12u l=0.13u
XNv009592330 o_v009592330 i_v009592330 0 0 sg13_lv_nmos w=0.74u l=0.13u
CLv009592330 o_v009592330 0 2f
VSv009813490 s_v009813490 0 PWL(0 0 100p 0 102p 0.9813490)
VIv009813490 i_v009813490 0 0
XPv009813490 o_v009813490 i_v009813490 s_v009813490 s_v009813490 sg13_lv_pmos w=1.12u l=0.13u
XNv009813490 o_v009813490 i_v009813490 0 0 sg13_lv_nmos w=0.74u l=0.13u
CLv009813490 o_v009813490 0 2f
VSv009870070 s_v009870070 0 PWL(0 0 100p 0 102p 0.9870070)
VIv009870070 i_v009870070 0 0
XPv009870070 o_v009870070 i_v009870070 s_v009870070 s_v009870070 sg13_lv_pmos w=1.12u l=0.13u
XNv009870070 o_v009870070 i_v009870070 0 0 sg13_lv_nmos w=0.74u l=0.13u
CLv009870070 o_v009870070 0 2f
VSv010009900 s_v010009900 0 PWL(0 0 100p 0 102p 1.0009900)
VIv010009900 i_v010009900 0 0
XPv010009900 o_v010009900 i_v010009900 s_v010009900 s_v010009900 sg13_lv_pmos w=1.12u l=0.13u
XNv010009900 o_v010009900 i_v010009900 0 0 sg13_lv_nmos w=0.74u l=0.13u
CLv010009900 o_v010009900 0 2f
VSv010010780 s_v010010780 0 PWL(0 0 100p 0 102p 1.0010780)
VIv010010780 i_v010010780 0 0
XPv010010780 o_v010010780 i_v010010780 s_v010010780 s_v010010780 sg13_lv_pmos w=1.12u l=0.13u
XNv010010780 o_v010010780 i_v010010780 0 0 sg13_lv_nmos w=0.74u l=0.13u
CLv010010780 o_v010010780 0 2f
VSzc s_zc 0 1.2000000
VIzc i_zc 0 PWL(0 1.2000000 100p 1.2000000 102p 0)
XPzc o_zc i_zc s_zc s_zc sg13_lv_pmos w=1.12u l=0.13u
XNzc o_zc i_zc 0 0 sg13_lv_nmos w=0.74u l=0.13u
CLzc o_zc 0 2f
.tran 0.05p 600p 0 0.2p
.measure tran T50v009197100 WHEN V(o_v009197100)=0.45985500 RISE=1
.measure tran T80v009197100 WHEN V(o_v009197100)=0.73576800 RISE=1
.measure tran T90v009197100 WHEN V(o_v009197100)=0.82773900 RISE=1
.measure tran T95v009197100 WHEN V(o_v009197100)=0.87372450 RISE=1
.measure tran T50v009225240 WHEN V(o_v009225240)=0.46126200 RISE=1
.measure tran T80v009225240 WHEN V(o_v009225240)=0.73801920 RISE=1
.measure tran T90v009225240 WHEN V(o_v009225240)=0.83027160 RISE=1
.measure tran T95v009225240 WHEN V(o_v009225240)=0.87639780 RISE=1
.measure tran T50v009373640 WHEN V(o_v009373640)=0.46868200 RISE=1
.measure tran T80v009373640 WHEN V(o_v009373640)=0.74989120 RISE=1
.measure tran T90v009373640 WHEN V(o_v009373640)=0.84362760 RISE=1
.measure tran T95v009373640 WHEN V(o_v009373640)=0.89049580 RISE=1
.measure tran T50v009402800 WHEN V(o_v009402800)=0.47014000 RISE=1
.measure tran T80v009402800 WHEN V(o_v009402800)=0.75222400 RISE=1
.measure tran T90v009402800 WHEN V(o_v009402800)=0.84625200 RISE=1
.measure tran T95v009402800 WHEN V(o_v009402800)=0.89326600 RISE=1
.measure tran T50v009592330 WHEN V(o_v009592330)=0.47961650 RISE=1
.measure tran T80v009592330 WHEN V(o_v009592330)=0.76738640 RISE=1
.measure tran T90v009592330 WHEN V(o_v009592330)=0.86330970 RISE=1
.measure tran T95v009592330 WHEN V(o_v009592330)=0.91127135 RISE=1
.measure tran T50v009813490 WHEN V(o_v009813490)=0.49067450 RISE=1
.measure tran T80v009813490 WHEN V(o_v009813490)=0.78507920 RISE=1
.measure tran T90v009813490 WHEN V(o_v009813490)=0.88321410 RISE=1
.measure tran T95v009813490 WHEN V(o_v009813490)=0.93228155 RISE=1
.measure tran T50v009870070 WHEN V(o_v009870070)=0.49350350 RISE=1
.measure tran T80v009870070 WHEN V(o_v009870070)=0.78960560 RISE=1
.measure tran T90v009870070 WHEN V(o_v009870070)=0.88830630 RISE=1
.measure tran T95v009870070 WHEN V(o_v009870070)=0.93765665 RISE=1
.measure tran T50v010009900 WHEN V(o_v010009900)=0.50049500 RISE=1
.measure tran T80v010009900 WHEN V(o_v010009900)=0.80079200 RISE=1
.measure tran T90v010009900 WHEN V(o_v010009900)=0.90089100 RISE=1
.measure tran T95v010009900 WHEN V(o_v010009900)=0.95094050 RISE=1
.measure tran T50v010010780 WHEN V(o_v010010780)=0.50053900 RISE=1
.measure tran T80v010010780 WHEN V(o_v010010780)=0.80086240 RISE=1
.measure tran T90v010010780 WHEN V(o_v010010780)=0.90097020 RISE=1
.measure tran T95v010010780 WHEN V(o_v010010780)=0.95102410 RISE=1
.measure tran T50zc WHEN V(o_zc)=0.60000000 RISE=1
.measure tran T80zc WHEN V(o_zc)=0.96000000 RISE=1
.measure tran T90zc WHEN V(o_zc)=1.08000000 RISE=1
.measure tran T95zc WHEN V(o_zc)=1.14000000 RISE=1
.print tran V(o_v009197100) V(o_v009225240) V(o_v009373640) V(o_v009402800) V(o_v009592330) V(o_v009813490) V(o_v009870070) V(o_v010009900)
+ V(o_v010010780) V(o_zc)
.end
