.hdl "/usr/local/share/xyce/verilog-a/psp103/psp103.va"
.include "/usr/local/src/kestrel/sim/models/sg13g2_psp103_tt.lib"
.include "/usr/local/src/stat-sim/qal/sg13lv_compat.sp"
.OPTIONS TIMEINT METHOD=GEAR RELTOL=1e-6 ABSTOL=1e-15 CHGTOL=1e-17
VSv007138163 s_v007138163 0 PWL(0 0 100p 0 102p 0.7138163)
VIv007138163 i_v007138163 0 0
XPv007138163 o_v007138163 i_v007138163 s_v007138163 s_v007138163 sg13_lv_pmos w=1.12u l=0.13u
XNv007138163 o_v007138163 i_v007138163 0 0 sg13_lv_nmos w=0.74u l=0.13u
CLv007138163 o_v007138163 0 2f
VSv008779140 s_v008779140 0 PWL(0 0 100p 0 102p 0.8779140)
VIv008779140 i_v008779140 0 0
XPv008779140 o_v008779140 i_v008779140 s_v008779140 s_v008779140 sg13_lv_pmos w=1.12u l=0.13u
XNv008779140 o_v008779140 i_v008779140 0 0 sg13_lv_nmos w=0.74u l=0.13u
CLv008779140 o_v008779140 0 2f
VSv008961160 s_v008961160 0 PWL(0 0 100p 0 102p 0.8961160)
VIv008961160 i_v008961160 0 0
XPv008961160 o_v008961160 i_v008961160 s_v008961160 s_v008961160 sg13_lv_pmos w=1.12u l=0.13u
XNv008961160 o_v008961160 i_v008961160 0 0 sg13_lv_nmos w=0.74u l=0.13u
CLv008961160 o_v008961160 0 2f
VSv009147290 s_v009147290 0 PWL(0 0 100p 0 102p 0.9147290)
VIv009147290 i_v009147290 0 0
XPv009147290 o_v009147290 i_v009147290 s_v009147290 s_v009147290 sg13_lv_pmos w=1.12u l=0.13u
XNv009147290 o_v009147290 i_v009147290 0 0 sg13_lv_nmos w=0.74u l=0.13u
CLv009147290 o_v009147290 0 2f
VSv009273350 s_v009273350 0 PWL(0 0 100p 0 102p 0.9273350)
VIv009273350 i_v009273350 0 0
XPv009273350 o_v009273350 i_v009273350 s_v009273350 s_v009273350 sg13_lv_pmos w=1.12u l=0.13u
XNv009273350 o_v009273350 i_v009273350 0 0 sg13_lv_nmos w=0.74u l=0.13u
CLv009273350 o_v009273350 0 2f
VSv009301740 s_v009301740 0 PWL(0 0 100p 0 102p 0.9301740)
VIv009301740 i_v009301740 0 0
XPv009301740 o_v009301740 i_v009301740 s_v009301740 s_v009301740 sg13_lv_pmos w=1.12u l=0.13u
XNv009301740 o_v009301740 i_v009301740 0 0 sg13_lv_nmos w=0.74u l=0.13u
CLv009301740 o_v009301740 0 2f
VSv009345470 s_v009345470 0 PWL(0 0 100p 0 102p 0.9345470)
VIv009345470 i_v009345470 0 0
XPv009345470 o_v009345470 i_v009345470 s_v009345470 s_v009345470 sg13_lv_pmos w=1.12u l=0.13u
XNv009345470 o_v009345470 i_v009345470 0 0 sg13_lv_nmos w=0.74u l=0.13u
CLv009345470 o_v009345470 0 2f
VSv009471550 s_v009471550 0 PWL(0 0 100p 0 102p 0.9471550)
VIv009471550 i_v009471550 0 0
XPv009471550 o_v009471550 i_v009471550 s_v009471550 s_v009471550 sg13_lv_pmos w=1.12u l=0.13u
XNv009471550 o_v009471550 i_v009471550 0 0 sg13_lv_nmos w=0.74u l=0.13u
CLv009471550 o_v009471550 0 2f
VSv009813490 s_v009813490 0 PWL(0 0 100p 0 102p 0.9813490)
VIv009813490 i_v009813490 0 0
XPv009813490 o_v009813490 i_v009813490 s_v009813490 s_v009813490 sg13_lv_pmos w=1.12u l=0.13u
XNv009813490 o_v009813490 i_v009813490 0 0 sg13_lv_nmos w=0.74u l=0.13u
CLv009813490 o_v009813490 0 2f
VSv009870070 s_v009870070 0 PWL(0 0 100p 0 102p 0.9870070)
VIv009870070 i_v009870070 0 0
XPv009870070 o_v009870070 i_v009870070 s_v009870070 s_v009870070 sg13_lv_pmos w=1.12u l=0.13u
XNv009870070 o_v009870070 i_v009870070 0 0 sg13_lv_nmos w=0.74u l=0.13u
CLv009870070 o_v009870070 0 2f
VSv009919970 s_v009919970 0 PWL(0 0 100p 0 102p 0.9919970)
VIv009919970 i_v009919970 0 0
XPv009919970 o_v009919970 i_v009919970 s_v009919970 s_v009919970 sg13_lv_pmos w=1.12u l=0.13u
XNv009919970 o_v009919970 i_v009919970 0 0 sg13_lv_nmos w=0.74u l=0.13u
CLv009919970 o_v009919970 0 2f
VSv010004960 s_v010004960 0 PWL(0 0 100p 0 102p 1.0004960)
VIv010004960 i_v010004960 0 0
XPv010004960 o_v010004960 i_v010004960 s_v010004960 s_v010004960 sg13_lv_pmos w=1.12u l=0.13u
XNv010004960 o_v010004960 i_v010004960 0 0 sg13_lv_nmos w=0.74u l=0.13u
CLv010004960 o_v010004960 0 2f
VSv010106660 s_v010106660 0 PWL(0 0 100p 0 102p 1.0106660)
VIv010106660 i_v010106660 0 0
XPv010106660 o_v010106660 i_v010106660 s_v010106660 s_v010106660 sg13_lv_pmos w=1.12u l=0.13u
XNv010106660 o_v010106660 i_v010106660 0 0 sg13_lv_nmos w=0.74u l=0.13u
CLv010106660 o_v010106660 0 2f
VSr4885216 s_r4885216 0 PWL(0 0 100p 0 102p 0.4885216)
VIr4885216 i_r4885216 0 0
XPr4885216 o_r4885216 i_r4885216 s_r4885216 s_r4885216 sg13_lv_pmos w=1.12u l=0.13u
XNr4885216 o_r4885216 i_r4885216 0 0 sg13_lv_nmos w=0.74u l=0.13u
CLr4885216 o_r4885216 0 2f
VSr5883760 s_r5883760 0 PWL(0 0 100p 0 102p 0.5883760)
VIr5883760 i_r5883760 0 0
XPr5883760 o_r5883760 i_r5883760 s_r5883760 s_r5883760 sg13_lv_pmos w=1.12u l=0.13u
XNr5883760 o_r5883760 i_r5883760 0 0 sg13_lv_nmos w=0.74u l=0.13u
CLr5883760 o_r5883760 0 2f
VSr6754250 s_r6754250 0 PWL(0 0 100p 0 102p 0.6754250)
VIr6754250 i_r6754250 0 0
XPr6754250 o_r6754250 i_r6754250 s_r6754250 s_r6754250 sg13_lv_pmos w=1.12u l=0.13u
XNr6754250 o_r6754250 i_r6754250 0 0 sg13_lv_nmos w=0.74u l=0.13u
CLr6754250 o_r6754250 0 2f
VSg1000 s_g1000 0 PWL(0 0 100p 0 102p 1.0000000)
VIg1000 i_g1000 0 0
XPg1000 o_g1000 i_g1000 s_g1000 s_g1000 sg13_lv_pmos w=1.12u l=0.13u
XNg1000 o_g1000 i_g1000 0 0 sg13_lv_nmos w=0.74u l=0.13u
CLg1000 o_g1000 0 2f
VSg1200 s_g1200 0 PWL(0 0 100p 0 102p 1.2000000)
VIg1200 i_g1200 0 0
XPg1200 o_g1200 i_g1200 s_g1200 s_g1200 sg13_lv_pmos w=1.12u l=0.13u
XNg1200 o_g1200 i_g1200 0 0 sg13_lv_nmos w=0.74u l=0.13u
CLg1200 o_g1200 0 2f
VSg1500 s_g1500 0 PWL(0 0 100p 0 102p 1.5000000)
VIg1500 i_g1500 0 0
XPg1500 o_g1500 i_g1500 s_g1500 s_g1500 sg13_lv_pmos w=1.12u l=0.13u
XNg1500 o_g1500 i_g1500 0 0 sg13_lv_nmos w=0.74u l=0.13u
CLg1500 o_g1500 0 2f
VSzc s_zc 0 1.2000000
VIzc i_zc 0 PWL(0 1.2000000 100p 1.2000000 102p 0)
XPzc o_zc i_zc s_zc s_zc sg13_lv_pmos w=1.12u l=0.13u
XNzc o_zc i_zc 0 0 sg13_lv_nmos w=0.74u l=0.13u
CLzc o_zc 0 2f
.tran 0.05p 1200p 0 0.2p
.measure tran T50v007138163 WHEN V(o_v007138163)=0.35690815 RISE=1
.measure tran T80v007138163 WHEN V(o_v007138163)=0.57105304 RISE=1
.measure tran T90v007138163 WHEN V(o_v007138163)=0.64243467 RISE=1
.measure tran T95v007138163 WHEN V(o_v007138163)=0.67812548 RISE=1
.measure tran T50v008779140 WHEN V(o_v008779140)=0.43895700 RISE=1
.measure tran T80v008779140 WHEN V(o_v008779140)=0.70233120 RISE=1
.measure tran T90v008779140 WHEN V(o_v008779140)=0.79012260 RISE=1
.measure tran T95v008779140 WHEN V(o_v008779140)=0.83401830 RISE=1
.measure tran T50v008961160 WHEN V(o_v008961160)=0.44805800 RISE=1
.measure tran T80v008961160 WHEN V(o_v008961160)=0.71689280 RISE=1
.measure tran T90v008961160 WHEN V(o_v008961160)=0.80650440 RISE=1
.measure tran T95v008961160 WHEN V(o_v008961160)=0.85131020 RISE=1
.measure tran T50v009147290 WHEN V(o_v009147290)=0.45736450 RISE=1
.measure tran T80v009147290 WHEN V(o_v009147290)=0.73178320 RISE=1
.measure tran T90v009147290 WHEN V(o_v009147290)=0.82325610 RISE=1
.measure tran T95v009147290 WHEN V(o_v009147290)=0.86899255 RISE=1
.measure tran T50v009273350 WHEN V(o_v009273350)=0.46366750 RISE=1
.measure tran T80v009273350 WHEN V(o_v009273350)=0.74186800 RISE=1
.measure tran T90v009273350 WHEN V(o_v009273350)=0.83460150 RISE=1
.measure tran T95v009273350 WHEN V(o_v009273350)=0.88096825 RISE=1
.measure tran T50v009301740 WHEN V(o_v009301740)=0.46508700 RISE=1
.measure tran T80v009301740 WHEN V(o_v009301740)=0.74413920 RISE=1
.measure tran T90v009301740 WHEN V(o_v009301740)=0.83715660 RISE=1
.measure tran T95v009301740 WHEN V(o_v009301740)=0.88366530 RISE=1
.measure tran T50v009345470 WHEN V(o_v009345470)=0.46727350 RISE=1
.measure tran T80v009345470 WHEN V(o_v009345470)=0.74763760 RISE=1
.measure tran T90v009345470 WHEN V(o_v009345470)=0.84109230 RISE=1
.measure tran T95v009345470 WHEN V(o_v009345470)=0.88781965 RISE=1
.measure tran T50v009471550 WHEN V(o_v009471550)=0.47357750 RISE=1
.measure tran T80v009471550 WHEN V(o_v009471550)=0.75772400 RISE=1
.measure tran T90v009471550 WHEN V(o_v009471550)=0.85243950 RISE=1
.measure tran T95v009471550 WHEN V(o_v009471550)=0.89979725 RISE=1
.measure tran T50v009813490 WHEN V(o_v009813490)=0.49067450 RISE=1
.measure tran T80v009813490 WHEN V(o_v009813490)=0.78507920 RISE=1
.measure tran T90v009813490 WHEN V(o_v009813490)=0.88321410 RISE=1
.measure tran T95v009813490 WHEN V(o_v009813490)=0.93228155 RISE=1
.measure tran T50v009870070 WHEN V(o_v009870070)=0.49350350 RISE=1
.measure tran T80v009870070 WHEN V(o_v009870070)=0.78960560 RISE=1
.measure tran T90v009870070 WHEN V(o_v009870070)=0.88830630 RISE=1
.measure tran T95v009870070 WHEN V(o_v009870070)=0.93765665 RISE=1
.measure tran T50v009919970 WHEN V(o_v009919970)=0.49599850 RISE=1
.measure tran T80v009919970 WHEN V(o_v009919970)=0.79359760 RISE=1
.measure tran T90v009919970 WHEN V(o_v009919970)=0.89279730 RISE=1
.measure tran T95v009919970 WHEN V(o_v009919970)=0.94239715 RISE=1
.measure tran T50v010004960 WHEN V(o_v010004960)=0.50024800 RISE=1
.measure tran T80v010004960 WHEN V(o_v010004960)=0.80039680 RISE=1
.measure tran T90v010004960 WHEN V(o_v010004960)=0.90044640 RISE=1
.measure tran T95v010004960 WHEN V(o_v010004960)=0.95047120 RISE=1
.measure tran T50v010106660 WHEN V(o_v010106660)=0.50533300 RISE=1
.measure tran T80v010106660 WHEN V(o_v010106660)=0.80853280 RISE=1
.measure tran T90v010106660 WHEN V(o_v010106660)=0.90959940 RISE=1
.measure tran T95v010106660 WHEN V(o_v010106660)=0.96013270 RISE=1
.measure tran T50r4885216 WHEN V(o_r4885216)=0.24426080 RISE=1
.measure tran T80r4885216 WHEN V(o_r4885216)=0.39081728 RISE=1
.measure tran T90r4885216 WHEN V(o_r4885216)=0.43966944 RISE=1
.measure tran T95r4885216 WHEN V(o_r4885216)=0.46409552 RISE=1
.measure tran T50r5883760 WHEN V(o_r5883760)=0.29418800 RISE=1
.measure tran T80r5883760 WHEN V(o_r5883760)=0.47070080 RISE=1
.measure tran T90r5883760 WHEN V(o_r5883760)=0.52953840 RISE=1
.measure tran T95r5883760 WHEN V(o_r5883760)=0.55895720 RISE=1
.measure tran T50r6754250 WHEN V(o_r6754250)=0.33771250 RISE=1
.measure tran T80r6754250 WHEN V(o_r6754250)=0.54034000 RISE=1
.measure tran T90r6754250 WHEN V(o_r6754250)=0.60788250 RISE=1
.measure tran T95r6754250 WHEN V(o_r6754250)=0.64165375 RISE=1
.measure tran T50g1000 WHEN V(o_g1000)=0.50000000 RISE=1
.measure tran T80g1000 WHEN V(o_g1000)=0.80000000 RISE=1
.measure tran T90g1000 WHEN V(o_g1000)=0.90000000 RISE=1
.measure tran T95g1000 WHEN V(o_g1000)=0.95000000 RISE=1
.measure tran T50g1200 WHEN V(o_g1200)=0.60000000 RISE=1
.measure tran T80g1200 WHEN V(o_g1200)=0.96000000 RISE=1
.measure tran T90g1200 WHEN V(o_g1200)=1.08000000 RISE=1
.measure tran T95g1200 WHEN V(o_g1200)=1.14000000 RISE=1
.measure tran T50g1500 WHEN V(o_g1500)=0.75000000 RISE=1
.measure tran T80g1500 WHEN V(o_g1500)=1.20000000 RISE=1
.measure tran T90g1500 WHEN V(o_g1500)=1.35000000 RISE=1
.measure tran T95g1500 WHEN V(o_g1500)=1.42500000 RISE=1
.measure tran T50zc WHEN V(o_zc)=0.60000000 RISE=1
.measure tran T80zc WHEN V(o_zc)=0.96000000 RISE=1
.measure tran T90zc WHEN V(o_zc)=1.08000000 RISE=1
.measure tran T95zc WHEN V(o_zc)=1.14000000 RISE=1
.print tran V(o_v007138163) V(o_v008779140) V(o_v008961160) V(o_v009147290) V(o_v009273350) V(o_v009301740) V(o_v009345470) V(o_v009471550)
+ V(o_v009813490) V(o_v009870070) V(o_v009919970) V(o_v010004960) V(o_v010106660) V(o_r4885216) V(o_r5883760) V(o_r6754250)
+ V(o_g1000) V(o_g1200) V(o_g1500) V(o_zc)
.end
