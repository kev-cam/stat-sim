.hdl "/usr/local/share/xyce/verilog-a/psp103/psp103.va"
.include "/usr/local/src/kestrel/sim/models/sg13g2_psp103_tt.lib"
.include "/usr/local/src/stat-sim/qal/sg13lv_compat.sp"
.OPTIONS TIMEINT METHOD=GEAR RELTOL=1e-6 ABSTOL=1e-15 CHGTOL=1e-17
VSo0600 s_o0600 0 PWL(0 0 100p 0 102p 0.6000000)
VA1o0600 a1_o0600 0 0
VA2o0600 a2_o0600 0 0
VB1o0600 b1_o0600 0 0.6000000
XP0o0600 nt_o0600 a1_o0600 s_o0600 s_o0600 sg13_lv_pmos w=1.12u l=0.13u
XP1o0600 o_o0600 a2_o0600 nt_o0600 s_o0600 sg13_lv_pmos w=1.12u l=0.13u
XP2o0600 o_o0600 b1_o0600 s_o0600 s_o0600 sg13_lv_pmos w=1.12u l=0.13u
XN0o0600 ns_o0600 a2_o0600 0 0 sg13_lv_nmos w=0.74u l=0.13u
XN2o0600 ns_o0600 a1_o0600 0 0 sg13_lv_nmos w=0.74u l=0.13u
XN1o0600 o_o0600 b1_o0600 ns_o0600 0 sg13_lv_nmos w=0.74u l=0.13u
CX1o0600 nt_o0600 s_o0600 0.1f
CX2o0600 ns_o0600 0 0.1f
CLo0600 o_o0600 0 2f
VSo0800 s_o0800 0 PWL(0 0 100p 0 102p 0.8000000)
VA1o0800 a1_o0800 0 0
VA2o0800 a2_o0800 0 0
VB1o0800 b1_o0800 0 0.8000000
XP0o0800 nt_o0800 a1_o0800 s_o0800 s_o0800 sg13_lv_pmos w=1.12u l=0.13u
XP1o0800 o_o0800 a2_o0800 nt_o0800 s_o0800 sg13_lv_pmos w=1.12u l=0.13u
XP2o0800 o_o0800 b1_o0800 s_o0800 s_o0800 sg13_lv_pmos w=1.12u l=0.13u
XN0o0800 ns_o0800 a2_o0800 0 0 sg13_lv_nmos w=0.74u l=0.13u
XN2o0800 ns_o0800 a1_o0800 0 0 sg13_lv_nmos w=0.74u l=0.13u
XN1o0800 o_o0800 b1_o0800 ns_o0800 0 sg13_lv_nmos w=0.74u l=0.13u
CX1o0800 nt_o0800 s_o0800 0.1f
CX2o0800 ns_o0800 0 0.1f
CLo0800 o_o0800 0 2f
VSo1000 s_o1000 0 PWL(0 0 100p 0 102p 1.0000000)
VA1o1000 a1_o1000 0 0
VA2o1000 a2_o1000 0 0
VB1o1000 b1_o1000 0 1.0000000
XP0o1000 nt_o1000 a1_o1000 s_o1000 s_o1000 sg13_lv_pmos w=1.12u l=0.13u
XP1o1000 o_o1000 a2_o1000 nt_o1000 s_o1000 sg13_lv_pmos w=1.12u l=0.13u
XP2o1000 o_o1000 b1_o1000 s_o1000 s_o1000 sg13_lv_pmos w=1.12u l=0.13u
XN0o1000 ns_o1000 a2_o1000 0 0 sg13_lv_nmos w=0.74u l=0.13u
XN2o1000 ns_o1000 a1_o1000 0 0 sg13_lv_nmos w=0.74u l=0.13u
XN1o1000 o_o1000 b1_o1000 ns_o1000 0 sg13_lv_nmos w=0.74u l=0.13u
CX1o1000 nt_o1000 s_o1000 0.1f
CX2o1000 ns_o1000 0 0.1f
CLo1000 o_o1000 0 2f
VSo1200 s_o1200 0 PWL(0 0 100p 0 102p 1.2000000)
VA1o1200 a1_o1200 0 0
VA2o1200 a2_o1200 0 0
VB1o1200 b1_o1200 0 1.2000000
XP0o1200 nt_o1200 a1_o1200 s_o1200 s_o1200 sg13_lv_pmos w=1.12u l=0.13u
XP1o1200 o_o1200 a2_o1200 nt_o1200 s_o1200 sg13_lv_pmos w=1.12u l=0.13u
XP2o1200 o_o1200 b1_o1200 s_o1200 s_o1200 sg13_lv_pmos w=1.12u l=0.13u
XN0o1200 ns_o1200 a2_o1200 0 0 sg13_lv_nmos w=0.74u l=0.13u
XN2o1200 ns_o1200 a1_o1200 0 0 sg13_lv_nmos w=0.74u l=0.13u
XN1o1200 o_o1200 b1_o1200 ns_o1200 0 sg13_lv_nmos w=0.74u l=0.13u
CX1o1200 nt_o1200 s_o1200 0.1f
CX2o1200 ns_o1200 0 0.1f
CLo1200 o_o1200 0 2f
VSo1320 s_o1320 0 PWL(0 0 100p 0 102p 1.3200000)
VA1o1320 a1_o1320 0 0
VA2o1320 a2_o1320 0 0
VB1o1320 b1_o1320 0 1.3200000
XP0o1320 nt_o1320 a1_o1320 s_o1320 s_o1320 sg13_lv_pmos w=1.12u l=0.13u
XP1o1320 o_o1320 a2_o1320 nt_o1320 s_o1320 sg13_lv_pmos w=1.12u l=0.13u
XP2o1320 o_o1320 b1_o1320 s_o1320 s_o1320 sg13_lv_pmos w=1.12u l=0.13u
XN0o1320 ns_o1320 a2_o1320 0 0 sg13_lv_nmos w=0.74u l=0.13u
XN2o1320 ns_o1320 a1_o1320 0 0 sg13_lv_nmos w=0.74u l=0.13u
XN1o1320 o_o1320 b1_o1320 ns_o1320 0 sg13_lv_nmos w=0.74u l=0.13u
CX1o1320 nt_o1320 s_o1320 0.1f
CX2o1320 ns_o1320 0 0.1f
CLo1320 o_o1320 0 2f
VSo1350 s_o1350 0 PWL(0 0 100p 0 102p 1.3500000)
VA1o1350 a1_o1350 0 0
VA2o1350 a2_o1350 0 0
VB1o1350 b1_o1350 0 1.3500000
XP0o1350 nt_o1350 a1_o1350 s_o1350 s_o1350 sg13_lv_pmos w=1.12u l=0.13u
XP1o1350 o_o1350 a2_o1350 nt_o1350 s_o1350 sg13_lv_pmos w=1.12u l=0.13u
XP2o1350 o_o1350 b1_o1350 s_o1350 s_o1350 sg13_lv_pmos w=1.12u l=0.13u
XN0o1350 ns_o1350 a2_o1350 0 0 sg13_lv_nmos w=0.74u l=0.13u
XN2o1350 ns_o1350 a1_o1350 0 0 sg13_lv_nmos w=0.74u l=0.13u
XN1o1350 o_o1350 b1_o1350 ns_o1350 0 sg13_lv_nmos w=0.74u l=0.13u
CX1o1350 nt_o1350 s_o1350 0.1f
CX2o1350 ns_o1350 0 0.1f
CLo1350 o_o1350 0 2f
VSo1500 s_o1500 0 PWL(0 0 100p 0 102p 1.5000000)
VA1o1500 a1_o1500 0 0
VA2o1500 a2_o1500 0 0
VB1o1500 b1_o1500 0 1.5000000
XP0o1500 nt_o1500 a1_o1500 s_o1500 s_o1500 sg13_lv_pmos w=1.12u l=0.13u
XP1o1500 o_o1500 a2_o1500 nt_o1500 s_o1500 sg13_lv_pmos w=1.12u l=0.13u
XP2o1500 o_o1500 b1_o1500 s_o1500 s_o1500 sg13_lv_pmos w=1.12u l=0.13u
XN0o1500 ns_o1500 a2_o1500 0 0 sg13_lv_nmos w=0.74u l=0.13u
XN2o1500 ns_o1500 a1_o1500 0 0 sg13_lv_nmos w=0.74u l=0.13u
XN1o1500 o_o1500 b1_o1500 ns_o1500 0 sg13_lv_nmos w=0.74u l=0.13u
CX1o1500 nt_o1500 s_o1500 0.1f
CX2o1500 ns_o1500 0 0.1f
CLo1500 o_o1500 0 2f
VSo1650 s_o1650 0 PWL(0 0 100p 0 102p 1.6500000)
VA1o1650 a1_o1650 0 0
VA2o1650 a2_o1650 0 0
VB1o1650 b1_o1650 0 1.6500000
XP0o1650 nt_o1650 a1_o1650 s_o1650 s_o1650 sg13_lv_pmos w=1.12u l=0.13u
XP1o1650 o_o1650 a2_o1650 nt_o1650 s_o1650 sg13_lv_pmos w=1.12u l=0.13u
XP2o1650 o_o1650 b1_o1650 s_o1650 s_o1650 sg13_lv_pmos w=1.12u l=0.13u
XN0o1650 ns_o1650 a2_o1650 0 0 sg13_lv_nmos w=0.74u l=0.13u
XN2o1650 ns_o1650 a1_o1650 0 0 sg13_lv_nmos w=0.74u l=0.13u
XN1o1650 o_o1650 b1_o1650 ns_o1650 0 sg13_lv_nmos w=0.74u l=0.13u
CX1o1650 nt_o1650 s_o1650 0.1f
CX2o1650 ns_o1650 0 0.1f
CLo1650 o_o1650 0 2f
VSob0800 s_ob0800 0 PWL(0 0 100p 0 102p 0.8000000)
VA1ob0800 a1_ob0800 0 0
VA2ob0800 a2_ob0800 0 0
VB1ob0800 b1_ob0800 0 1.6500000
XP0ob0800 nt_ob0800 a1_ob0800 s_ob0800 s_ob0800 sg13_lv_pmos w=1.12u l=0.13u
XP1ob0800 o_ob0800 a2_ob0800 nt_ob0800 s_ob0800 sg13_lv_pmos w=1.12u l=0.13u
XP2ob0800 o_ob0800 b1_ob0800 s_ob0800 s_ob0800 sg13_lv_pmos w=1.12u l=0.13u
XN0ob0800 ns_ob0800 a2_ob0800 0 0 sg13_lv_nmos w=0.74u l=0.13u
XN2ob0800 ns_ob0800 a1_ob0800 0 0 sg13_lv_nmos w=0.74u l=0.13u
XN1ob0800 o_ob0800 b1_ob0800 ns_ob0800 0 sg13_lv_nmos w=0.74u l=0.13u
CX1ob0800 nt_ob0800 s_ob0800 0.1f
CX2ob0800 ns_ob0800 0 0.1f
CLob0800 o_ob0800 0 2f
VSob1200 s_ob1200 0 PWL(0 0 100p 0 102p 1.2000000)
VA1ob1200 a1_ob1200 0 0
VA2ob1200 a2_ob1200 0 0
VB1ob1200 b1_ob1200 0 1.6500000
XP0ob1200 nt_ob1200 a1_ob1200 s_ob1200 s_ob1200 sg13_lv_pmos w=1.12u l=0.13u
XP1ob1200 o_ob1200 a2_ob1200 nt_ob1200 s_ob1200 sg13_lv_pmos w=1.12u l=0.13u
XP2ob1200 o_ob1200 b1_ob1200 s_ob1200 s_ob1200 sg13_lv_pmos w=1.12u l=0.13u
XN0ob1200 ns_ob1200 a2_ob1200 0 0 sg13_lv_nmos w=0.74u l=0.13u
XN2ob1200 ns_ob1200 a1_ob1200 0 0 sg13_lv_nmos w=0.74u l=0.13u
XN1ob1200 o_ob1200 b1_ob1200 ns_ob1200 0 sg13_lv_nmos w=0.74u l=0.13u
CX1ob1200 nt_ob1200 s_ob1200 0.1f
CX2ob1200 ns_ob1200 0 0.1f
CLob1200 o_ob1200 0 2f
VSzc s_zc 0 1.2000000
VIzc i_zc 0 PWL(0 1.2000000 100p 1.2000000 102p 0)
XPzc o_zc i_zc s_zc s_zc sg13_lv_pmos w=1.12u l=0.13u
XNzc o_zc i_zc 0 0 sg13_lv_nmos w=0.74u l=0.13u
CLzc o_zc 0 2f
.tran 0.05p 2000p 0 0.2p
.measure tran T50o0600 WHEN V(o_o0600)=0.30000000 RISE=1
.measure tran T80o0600 WHEN V(o_o0600)=0.48000000 RISE=1
.measure tran T90o0600 WHEN V(o_o0600)=0.54000000 RISE=1
.measure tran T95o0600 WHEN V(o_o0600)=0.57000000 RISE=1
.measure tran T50o0800 WHEN V(o_o0800)=0.40000000 RISE=1
.measure tran T80o0800 WHEN V(o_o0800)=0.64000000 RISE=1
.measure tran T90o0800 WHEN V(o_o0800)=0.72000000 RISE=1
.measure tran T95o0800 WHEN V(o_o0800)=0.76000000 RISE=1
.measure tran T50o1000 WHEN V(o_o1000)=0.50000000 RISE=1
.measure tran T80o1000 WHEN V(o_o1000)=0.80000000 RISE=1
.measure tran T90o1000 WHEN V(o_o1000)=0.90000000 RISE=1
.measure tran T95o1000 WHEN V(o_o1000)=0.95000000 RISE=1
.measure tran T50o1200 WHEN V(o_o1200)=0.60000000 RISE=1
.measure tran T80o1200 WHEN V(o_o1200)=0.96000000 RISE=1
.measure tran T90o1200 WHEN V(o_o1200)=1.08000000 RISE=1
.measure tran T95o1200 WHEN V(o_o1200)=1.14000000 RISE=1
.measure tran T50o1320 WHEN V(o_o1320)=0.66000000 RISE=1
.measure tran T80o1320 WHEN V(o_o1320)=1.05600000 RISE=1
.measure tran T90o1320 WHEN V(o_o1320)=1.18800000 RISE=1
.measure tran T95o1320 WHEN V(o_o1320)=1.25400000 RISE=1
.measure tran T50o1350 WHEN V(o_o1350)=0.67500000 RISE=1
.measure tran T80o1350 WHEN V(o_o1350)=1.08000000 RISE=1
.measure tran T90o1350 WHEN V(o_o1350)=1.21500000 RISE=1
.measure tran T95o1350 WHEN V(o_o1350)=1.28250000 RISE=1
.measure tran T50o1500 WHEN V(o_o1500)=0.75000000 RISE=1
.measure tran T80o1500 WHEN V(o_o1500)=1.20000000 RISE=1
.measure tran T90o1500 WHEN V(o_o1500)=1.35000000 RISE=1
.measure tran T95o1500 WHEN V(o_o1500)=1.42500000 RISE=1
.measure tran T50o1650 WHEN V(o_o1650)=0.82500000 RISE=1
.measure tran T80o1650 WHEN V(o_o1650)=1.32000000 RISE=1
.measure tran T90o1650 WHEN V(o_o1650)=1.48500000 RISE=1
.measure tran T95o1650 WHEN V(o_o1650)=1.56750000 RISE=1
.measure tran T50ob0800 WHEN V(o_ob0800)=0.40000000 RISE=1
.measure tran T80ob0800 WHEN V(o_ob0800)=0.64000000 RISE=1
.measure tran T90ob0800 WHEN V(o_ob0800)=0.72000000 RISE=1
.measure tran T95ob0800 WHEN V(o_ob0800)=0.76000000 RISE=1
.measure tran T50ob1200 WHEN V(o_ob1200)=0.60000000 RISE=1
.measure tran T80ob1200 WHEN V(o_ob1200)=0.96000000 RISE=1
.measure tran T90ob1200 WHEN V(o_ob1200)=1.08000000 RISE=1
.measure tran T95ob1200 WHEN V(o_ob1200)=1.14000000 RISE=1
.measure tran T50zc WHEN V(o_zc)=0.60000000 RISE=1
.measure tran T80zc WHEN V(o_zc)=0.96000000 RISE=1
.measure tran T90zc WHEN V(o_zc)=1.08000000 RISE=1
.measure tran T95zc WHEN V(o_zc)=1.14000000 RISE=1
.print tran V(o_o0600) V(o_o0800) V(o_o1000) V(o_o1200) V(o_o1320) V(o_o1350) V(o_o1500) V(o_o1650)
+ V(o_ob0800) V(o_ob1200) V(o_zc)
.end
