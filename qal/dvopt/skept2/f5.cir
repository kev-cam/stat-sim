.hdl "/usr/local/share/xyce/verilog-a/psp103/psp103.va"
.include "/usr/local/src/kestrel/sim/models/sg13g2_psp103_tt.lib"
.include "/usr/local/src/stat-sim/qal/sg13lv_compat.sp"
.OPTIONS TIMEINT METHOD=GEAR RELTOL=1e-6 ABSTOL=1e-15 CHGTOL=1e-17
VSv008249330 s_v008249330 0 PWL(0 0 100p 0 102p 0.8249330)
VIv008249330 i_v008249330 0 0
XPv008249330 o_v008249330 i_v008249330 s_v008249330 s_v008249330 sg13_lv_pmos w=1.12u l=0.13u
XNv008249330 o_v008249330 i_v008249330 0 0 sg13_lv_nmos w=0.74u l=0.13u
CLv008249330 o_v008249330 0 2f
VSv008354156 s_v008354156 0 PWL(0 0 100p 0 102p 0.8354156)
VIv008354156 i_v008354156 0 0
XPv008354156 o_v008354156 i_v008354156 s_v008354156 s_v008354156 sg13_lv_pmos w=1.12u l=0.13u
XNv008354156 o_v008354156 i_v008354156 0 0 sg13_lv_nmos w=0.74u l=0.13u
CLv008354156 o_v008354156 0 2f
VSv008779144 s_v008779144 0 PWL(0 0 100p 0 102p 0.8779144)
VIv008779144 i_v008779144 0 0
XPv008779144 o_v008779144 i_v008779144 s_v008779144 s_v008779144 sg13_lv_pmos w=1.12u l=0.13u
XNv008779144 o_v008779144 i_v008779144 0 0 sg13_lv_nmos w=0.74u l=0.13u
CLv008779144 o_v008779144 0 2f
VSv008961159 s_v008961159 0 PWL(0 0 100p 0 102p 0.8961159)
VIv008961159 i_v008961159 0 0
XPv008961159 o_v008961159 i_v008961159 s_v008961159 s_v008961159 sg13_lv_pmos w=1.12u l=0.13u
XNv008961159 o_v008961159 i_v008961159 0 0 sg13_lv_nmos w=0.74u l=0.13u
CLv008961159 o_v008961159 0 2f
VSv009116509 s_v009116509 0 PWL(0 0 100p 0 102p 0.9116509)
VIv009116509 i_v009116509 0 0
XPv009116509 o_v009116509 i_v009116509 s_v009116509 s_v009116509 sg13_lv_pmos w=1.12u l=0.13u
XNv009116509 o_v009116509 i_v009116509 0 0 sg13_lv_nmos w=0.74u l=0.13u
CLv009116509 o_v009116509 0 2f
VSv009133573 s_v009133573 0 PWL(0 0 100p 0 102p 0.9133573)
VIv009133573 i_v009133573 0 0
XPv009133573 o_v009133573 i_v009133573 s_v009133573 s_v009133573 sg13_lv_pmos w=1.12u l=0.13u
XNv009133573 o_v009133573 i_v009133573 0 0 sg13_lv_nmos w=0.74u l=0.13u
CLv009133573 o_v009133573 0 2f
VSv009147288 s_v009147288 0 PWL(0 0 100p 0 102p 0.9147288)
VIv009147288 i_v009147288 0 0
XPv009147288 o_v009147288 i_v009147288 s_v009147288 s_v009147288 sg13_lv_pmos w=1.12u l=0.13u
XNv009147288 o_v009147288 i_v009147288 0 0 sg13_lv_nmos w=0.74u l=0.13u
CLv009147288 o_v009147288 0 2f
VSv009197102 s_v009197102 0 PWL(0 0 100p 0 102p 0.9197102)
VIv009197102 i_v009197102 0 0
XPv009197102 o_v009197102 i_v009197102 s_v009197102 s_v009197102 sg13_lv_pmos w=1.12u l=0.13u
XNv009197102 o_v009197102 i_v009197102 0 0 sg13_lv_nmos w=0.74u l=0.13u
CLv009197102 o_v009197102 0 2f
VSv009225238 s_v009225238 0 PWL(0 0 100p 0 102p 0.9225238)
VIv009225238 i_v009225238 0 0
XPv009225238 o_v009225238 i_v009225238 s_v009225238 s_v009225238 sg13_lv_pmos w=1.12u l=0.13u
XNv009225238 o_v009225238 i_v009225238 0 0 sg13_lv_nmos w=0.74u l=0.13u
CLv009225238 o_v009225238 0 2f
VSv009301738 s_v009301738 0 PWL(0 0 100p 0 102p 0.9301738)
VIv009301738 i_v009301738 0 0
XPv009301738 o_v009301738 i_v009301738 s_v009301738 s_v009301738 sg13_lv_pmos w=1.12u l=0.13u
XNv009301738 o_v009301738 i_v009301738 0 0 sg13_lv_nmos w=0.74u l=0.13u
CLv009301738 o_v009301738 0 2f
VSv009345467 s_v009345467 0 PWL(0 0 100p 0 102p 0.9345467)
VIv009345467 i_v009345467 0 0
XPv009345467 o_v009345467 i_v009345467 s_v009345467 s_v009345467 sg13_lv_pmos w=1.12u l=0.13u
XNv009345467 o_v009345467 i_v009345467 0 0 sg13_lv_nmos w=0.74u l=0.13u
CLv009345467 o_v009345467 0 2f
VSv009373642 s_v009373642 0 PWL(0 0 100p 0 102p 0.9373642)
VIv009373642 i_v009373642 0 0
XPv009373642 o_v009373642 i_v009373642 s_v009373642 s_v009373642 sg13_lv_pmos w=1.12u l=0.13u
XNv009373642 o_v009373642 i_v009373642 0 0 sg13_lv_nmos w=0.74u l=0.13u
CLv009373642 o_v009373642 0 2f
VSv009402804 s_v009402804 0 PWL(0 0 100p 0 102p 0.9402804)
VIv009402804 i_v009402804 0 0
XPv009402804 o_v009402804 i_v009402804 s_v009402804 s_v009402804 sg13_lv_pmos w=1.12u l=0.13u
XNv009402804 o_v009402804 i_v009402804 0 0 sg13_lv_nmos w=0.74u l=0.13u
CLv009402804 o_v009402804 0 2f
VSv009471547 s_v009471547 0 PWL(0 0 100p 0 102p 0.9471547)
VIv009471547 i_v009471547 0 0
XPv009471547 o_v009471547 i_v009471547 s_v009471547 s_v009471547 sg13_lv_pmos w=1.12u l=0.13u
XNv009471547 o_v009471547 i_v009471547 0 0 sg13_lv_nmos w=0.74u l=0.13u
CLv009471547 o_v009471547 0 2f
VSv009592325 s_v009592325 0 PWL(0 0 100p 0 102p 0.9592325)
VIv009592325 i_v009592325 0 0
XPv009592325 o_v009592325 i_v009592325 s_v009592325 s_v009592325 sg13_lv_pmos w=1.12u l=0.13u
XNv009592325 o_v009592325 i_v009592325 0 0 sg13_lv_nmos w=0.74u l=0.13u
CLv009592325 o_v009592325 0 2f
VSv009599666 s_v009599666 0 PWL(0 0 100p 0 102p 0.9599666)
VIv009599666 i_v009599666 0 0
XPv009599666 o_v009599666 i_v009599666 s_v009599666 s_v009599666 sg13_lv_pmos w=1.12u l=0.13u
XNv009599666 o_v009599666 i_v009599666 0 0 sg13_lv_nmos w=0.74u l=0.13u
CLv009599666 o_v009599666 0 2f
VSv009691766 s_v009691766 0 PWL(0 0 100p 0 102p 0.9691766)
VIv009691766 i_v009691766 0 0
XPv009691766 o_v009691766 i_v009691766 s_v009691766 s_v009691766 sg13_lv_pmos w=1.12u l=0.13u
XNv009691766 o_v009691766 i_v009691766 0 0 sg13_lv_nmos w=0.74u l=0.13u
CLv009691766 o_v009691766 0 2f
VSv009783934 s_v009783934 0 PWL(0 0 100p 0 102p 0.9783934)
VIv009783934 i_v009783934 0 0
XPv009783934 o_v009783934 i_v009783934 s_v009783934 s_v009783934 sg13_lv_pmos w=1.12u l=0.13u
XNv009783934 o_v009783934 i_v009783934 0 0 sg13_lv_nmos w=0.74u l=0.13u
CLv009783934 o_v009783934 0 2f
VSv009813494 s_v009813494 0 PWL(0 0 100p 0 102p 0.9813494)
VIv009813494 i_v009813494 0 0
XPv009813494 o_v009813494 i_v009813494 s_v009813494 s_v009813494 sg13_lv_pmos w=1.12u l=0.13u
XNv009813494 o_v009813494 i_v009813494 0 0 sg13_lv_nmos w=0.74u l=0.13u
CLv009813494 o_v009813494 0 2f
VSv009828885 s_v009828885 0 PWL(0 0 100p 0 102p 0.9828885)
VIv009828885 i_v009828885 0 0
XPv009828885 o_v009828885 i_v009828885 s_v009828885 s_v009828885 sg13_lv_pmos w=1.12u l=0.13u
XNv009828885 o_v009828885 i_v009828885 0 0 sg13_lv_nmos w=0.74u l=0.13u
CLv009828885 o_v009828885 0 2f
VSv009919974 s_v009919974 0 PWL(0 0 100p 0 102p 0.9919974)
VIv009919974 i_v009919974 0 0
XPv009919974 o_v009919974 i_v009919974 s_v009919974 s_v009919974 sg13_lv_pmos w=1.12u l=0.13u
XNv009919974 o_v009919974 i_v009919974 0 0 sg13_lv_nmos w=0.74u l=0.13u
CLv009919974 o_v009919974 0 2f
VSzc s_zc 0 1.2000000
VIzc i_zc 0 PWL(0 1.2000000 100p 1.2000000 102p 0)
XPzc o_zc i_zc s_zc s_zc sg13_lv_pmos w=1.12u l=0.13u
XNzc o_zc i_zc 0 0 sg13_lv_nmos w=0.74u l=0.13u
CLzc o_zc 0 2f
.tran 0.05p 600p 0 0.2p
.measure tran T50v008249330 WHEN V(o_v008249330)=0.41246650 RISE=1
.measure tran T80v008249330 WHEN V(o_v008249330)=0.65994640 RISE=1
.measure tran T90v008249330 WHEN V(o_v008249330)=0.74243970 RISE=1
.measure tran T95v008249330 WHEN V(o_v008249330)=0.78368635 RISE=1
.measure tran T50v008354156 WHEN V(o_v008354156)=0.41770780 RISE=1
.measure tran T80v008354156 WHEN V(o_v008354156)=0.66833248 RISE=1
.measure tran T90v008354156 WHEN V(o_v008354156)=0.75187404 RISE=1
.measure tran T95v008354156 WHEN V(o_v008354156)=0.79364482 RISE=1
.measure tran T50v008779144 WHEN V(o_v008779144)=0.43895720 RISE=1
.measure tran T80v008779144 WHEN V(o_v008779144)=0.70233152 RISE=1
.measure tran T90v008779144 WHEN V(o_v008779144)=0.79012296 RISE=1
.measure tran T95v008779144 WHEN V(o_v008779144)=0.83401868 RISE=1
.measure tran T50v008961159 WHEN V(o_v008961159)=0.44805795 RISE=1
.measure tran T80v008961159 WHEN V(o_v008961159)=0.71689272 RISE=1
.measure tran T90v008961159 WHEN V(o_v008961159)=0.80650431 RISE=1
.measure tran T95v008961159 WHEN V(o_v008961159)=0.85131010 RISE=1
.measure tran T50v009116509 WHEN V(o_v009116509)=0.45582545 RISE=1
.measure tran T80v009116509 WHEN V(o_v009116509)=0.72932072 RISE=1
.measure tran T90v009116509 WHEN V(o_v009116509)=0.82048581 RISE=1
.measure tran T95v009116509 WHEN V(o_v009116509)=0.86606836 RISE=1
.measure tran T50v009133573 WHEN V(o_v009133573)=0.45667865 RISE=1
.measure tran T80v009133573 WHEN V(o_v009133573)=0.73068584 RISE=1
.measure tran T90v009133573 WHEN V(o_v009133573)=0.82202157 RISE=1
.measure tran T95v009133573 WHEN V(o_v009133573)=0.86768943 RISE=1
.measure tran T50v009147288 WHEN V(o_v009147288)=0.45736440 RISE=1
.measure tran T80v009147288 WHEN V(o_v009147288)=0.73178304 RISE=1
.measure tran T90v009147288 WHEN V(o_v009147288)=0.82325592 RISE=1
.measure tran T95v009147288 WHEN V(o_v009147288)=0.86899236 RISE=1
.measure tran T50v009197102 WHEN V(o_v009197102)=0.45985510 RISE=1
.measure tran T80v009197102 WHEN V(o_v009197102)=0.73576816 RISE=1
.measure tran T90v009197102 WHEN V(o_v009197102)=0.82773918 RISE=1
.measure tran T95v009197102 WHEN V(o_v009197102)=0.87372469 RISE=1
.measure tran T50v009225238 WHEN V(o_v009225238)=0.46126190 RISE=1
.measure tran T80v009225238 WHEN V(o_v009225238)=0.73801904 RISE=1
.measure tran T90v009225238 WHEN V(o_v009225238)=0.83027142 RISE=1
.measure tran T95v009225238 WHEN V(o_v009225238)=0.87639761 RISE=1
.measure tran T50v009301738 WHEN V(o_v009301738)=0.46508690 RISE=1
.measure tran T80v009301738 WHEN V(o_v009301738)=0.74413904 RISE=1
.measure tran T90v009301738 WHEN V(o_v009301738)=0.83715642 RISE=1
.measure tran T95v009301738 WHEN V(o_v009301738)=0.88366511 RISE=1
.measure tran T50v009345467 WHEN V(o_v009345467)=0.46727335 RISE=1
.measure tran T80v009345467 WHEN V(o_v009345467)=0.74763736 RISE=1
.measure tran T90v009345467 WHEN V(o_v009345467)=0.84109203 RISE=1
.measure tran T95v009345467 WHEN V(o_v009345467)=0.88781936 RISE=1
.measure tran T50v009373642 WHEN V(o_v009373642)=0.46868210 RISE=1
.measure tran T80v009373642 WHEN V(o_v009373642)=0.74989136 RISE=1
.measure tran T90v009373642 WHEN V(o_v009373642)=0.84362778 RISE=1
.measure tran T95v009373642 WHEN V(o_v009373642)=0.89049599 RISE=1
.measure tran T50v009402804 WHEN V(o_v009402804)=0.47014020 RISE=1
.measure tran T80v009402804 WHEN V(o_v009402804)=0.75222432 RISE=1
.measure tran T90v009402804 WHEN V(o_v009402804)=0.84625236 RISE=1
.measure tran T95v009402804 WHEN V(o_v009402804)=0.89326638 RISE=1
.measure tran T50v009471547 WHEN V(o_v009471547)=0.47357735 RISE=1
.measure tran T80v009471547 WHEN V(o_v009471547)=0.75772376 RISE=1
.measure tran T90v009471547 WHEN V(o_v009471547)=0.85243923 RISE=1
.measure tran T95v009471547 WHEN V(o_v009471547)=0.89979696 RISE=1
.measure tran T50v009592325 WHEN V(o_v009592325)=0.47961625 RISE=1
.measure tran T80v009592325 WHEN V(o_v009592325)=0.76738600 RISE=1
.measure tran T90v009592325 WHEN V(o_v009592325)=0.86330925 RISE=1
.measure tran T95v009592325 WHEN V(o_v009592325)=0.91127088 RISE=1
.measure tran T50v009599666 WHEN V(o_v009599666)=0.47998330 RISE=1
.measure tran T80v009599666 WHEN V(o_v009599666)=0.76797328 RISE=1
.measure tran T90v009599666 WHEN V(o_v009599666)=0.86396994 RISE=1
.measure tran T95v009599666 WHEN V(o_v009599666)=0.91196827 RISE=1
.measure tran T50v009691766 WHEN V(o_v009691766)=0.48458830 RISE=1
.measure tran T80v009691766 WHEN V(o_v009691766)=0.77534128 RISE=1
.measure tran T90v009691766 WHEN V(o_v009691766)=0.87225894 RISE=1
.measure tran T95v009691766 WHEN V(o_v009691766)=0.92071777 RISE=1
.measure tran T50v009783934 WHEN V(o_v009783934)=0.48919670 RISE=1
.measure tran T80v009783934 WHEN V(o_v009783934)=0.78271472 RISE=1
.measure tran T90v009783934 WHEN V(o_v009783934)=0.88055406 RISE=1
.measure tran T95v009783934 WHEN V(o_v009783934)=0.92947373 RISE=1
.measure tran T50v009813494 WHEN V(o_v009813494)=0.49067470 RISE=1
.measure tran T80v009813494 WHEN V(o_v009813494)=0.78507952 RISE=1
.measure tran T90v009813494 WHEN V(o_v009813494)=0.88321446 RISE=1
.measure tran T95v009813494 WHEN V(o_v009813494)=0.93228193 RISE=1
.measure tran T50v009828885 WHEN V(o_v009828885)=0.49144425 RISE=1
.measure tran T80v009828885 WHEN V(o_v009828885)=0.78631080 RISE=1
.measure tran T90v009828885 WHEN V(o_v009828885)=0.88459965 RISE=1
.measure tran T95v009828885 WHEN V(o_v009828885)=0.93374408 RISE=1
.measure tran T50v009919974 WHEN V(o_v009919974)=0.49599870 RISE=1
.measure tran T80v009919974 WHEN V(o_v009919974)=0.79359792 RISE=1
.measure tran T90v009919974 WHEN V(o_v009919974)=0.89279766 RISE=1
.measure tran T95v009919974 WHEN V(o_v009919974)=0.94239753 RISE=1
.measure tran T50zc WHEN V(o_zc)=0.60000000 RISE=1
.measure tran T80zc WHEN V(o_zc)=0.96000000 RISE=1
.measure tran T90zc WHEN V(o_zc)=1.08000000 RISE=1
.measure tran T95zc WHEN V(o_zc)=1.14000000 RISE=1
.print tran V(o_v008249330) V(o_v008354156) V(o_v008779144) V(o_v008961159) V(o_v009116509) V(o_v009133573) V(o_v009147288) V(o_v009197102)
+ V(o_v009225238) V(o_v009301738) V(o_v009345467) V(o_v009373642) V(o_v009402804) V(o_v009471547) V(o_v009592325) V(o_v009599666)
+ V(o_v009691766) V(o_v009783934) V(o_v009813494) V(o_v009828885) V(o_v009919974) V(o_zc)
.end
