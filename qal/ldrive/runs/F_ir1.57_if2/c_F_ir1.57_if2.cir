* qal/ldrive F Ir=1.57 If=2 two_slope=False pat=P0 -- committed trap_tt92_d3 deck with the VPH trapezoids replaced by ideal current-source drives (see ldrive.py)
.hdl "/usr/local/share/xyce/verilog-a/psp103/psp103.va"
.include "/usr/local/src/kestrel/sim/models/sg13g2_psp103_tt.lib"
.include "/usr/local/src/stat-sim/qal/sg13lv_compat.sp"
.OPTIONS TIMEINT METHOD=GEAR RELTOL=1e-6 ABSTOL=1e-15 CHGTOL=1e-17
IR1 0 ir1 PWL(0 -0.002 1p 0.00157 92p 0.00157 93p 0 184p 0 185p -0.002 276p -0.002 277p 0.00157 368p 0.00157 369p 0 460p 0 461p -0.002 552p -0.002 553p 0.00157 644p 0.00157 645p 0 736p 0 737p -0.002 828p -0.002 829p 0.00157 920p 0.00157 921p 0 1012p 0 1013p -0.002 1104p -0.002 1105p 0.00157 1196p 0.00157 1197p 0 1288p 0 1289p -0.002 1380p -0.002 1381p 0.00157 1472p 0.00157 1473p 0 1564p 0 1565p -0.002 1656p -0.002 1657p 0.00157 1748p 0.00157 1749p 0 1840p 0 1841p -0.002 1932p -0.002 1933p 0.00157 2024p 0.00157 2025p 0 2116p 0 2117p -0.002 2208p -0.002 2209p 0.00157)
VCT1 ct1 0 PWL(0 0 92p 0 93p 1 184p 1 185p 0 368p 0 369p 1 460p 1 461p 0 644p 0 645p 1 736p 1 737p 0 920p 0 921p 1 1012p 1 1013p 0 1196p 0 1197p 1 1288p 1 1289p 0 1472p 0 1473p 1 1564p 1 1565p 0 1748p 0 1749p 1 1840p 1 1841p 0 2024p 0 2025p 1 2116p 1 2117p 0)
VCB1 cb1 0 PWL(0 1 1p 0 274p 0 275p 1 276p 1 277p 0 550p 0 551p 1 552p 1 553p 0 826p 0 827p 1 828p 1 829p 0 1102p 0 1103p 1 1104p 1 1105p 0 1378p 0 1379p 1 1380p 1 1381p 0 1654p 0 1655p 1 1656p 1 1657p 0 1930p 0 1931p 1 1932p 1 1933p 0 2206p 0 2207p 1 2208p 1 2209p 0)
VAIR1 ir1 drv1 0
VPH1 phs1 drv1 0
VH1 vh1 0 DC 1.65
BSH1 vh1 drv1 I={ 1*V(ct1)*(V(vh1)-V(drv1)) }
VF1 fl1 0 DC 0
BSF1 drv1 fl1 I={ 1*V(cb1)*V(drv1) }
BSD1 drv1 fl1 I={ 1*0.5*(V(drv1)-sqrt(V(drv1)*V(drv1)+1e-10)) }
RS1 phs1 ph1 0.001
IR2 0 ir2 PWL(0 0 1p -0.002 92p -0.002 93p 0.00157 184p 0.00157 185p 0 276p 0 277p -0.002 368p -0.002 369p 0.00157 460p 0.00157 461p 0 552p 0 553p -0.002 644p -0.002 645p 0.00157 736p 0.00157 737p 0 828p 0 829p -0.002 920p -0.002 921p 0.00157 1012p 0.00157 1013p 0 1104p 0 1105p -0.002 1196p -0.002 1197p 0.00157 1288p 0.00157 1289p 0 1380p 0 1381p -0.002 1472p -0.002 1473p 0.00157 1564p 0.00157 1565p 0 1656p 0 1657p -0.002 1748p -0.002 1749p 0.00157 1840p 0.00157 1841p 0 1932p 0 1933p -0.002 2024p -0.002 2025p 0.00157 2116p 0.00157 2117p 0 2208p 0 2209p -0.002)
VCT2 ct2 0 PWL(0 1 1p 0 184p 0 185p 1 276p 1 277p 0 460p 0 461p 1 552p 1 553p 0 736p 0 737p 1 828p 1 829p 0 1012p 0 1013p 1 1104p 1 1105p 0 1288p 0 1289p 1 1380p 1 1381p 0 1564p 0 1565p 1 1656p 1 1657p 0 1840p 0 1841p 1 1932p 1 1933p 0 2116p 0 2117p 1 2208p 1 2209p 0)
VCB2 cb2 0 PWL(0 0 90p 0 91p 1 92p 1 93p 0 366p 0 367p 1 368p 1 369p 0 642p 0 643p 1 644p 1 645p 0 918p 0 919p 1 920p 1 921p 0 1194p 0 1195p 1 1196p 1 1197p 0 1470p 0 1471p 1 1472p 1 1473p 0 1746p 0 1747p 1 1748p 1 1749p 0 2022p 0 2023p 1 2024p 1 2025p 0)
VAIR2 ir2 drv2 0
VPH2 phs2 drv2 0
VH2 vh2 0 DC 1.65
BSH2 vh2 drv2 I={ 1*V(ct2)*(V(vh2)-V(drv2)) }
VF2 fl2 0 DC 0
BSF2 drv2 fl2 I={ 1*V(cb2)*V(drv2) }
BSD2 drv2 fl2 I={ 1*0.5*(V(drv2)-sqrt(V(drv2)*V(drv2)+1e-10)) }
RS2 phs2 ph2 0.001
IR3 0 ir3 PWL(0 0.00157 1p 0 92p 0 93p -0.002 184p -0.002 185p 0.00157 276p 0.00157 277p 0 368p 0 369p -0.002 460p -0.002 461p 0.00157 552p 0.00157 553p 0 644p 0 645p -0.002 736p -0.002 737p 0.00157 828p 0.00157 829p 0 920p 0 921p -0.002 1012p -0.002 1013p 0.00157 1104p 0.00157 1105p 0 1196p 0 1197p -0.002 1288p -0.002 1289p 0.00157 1380p 0.00157 1381p 0 1472p 0 1473p -0.002 1564p -0.002 1565p 0.00157 1656p 0.00157 1657p 0 1748p 0 1749p -0.002 1840p -0.002 1841p 0.00157 1932p 0.00157 1933p 0 2024p 0 2025p -0.002 2116p -0.002 2117p 0.00157 2208p 0.00157 2209p 0)
VCT3 ct3 0 PWL(0 1 92p 1 93p 0 276p 0 277p 1 368p 1 369p 0 552p 0 553p 1 644p 1 645p 0 828p 0 829p 1 920p 1 921p 0 1104p 0 1105p 1 1196p 1 1197p 0 1380p 0 1381p 1 1472p 1 1473p 0 1656p 0 1657p 1 1748p 1 1749p 0 1932p 0 1933p 1 2024p 1 2025p 0 2208p 0 2209p 1)
VCB3 cb3 0 PWL(0 0 182p 0 183p 1 184p 1 185p 0 458p 0 459p 1 460p 1 461p 0 734p 0 735p 1 736p 1 737p 0 1010p 0 1011p 1 1012p 1 1013p 0 1286p 0 1287p 1 1288p 1 1289p 0 1562p 0 1563p 1 1564p 1 1565p 0 1838p 0 1839p 1 1840p 1 1841p 0 2114p 0 2115p 1 2116p 1 2117p 0)
VAIR3 ir3 drv3 0
VPH3 phs3 drv3 0
VH3 vh3 0 DC 1.65
BSH3 vh3 drv3 I={ 1*V(ct3)*(V(vh3)-V(drv3)) }
VF3 fl3 0 DC 0
BSF3 drv3 fl3 I={ 1*V(cb3)*V(drv3) }
BSD3 drv3 fl3 I={ 1*0.5*(V(drv3)-sqrt(V(drv3)*V(drv3)+1e-10)) }
RS3 phs3 ph3 0.001
IR4 0 ir4 PWL(0 -0.002 1p 0.00157 92p 0.00157 93p 0 184p 0 185p -0.002 276p -0.002 277p 0.00157 368p 0.00157 369p 0 460p 0 461p -0.002 552p -0.002 553p 0.00157 644p 0.00157 645p 0 736p 0 737p -0.002 828p -0.002 829p 0.00157 920p 0.00157 921p 0 1012p 0 1013p -0.002 1104p -0.002 1105p 0.00157 1196p 0.00157 1197p 0 1288p 0 1289p -0.002 1380p -0.002 1381p 0.00157 1472p 0.00157 1473p 0 1564p 0 1565p -0.002 1656p -0.002 1657p 0.00157 1748p 0.00157 1749p 0 1840p 0 1841p -0.002 1932p -0.002 1933p 0.00157 2024p 0.00157 2025p 0 2116p 0 2117p -0.002 2208p -0.002 2209p 0.00157)
VCT4 ct4 0 PWL(0 0 92p 0 93p 1 184p 1 185p 0 368p 0 369p 1 460p 1 461p 0 644p 0 645p 1 736p 1 737p 0 920p 0 921p 1 1012p 1 1013p 0 1196p 0 1197p 1 1288p 1 1289p 0 1472p 0 1473p 1 1564p 1 1565p 0 1748p 0 1749p 1 1840p 1 1841p 0 2024p 0 2025p 1 2116p 1 2117p 0)
VCB4 cb4 0 PWL(0 1 1p 0 274p 0 275p 1 276p 1 277p 0 550p 0 551p 1 552p 1 553p 0 826p 0 827p 1 828p 1 829p 0 1102p 0 1103p 1 1104p 1 1105p 0 1378p 0 1379p 1 1380p 1 1381p 0 1654p 0 1655p 1 1656p 1 1657p 0 1930p 0 1931p 1 1932p 1 1933p 0 2206p 0 2207p 1 2208p 1 2209p 0)
VAIR4 ir4 drv4 0
VPH4 phs4 drv4 0
VH4 vh4 0 DC 1.65
BSH4 vh4 drv4 I={ 1*V(ct4)*(V(vh4)-V(drv4)) }
VF4 fl4 0 DC 0
BSF4 drv4 fl4 I={ 1*V(cb4)*V(drv4) }
BSD4 drv4 fl4 I={ 1*0.5*(V(drv4)-sqrt(V(drv4)*V(drv4)+1e-10)) }
RS4 phs4 ph4 0.001
IR5 0 ir5 PWL(0 0 1p -0.002 92p -0.002 93p 0.00157 184p 0.00157 185p 0 276p 0 277p -0.002 368p -0.002 369p 0.00157 460p 0.00157 461p 0 552p 0 553p -0.002 644p -0.002 645p 0.00157 736p 0.00157 737p 0 828p 0 829p -0.002 920p -0.002 921p 0.00157 1012p 0.00157 1013p 0 1104p 0 1105p -0.002 1196p -0.002 1197p 0.00157 1288p 0.00157 1289p 0 1380p 0 1381p -0.002 1472p -0.002 1473p 0.00157 1564p 0.00157 1565p 0 1656p 0 1657p -0.002 1748p -0.002 1749p 0.00157 1840p 0.00157 1841p 0 1932p 0 1933p -0.002 2024p -0.002 2025p 0.00157 2116p 0.00157 2117p 0 2208p 0 2209p -0.002)
VCT5 ct5 0 PWL(0 1 1p 0 184p 0 185p 1 276p 1 277p 0 460p 0 461p 1 552p 1 553p 0 736p 0 737p 1 828p 1 829p 0 1012p 0 1013p 1 1104p 1 1105p 0 1288p 0 1289p 1 1380p 1 1381p 0 1564p 0 1565p 1 1656p 1 1657p 0 1840p 0 1841p 1 1932p 1 1933p 0 2116p 0 2117p 1 2208p 1 2209p 0)
VCB5 cb5 0 PWL(0 0 90p 0 91p 1 92p 1 93p 0 366p 0 367p 1 368p 1 369p 0 642p 0 643p 1 644p 1 645p 0 918p 0 919p 1 920p 1 921p 0 1194p 0 1195p 1 1196p 1 1197p 0 1470p 0 1471p 1 1472p 1 1473p 0 1746p 0 1747p 1 1748p 1 1749p 0 2022p 0 2023p 1 2024p 1 2025p 0)
VAIR5 ir5 drv5 0
VPH5 phs5 drv5 0
VH5 vh5 0 DC 1.65
BSH5 vh5 drv5 I={ 1*V(ct5)*(V(vh5)-V(drv5)) }
VF5 fl5 0 DC 0
BSF5 drv5 fl5 I={ 1*V(cb5)*V(drv5) }
BSD5 drv5 fl5 I={ 1*0.5*(V(drv5)-sqrt(V(drv5)*V(drv5)+1e-10)) }
RS5 phs5 ph5 0.001
IR6 0 ir6 PWL(0 0.00157 1p 0 92p 0 93p -0.002 184p -0.002 185p 0.00157 276p 0.00157 277p 0 368p 0 369p -0.002 460p -0.002 461p 0.00157 552p 0.00157 553p 0 644p 0 645p -0.002 736p -0.002 737p 0.00157 828p 0.00157 829p 0 920p 0 921p -0.002 1012p -0.002 1013p 0.00157 1104p 0.00157 1105p 0 1196p 0 1197p -0.002 1288p -0.002 1289p 0.00157 1380p 0.00157 1381p 0 1472p 0 1473p -0.002 1564p -0.002 1565p 0.00157 1656p 0.00157 1657p 0 1748p 0 1749p -0.002 1840p -0.002 1841p 0.00157 1932p 0.00157 1933p 0 2024p 0 2025p -0.002 2116p -0.002 2117p 0.00157 2208p 0.00157 2209p 0)
VCT6 ct6 0 PWL(0 1 92p 1 93p 0 276p 0 277p 1 368p 1 369p 0 552p 0 553p 1 644p 1 645p 0 828p 0 829p 1 920p 1 921p 0 1104p 0 1105p 1 1196p 1 1197p 0 1380p 0 1381p 1 1472p 1 1473p 0 1656p 0 1657p 1 1748p 1 1749p 0 1932p 0 1933p 1 2024p 1 2025p 0 2208p 0 2209p 1)
VCB6 cb6 0 PWL(0 0 182p 0 183p 1 184p 1 185p 0 458p 0 459p 1 460p 1 461p 0 734p 0 735p 1 736p 1 737p 0 1010p 0 1011p 1 1012p 1 1013p 0 1286p 0 1287p 1 1288p 1 1289p 0 1562p 0 1563p 1 1564p 1 1565p 0 1838p 0 1839p 1 1840p 1 1841p 0 2114p 0 2115p 1 2116p 1 2117p 0)
VAIR6 ir6 drv6 0
VPH6 phs6 drv6 0
VH6 vh6 0 DC 1.65
BSH6 vh6 drv6 I={ 1*V(ct6)*(V(vh6)-V(drv6)) }
VF6 fl6 0 DC 0
BSF6 drv6 fl6 I={ 1*V(cb6)*V(drv6) }
BSD6 drv6 fl6 I={ 1*0.5*(V(drv6)-sqrt(V(drv6)*V(drv6)+1e-10)) }
RS6 phs6 ph6 0.001
VI1_0 in1_0 0 PWL(0 1.65 275p 1.65 277p 0 551p 0 553p 1.65 827p 1.65 829p 0 1103p 0 1105p 1.65 1379p 1.65 1381p 0 1655p 0 1657p 1.65 1931p 1.65 1933p 0)
VI1_1 in1_1 0 PWL(0 1.65 275p 1.65 277p 0 551p 0 553p 1.65 827p 1.65 829p 0 1103p 0 1105p 1.65 1379p 1.65 1381p 0 1655p 0 1657p 1.65 1931p 1.65 1933p 0)
VI1_2 in1_2 0 PWL(0 1.65 275p 1.65 277p 0 551p 0 553p 1.65 827p 1.65 829p 0 1103p 0 1105p 1.65 1379p 1.65 1381p 0 1655p 0 1657p 1.65 1931p 1.65 1933p 0)
VI1_3 in1_3 0 PWL(0 0 275p 0 277p 1.65 551p 1.65 553p 0 827p 0 829p 1.65 1103p 1.65 1105p 0 1379p 0 1381p 1.65 1655p 1.65 1657p 0 1931p 0 1933p 1.65)
VI1_4 in1_4 0 PWL(0 1.65 275p 1.65 277p 0 551p 0 553p 1.65 827p 1.65 829p 0 1103p 0 1105p 1.65 1379p 1.65 1381p 0 1655p 0 1657p 1.65 1931p 1.65 1933p 0)
VI1_5 in1_5 0 PWL(0 0 275p 0 277p 1.65 551p 1.65 553p 0 827p 0 829p 1.65 1103p 1.65 1105p 0 1379p 0 1381p 1.65 1655p 1.65 1657p 0 1931p 0 1933p 1.65)
VI1_6 in1_6 0 PWL(0 0 275p 0 277p 1.65 551p 1.65 553p 0 827p 0 829p 1.65 1103p 1.65 1105p 0 1379p 0 1381p 1.65 1655p 1.65 1657p 0 1931p 0 1933p 1.65)
VI1_7 in1_7 0 PWL(0 1.65 275p 1.65 277p 0 551p 0 553p 1.65 827p 1.65 829p 0 1103p 0 1105p 1.65 1379p 1.65 1381p 0 1655p 0 1657p 1.65 1931p 1.65 1933p 0)
VMG1 gn1 0 0
XP1_1_0 o1_1_0 in1_0 ph1 ph1 sg13_lv_pmos w=1.12u l=0.13u
XN1_1_0 o1_1_0 in1_0 gn1 gn1 sg13_lv_nmos w=0.74u l=0.13u
CL1_1_0 o1_1_0 gn1 2f
XP1_1_1 o1_1_1 in1_1 ph1 ph1 sg13_lv_pmos w=1.12u l=0.13u
XN1_1_1 o1_1_1 in1_1 gn1 gn1 sg13_lv_nmos w=0.74u l=0.13u
CL1_1_1 o1_1_1 gn1 2f
XP1_1_2 o1_1_2 in1_2 ph1 ph1 sg13_lv_pmos w=1.12u l=0.13u
XN1_1_2 o1_1_2 in1_2 gn1 gn1 sg13_lv_nmos w=0.74u l=0.13u
CL1_1_2 o1_1_2 gn1 2f
XP1_1_3 o1_1_3 in1_3 ph1 ph1 sg13_lv_pmos w=1.12u l=0.13u
XN1_1_3 o1_1_3 in1_3 gn1 gn1 sg13_lv_nmos w=0.74u l=0.13u
CL1_1_3 o1_1_3 gn1 2f
XP1_1_4 o1_1_4 in1_4 ph1 ph1 sg13_lv_pmos w=1.12u l=0.13u
XN1_1_4 o1_1_4 in1_4 gn1 gn1 sg13_lv_nmos w=0.74u l=0.13u
CL1_1_4 o1_1_4 gn1 2f
XP1_1_5 o1_1_5 in1_5 ph1 ph1 sg13_lv_pmos w=1.12u l=0.13u
XN1_1_5 o1_1_5 in1_5 gn1 gn1 sg13_lv_nmos w=0.74u l=0.13u
CL1_1_5 o1_1_5 gn1 2f
XP1_1_6 o1_1_6 in1_6 ph1 ph1 sg13_lv_pmos w=1.12u l=0.13u
XN1_1_6 o1_1_6 in1_6 gn1 gn1 sg13_lv_nmos w=0.74u l=0.13u
CL1_1_6 o1_1_6 gn1 2f
XP1_1_7 o1_1_7 in1_7 ph1 ph1 sg13_lv_pmos w=1.12u l=0.13u
XN1_1_7 o1_1_7 in1_7 gn1 gn1 sg13_lv_nmos w=0.74u l=0.13u
CL1_1_7 o1_1_7 gn1 2f
XP1_2_0 o1_2_0 o1_1_0 ph1 ph1 sg13_lv_pmos w=1.12u l=0.13u
XN1_2_0 o1_2_0 o1_1_0 gn1 gn1 sg13_lv_nmos w=0.74u l=0.13u
CL1_2_0 o1_2_0 gn1 2f
XP1_2_1 o1_2_1 o1_1_1 ph1 ph1 sg13_lv_pmos w=1.12u l=0.13u
XN1_2_1 o1_2_1 o1_1_1 gn1 gn1 sg13_lv_nmos w=0.74u l=0.13u
CL1_2_1 o1_2_1 gn1 2f
XP1_2_2 o1_2_2 o1_1_2 ph1 ph1 sg13_lv_pmos w=1.12u l=0.13u
XN1_2_2 o1_2_2 o1_1_2 gn1 gn1 sg13_lv_nmos w=0.74u l=0.13u
CL1_2_2 o1_2_2 gn1 2f
XP1_2_3 o1_2_3 o1_1_3 ph1 ph1 sg13_lv_pmos w=1.12u l=0.13u
XN1_2_3 o1_2_3 o1_1_3 gn1 gn1 sg13_lv_nmos w=0.74u l=0.13u
CL1_2_3 o1_2_3 gn1 2f
XP1_2_4 o1_2_4 o1_1_4 ph1 ph1 sg13_lv_pmos w=1.12u l=0.13u
XN1_2_4 o1_2_4 o1_1_4 gn1 gn1 sg13_lv_nmos w=0.74u l=0.13u
CL1_2_4 o1_2_4 gn1 2f
XP1_2_5 o1_2_5 o1_1_5 ph1 ph1 sg13_lv_pmos w=1.12u l=0.13u
XN1_2_5 o1_2_5 o1_1_5 gn1 gn1 sg13_lv_nmos w=0.74u l=0.13u
CL1_2_5 o1_2_5 gn1 2f
XP1_2_6 o1_2_6 o1_1_6 ph1 ph1 sg13_lv_pmos w=1.12u l=0.13u
XN1_2_6 o1_2_6 o1_1_6 gn1 gn1 sg13_lv_nmos w=0.74u l=0.13u
CL1_2_6 o1_2_6 gn1 2f
XP1_2_7 o1_2_7 o1_1_7 ph1 ph1 sg13_lv_pmos w=1.12u l=0.13u
XN1_2_7 o1_2_7 o1_1_7 gn1 gn1 sg13_lv_nmos w=0.74u l=0.13u
CL1_2_7 o1_2_7 gn1 2f
XP1_3_0 o1_3_0 o1_2_0 ph1 ph1 sg13_lv_pmos w=1.12u l=0.13u
XN1_3_0 o1_3_0 o1_2_0 gn1 gn1 sg13_lv_nmos w=0.74u l=0.13u
CL1_3_0 o1_3_0 gn1 2f
XP1_3_1 o1_3_1 o1_2_1 ph1 ph1 sg13_lv_pmos w=1.12u l=0.13u
XN1_3_1 o1_3_1 o1_2_1 gn1 gn1 sg13_lv_nmos w=0.74u l=0.13u
CL1_3_1 o1_3_1 gn1 2f
XP1_3_2 o1_3_2 o1_2_2 ph1 ph1 sg13_lv_pmos w=1.12u l=0.13u
XN1_3_2 o1_3_2 o1_2_2 gn1 gn1 sg13_lv_nmos w=0.74u l=0.13u
CL1_3_2 o1_3_2 gn1 2f
XP1_3_3 o1_3_3 o1_2_3 ph1 ph1 sg13_lv_pmos w=1.12u l=0.13u
XN1_3_3 o1_3_3 o1_2_3 gn1 gn1 sg13_lv_nmos w=0.74u l=0.13u
CL1_3_3 o1_3_3 gn1 2f
XP1_3_4 o1_3_4 o1_2_4 ph1 ph1 sg13_lv_pmos w=1.12u l=0.13u
XN1_3_4 o1_3_4 o1_2_4 gn1 gn1 sg13_lv_nmos w=0.74u l=0.13u
CL1_3_4 o1_3_4 gn1 2f
XP1_3_5 o1_3_5 o1_2_5 ph1 ph1 sg13_lv_pmos w=1.12u l=0.13u
XN1_3_5 o1_3_5 o1_2_5 gn1 gn1 sg13_lv_nmos w=0.74u l=0.13u
CL1_3_5 o1_3_5 gn1 2f
XP1_3_6 o1_3_6 o1_2_6 ph1 ph1 sg13_lv_pmos w=1.12u l=0.13u
XN1_3_6 o1_3_6 o1_2_6 gn1 gn1 sg13_lv_nmos w=0.74u l=0.13u
CL1_3_6 o1_3_6 gn1 2f
XP1_3_7 o1_3_7 o1_2_7 ph1 ph1 sg13_lv_pmos w=1.12u l=0.13u
XN1_3_7 o1_3_7 o1_2_7 gn1 gn1 sg13_lv_nmos w=0.74u l=0.13u
CL1_3_7 o1_3_7 gn1 2f
VMG2 gn2 0 0
XP2_1_0 o2_1_0 o1_3_0 ph2 ph2 sg13_lv_pmos w=1.12u l=0.13u
XN2_1_0 o2_1_0 o1_3_0 gn2 gn2 sg13_lv_nmos w=0.74u l=0.13u
CL2_1_0 o2_1_0 gn2 2f
XP2_1_1 o2_1_1 o1_3_1 ph2 ph2 sg13_lv_pmos w=1.12u l=0.13u
XN2_1_1 o2_1_1 o1_3_1 gn2 gn2 sg13_lv_nmos w=0.74u l=0.13u
CL2_1_1 o2_1_1 gn2 2f
XP2_1_2 o2_1_2 o1_3_2 ph2 ph2 sg13_lv_pmos w=1.12u l=0.13u
XN2_1_2 o2_1_2 o1_3_2 gn2 gn2 sg13_lv_nmos w=0.74u l=0.13u
CL2_1_2 o2_1_2 gn2 2f
XP2_1_3 o2_1_3 o1_3_3 ph2 ph2 sg13_lv_pmos w=1.12u l=0.13u
XN2_1_3 o2_1_3 o1_3_3 gn2 gn2 sg13_lv_nmos w=0.74u l=0.13u
CL2_1_3 o2_1_3 gn2 2f
XP2_1_4 o2_1_4 o1_3_4 ph2 ph2 sg13_lv_pmos w=1.12u l=0.13u
XN2_1_4 o2_1_4 o1_3_4 gn2 gn2 sg13_lv_nmos w=0.74u l=0.13u
CL2_1_4 o2_1_4 gn2 2f
XP2_1_5 o2_1_5 o1_3_5 ph2 ph2 sg13_lv_pmos w=1.12u l=0.13u
XN2_1_5 o2_1_5 o1_3_5 gn2 gn2 sg13_lv_nmos w=0.74u l=0.13u
CL2_1_5 o2_1_5 gn2 2f
XP2_1_6 o2_1_6 o1_3_6 ph2 ph2 sg13_lv_pmos w=1.12u l=0.13u
XN2_1_6 o2_1_6 o1_3_6 gn2 gn2 sg13_lv_nmos w=0.74u l=0.13u
CL2_1_6 o2_1_6 gn2 2f
XP2_1_7 o2_1_7 o1_3_7 ph2 ph2 sg13_lv_pmos w=1.12u l=0.13u
XN2_1_7 o2_1_7 o1_3_7 gn2 gn2 sg13_lv_nmos w=0.74u l=0.13u
CL2_1_7 o2_1_7 gn2 2f
XP2_2_0 o2_2_0 o2_1_0 ph2 ph2 sg13_lv_pmos w=1.12u l=0.13u
XN2_2_0 o2_2_0 o2_1_0 gn2 gn2 sg13_lv_nmos w=0.74u l=0.13u
CL2_2_0 o2_2_0 gn2 2f
XP2_2_1 o2_2_1 o2_1_1 ph2 ph2 sg13_lv_pmos w=1.12u l=0.13u
XN2_2_1 o2_2_1 o2_1_1 gn2 gn2 sg13_lv_nmos w=0.74u l=0.13u
CL2_2_1 o2_2_1 gn2 2f
XP2_2_2 o2_2_2 o2_1_2 ph2 ph2 sg13_lv_pmos w=1.12u l=0.13u
XN2_2_2 o2_2_2 o2_1_2 gn2 gn2 sg13_lv_nmos w=0.74u l=0.13u
CL2_2_2 o2_2_2 gn2 2f
XP2_2_3 o2_2_3 o2_1_3 ph2 ph2 sg13_lv_pmos w=1.12u l=0.13u
XN2_2_3 o2_2_3 o2_1_3 gn2 gn2 sg13_lv_nmos w=0.74u l=0.13u
CL2_2_3 o2_2_3 gn2 2f
XP2_2_4 o2_2_4 o2_1_4 ph2 ph2 sg13_lv_pmos w=1.12u l=0.13u
XN2_2_4 o2_2_4 o2_1_4 gn2 gn2 sg13_lv_nmos w=0.74u l=0.13u
CL2_2_4 o2_2_4 gn2 2f
XP2_2_5 o2_2_5 o2_1_5 ph2 ph2 sg13_lv_pmos w=1.12u l=0.13u
XN2_2_5 o2_2_5 o2_1_5 gn2 gn2 sg13_lv_nmos w=0.74u l=0.13u
CL2_2_5 o2_2_5 gn2 2f
XP2_2_6 o2_2_6 o2_1_6 ph2 ph2 sg13_lv_pmos w=1.12u l=0.13u
XN2_2_6 o2_2_6 o2_1_6 gn2 gn2 sg13_lv_nmos w=0.74u l=0.13u
CL2_2_6 o2_2_6 gn2 2f
XP2_2_7 o2_2_7 o2_1_7 ph2 ph2 sg13_lv_pmos w=1.12u l=0.13u
XN2_2_7 o2_2_7 o2_1_7 gn2 gn2 sg13_lv_nmos w=0.74u l=0.13u
CL2_2_7 o2_2_7 gn2 2f
XP2_3_0 o2_3_0 o2_2_0 ph2 ph2 sg13_lv_pmos w=1.12u l=0.13u
XN2_3_0 o2_3_0 o2_2_0 gn2 gn2 sg13_lv_nmos w=0.74u l=0.13u
CL2_3_0 o2_3_0 gn2 2f
XP2_3_1 o2_3_1 o2_2_1 ph2 ph2 sg13_lv_pmos w=1.12u l=0.13u
XN2_3_1 o2_3_1 o2_2_1 gn2 gn2 sg13_lv_nmos w=0.74u l=0.13u
CL2_3_1 o2_3_1 gn2 2f
XP2_3_2 o2_3_2 o2_2_2 ph2 ph2 sg13_lv_pmos w=1.12u l=0.13u
XN2_3_2 o2_3_2 o2_2_2 gn2 gn2 sg13_lv_nmos w=0.74u l=0.13u
CL2_3_2 o2_3_2 gn2 2f
XP2_3_3 o2_3_3 o2_2_3 ph2 ph2 sg13_lv_pmos w=1.12u l=0.13u
XN2_3_3 o2_3_3 o2_2_3 gn2 gn2 sg13_lv_nmos w=0.74u l=0.13u
CL2_3_3 o2_3_3 gn2 2f
XP2_3_4 o2_3_4 o2_2_4 ph2 ph2 sg13_lv_pmos w=1.12u l=0.13u
XN2_3_4 o2_3_4 o2_2_4 gn2 gn2 sg13_lv_nmos w=0.74u l=0.13u
CL2_3_4 o2_3_4 gn2 2f
XP2_3_5 o2_3_5 o2_2_5 ph2 ph2 sg13_lv_pmos w=1.12u l=0.13u
XN2_3_5 o2_3_5 o2_2_5 gn2 gn2 sg13_lv_nmos w=0.74u l=0.13u
CL2_3_5 o2_3_5 gn2 2f
XP2_3_6 o2_3_6 o2_2_6 ph2 ph2 sg13_lv_pmos w=1.12u l=0.13u
XN2_3_6 o2_3_6 o2_2_6 gn2 gn2 sg13_lv_nmos w=0.74u l=0.13u
CL2_3_6 o2_3_6 gn2 2f
XP2_3_7 o2_3_7 o2_2_7 ph2 ph2 sg13_lv_pmos w=1.12u l=0.13u
XN2_3_7 o2_3_7 o2_2_7 gn2 gn2 sg13_lv_nmos w=0.74u l=0.13u
CL2_3_7 o2_3_7 gn2 2f
VMG3 gn3 0 0
XP3_1_0 o3_1_0 o2_3_0 ph3 ph3 sg13_lv_pmos w=1.12u l=0.13u
XN3_1_0 o3_1_0 o2_3_0 gn3 gn3 sg13_lv_nmos w=0.74u l=0.13u
CL3_1_0 o3_1_0 gn3 2f
XP3_1_1 o3_1_1 o2_3_1 ph3 ph3 sg13_lv_pmos w=1.12u l=0.13u
XN3_1_1 o3_1_1 o2_3_1 gn3 gn3 sg13_lv_nmos w=0.74u l=0.13u
CL3_1_1 o3_1_1 gn3 2f
XP3_1_2 o3_1_2 o2_3_2 ph3 ph3 sg13_lv_pmos w=1.12u l=0.13u
XN3_1_2 o3_1_2 o2_3_2 gn3 gn3 sg13_lv_nmos w=0.74u l=0.13u
CL3_1_2 o3_1_2 gn3 2f
XP3_1_3 o3_1_3 o2_3_3 ph3 ph3 sg13_lv_pmos w=1.12u l=0.13u
XN3_1_3 o3_1_3 o2_3_3 gn3 gn3 sg13_lv_nmos w=0.74u l=0.13u
CL3_1_3 o3_1_3 gn3 2f
XP3_1_4 o3_1_4 o2_3_4 ph3 ph3 sg13_lv_pmos w=1.12u l=0.13u
XN3_1_4 o3_1_4 o2_3_4 gn3 gn3 sg13_lv_nmos w=0.74u l=0.13u
CL3_1_4 o3_1_4 gn3 2f
XP3_1_5 o3_1_5 o2_3_5 ph3 ph3 sg13_lv_pmos w=1.12u l=0.13u
XN3_1_5 o3_1_5 o2_3_5 gn3 gn3 sg13_lv_nmos w=0.74u l=0.13u
CL3_1_5 o3_1_5 gn3 2f
XP3_1_6 o3_1_6 o2_3_6 ph3 ph3 sg13_lv_pmos w=1.12u l=0.13u
XN3_1_6 o3_1_6 o2_3_6 gn3 gn3 sg13_lv_nmos w=0.74u l=0.13u
CL3_1_6 o3_1_6 gn3 2f
XP3_1_7 o3_1_7 o2_3_7 ph3 ph3 sg13_lv_pmos w=1.12u l=0.13u
XN3_1_7 o3_1_7 o2_3_7 gn3 gn3 sg13_lv_nmos w=0.74u l=0.13u
CL3_1_7 o3_1_7 gn3 2f
XP3_2_0 o3_2_0 o3_1_0 ph3 ph3 sg13_lv_pmos w=1.12u l=0.13u
XN3_2_0 o3_2_0 o3_1_0 gn3 gn3 sg13_lv_nmos w=0.74u l=0.13u
CL3_2_0 o3_2_0 gn3 2f
XP3_2_1 o3_2_1 o3_1_1 ph3 ph3 sg13_lv_pmos w=1.12u l=0.13u
XN3_2_1 o3_2_1 o3_1_1 gn3 gn3 sg13_lv_nmos w=0.74u l=0.13u
CL3_2_1 o3_2_1 gn3 2f
XP3_2_2 o3_2_2 o3_1_2 ph3 ph3 sg13_lv_pmos w=1.12u l=0.13u
XN3_2_2 o3_2_2 o3_1_2 gn3 gn3 sg13_lv_nmos w=0.74u l=0.13u
CL3_2_2 o3_2_2 gn3 2f
XP3_2_3 o3_2_3 o3_1_3 ph3 ph3 sg13_lv_pmos w=1.12u l=0.13u
XN3_2_3 o3_2_3 o3_1_3 gn3 gn3 sg13_lv_nmos w=0.74u l=0.13u
CL3_2_3 o3_2_3 gn3 2f
XP3_2_4 o3_2_4 o3_1_4 ph3 ph3 sg13_lv_pmos w=1.12u l=0.13u
XN3_2_4 o3_2_4 o3_1_4 gn3 gn3 sg13_lv_nmos w=0.74u l=0.13u
CL3_2_4 o3_2_4 gn3 2f
XP3_2_5 o3_2_5 o3_1_5 ph3 ph3 sg13_lv_pmos w=1.12u l=0.13u
XN3_2_5 o3_2_5 o3_1_5 gn3 gn3 sg13_lv_nmos w=0.74u l=0.13u
CL3_2_5 o3_2_5 gn3 2f
XP3_2_6 o3_2_6 o3_1_6 ph3 ph3 sg13_lv_pmos w=1.12u l=0.13u
XN3_2_6 o3_2_6 o3_1_6 gn3 gn3 sg13_lv_nmos w=0.74u l=0.13u
CL3_2_6 o3_2_6 gn3 2f
XP3_2_7 o3_2_7 o3_1_7 ph3 ph3 sg13_lv_pmos w=1.12u l=0.13u
XN3_2_7 o3_2_7 o3_1_7 gn3 gn3 sg13_lv_nmos w=0.74u l=0.13u
CL3_2_7 o3_2_7 gn3 2f
XP3_3_0 o3_3_0 o3_2_0 ph3 ph3 sg13_lv_pmos w=1.12u l=0.13u
XN3_3_0 o3_3_0 o3_2_0 gn3 gn3 sg13_lv_nmos w=0.74u l=0.13u
CL3_3_0 o3_3_0 gn3 2f
XP3_3_1 o3_3_1 o3_2_1 ph3 ph3 sg13_lv_pmos w=1.12u l=0.13u
XN3_3_1 o3_3_1 o3_2_1 gn3 gn3 sg13_lv_nmos w=0.74u l=0.13u
CL3_3_1 o3_3_1 gn3 2f
XP3_3_2 o3_3_2 o3_2_2 ph3 ph3 sg13_lv_pmos w=1.12u l=0.13u
XN3_3_2 o3_3_2 o3_2_2 gn3 gn3 sg13_lv_nmos w=0.74u l=0.13u
CL3_3_2 o3_3_2 gn3 2f
XP3_3_3 o3_3_3 o3_2_3 ph3 ph3 sg13_lv_pmos w=1.12u l=0.13u
XN3_3_3 o3_3_3 o3_2_3 gn3 gn3 sg13_lv_nmos w=0.74u l=0.13u
CL3_3_3 o3_3_3 gn3 2f
XP3_3_4 o3_3_4 o3_2_4 ph3 ph3 sg13_lv_pmos w=1.12u l=0.13u
XN3_3_4 o3_3_4 o3_2_4 gn3 gn3 sg13_lv_nmos w=0.74u l=0.13u
CL3_3_4 o3_3_4 gn3 2f
XP3_3_5 o3_3_5 o3_2_5 ph3 ph3 sg13_lv_pmos w=1.12u l=0.13u
XN3_3_5 o3_3_5 o3_2_5 gn3 gn3 sg13_lv_nmos w=0.74u l=0.13u
CL3_3_5 o3_3_5 gn3 2f
XP3_3_6 o3_3_6 o3_2_6 ph3 ph3 sg13_lv_pmos w=1.12u l=0.13u
XN3_3_6 o3_3_6 o3_2_6 gn3 gn3 sg13_lv_nmos w=0.74u l=0.13u
CL3_3_6 o3_3_6 gn3 2f
XP3_3_7 o3_3_7 o3_2_7 ph3 ph3 sg13_lv_pmos w=1.12u l=0.13u
XN3_3_7 o3_3_7 o3_2_7 gn3 gn3 sg13_lv_nmos w=0.74u l=0.13u
CL3_3_7 o3_3_7 gn3 2f
VMG4 gn4 0 0
XP4_1_0 o4_1_0 o3_3_0 ph4 ph4 sg13_lv_pmos w=1.12u l=0.13u
XN4_1_0 o4_1_0 o3_3_0 gn4 gn4 sg13_lv_nmos w=0.74u l=0.13u
CL4_1_0 o4_1_0 gn4 2f
XP4_1_1 o4_1_1 o3_3_1 ph4 ph4 sg13_lv_pmos w=1.12u l=0.13u
XN4_1_1 o4_1_1 o3_3_1 gn4 gn4 sg13_lv_nmos w=0.74u l=0.13u
CL4_1_1 o4_1_1 gn4 2f
XP4_1_2 o4_1_2 o3_3_2 ph4 ph4 sg13_lv_pmos w=1.12u l=0.13u
XN4_1_2 o4_1_2 o3_3_2 gn4 gn4 sg13_lv_nmos w=0.74u l=0.13u
CL4_1_2 o4_1_2 gn4 2f
XP4_1_3 o4_1_3 o3_3_3 ph4 ph4 sg13_lv_pmos w=1.12u l=0.13u
XN4_1_3 o4_1_3 o3_3_3 gn4 gn4 sg13_lv_nmos w=0.74u l=0.13u
CL4_1_3 o4_1_3 gn4 2f
XP4_1_4 o4_1_4 o3_3_4 ph4 ph4 sg13_lv_pmos w=1.12u l=0.13u
XN4_1_4 o4_1_4 o3_3_4 gn4 gn4 sg13_lv_nmos w=0.74u l=0.13u
CL4_1_4 o4_1_4 gn4 2f
XP4_1_5 o4_1_5 o3_3_5 ph4 ph4 sg13_lv_pmos w=1.12u l=0.13u
XN4_1_5 o4_1_5 o3_3_5 gn4 gn4 sg13_lv_nmos w=0.74u l=0.13u
CL4_1_5 o4_1_5 gn4 2f
XP4_1_6 o4_1_6 o3_3_6 ph4 ph4 sg13_lv_pmos w=1.12u l=0.13u
XN4_1_6 o4_1_6 o3_3_6 gn4 gn4 sg13_lv_nmos w=0.74u l=0.13u
CL4_1_6 o4_1_6 gn4 2f
XP4_1_7 o4_1_7 o3_3_7 ph4 ph4 sg13_lv_pmos w=1.12u l=0.13u
XN4_1_7 o4_1_7 o3_3_7 gn4 gn4 sg13_lv_nmos w=0.74u l=0.13u
CL4_1_7 o4_1_7 gn4 2f
XP4_2_0 o4_2_0 o4_1_0 ph4 ph4 sg13_lv_pmos w=1.12u l=0.13u
XN4_2_0 o4_2_0 o4_1_0 gn4 gn4 sg13_lv_nmos w=0.74u l=0.13u
CL4_2_0 o4_2_0 gn4 2f
XP4_2_1 o4_2_1 o4_1_1 ph4 ph4 sg13_lv_pmos w=1.12u l=0.13u
XN4_2_1 o4_2_1 o4_1_1 gn4 gn4 sg13_lv_nmos w=0.74u l=0.13u
CL4_2_1 o4_2_1 gn4 2f
XP4_2_2 o4_2_2 o4_1_2 ph4 ph4 sg13_lv_pmos w=1.12u l=0.13u
XN4_2_2 o4_2_2 o4_1_2 gn4 gn4 sg13_lv_nmos w=0.74u l=0.13u
CL4_2_2 o4_2_2 gn4 2f
XP4_2_3 o4_2_3 o4_1_3 ph4 ph4 sg13_lv_pmos w=1.12u l=0.13u
XN4_2_3 o4_2_3 o4_1_3 gn4 gn4 sg13_lv_nmos w=0.74u l=0.13u
CL4_2_3 o4_2_3 gn4 2f
XP4_2_4 o4_2_4 o4_1_4 ph4 ph4 sg13_lv_pmos w=1.12u l=0.13u
XN4_2_4 o4_2_4 o4_1_4 gn4 gn4 sg13_lv_nmos w=0.74u l=0.13u
CL4_2_4 o4_2_4 gn4 2f
XP4_2_5 o4_2_5 o4_1_5 ph4 ph4 sg13_lv_pmos w=1.12u l=0.13u
XN4_2_5 o4_2_5 o4_1_5 gn4 gn4 sg13_lv_nmos w=0.74u l=0.13u
CL4_2_5 o4_2_5 gn4 2f
XP4_2_6 o4_2_6 o4_1_6 ph4 ph4 sg13_lv_pmos w=1.12u l=0.13u
XN4_2_6 o4_2_6 o4_1_6 gn4 gn4 sg13_lv_nmos w=0.74u l=0.13u
CL4_2_6 o4_2_6 gn4 2f
XP4_2_7 o4_2_7 o4_1_7 ph4 ph4 sg13_lv_pmos w=1.12u l=0.13u
XN4_2_7 o4_2_7 o4_1_7 gn4 gn4 sg13_lv_nmos w=0.74u l=0.13u
CL4_2_7 o4_2_7 gn4 2f
XP4_3_0 o4_3_0 o4_2_0 ph4 ph4 sg13_lv_pmos w=1.12u l=0.13u
XN4_3_0 o4_3_0 o4_2_0 gn4 gn4 sg13_lv_nmos w=0.74u l=0.13u
CL4_3_0 o4_3_0 gn4 2f
XP4_3_1 o4_3_1 o4_2_1 ph4 ph4 sg13_lv_pmos w=1.12u l=0.13u
XN4_3_1 o4_3_1 o4_2_1 gn4 gn4 sg13_lv_nmos w=0.74u l=0.13u
CL4_3_1 o4_3_1 gn4 2f
XP4_3_2 o4_3_2 o4_2_2 ph4 ph4 sg13_lv_pmos w=1.12u l=0.13u
XN4_3_2 o4_3_2 o4_2_2 gn4 gn4 sg13_lv_nmos w=0.74u l=0.13u
CL4_3_2 o4_3_2 gn4 2f
XP4_3_3 o4_3_3 o4_2_3 ph4 ph4 sg13_lv_pmos w=1.12u l=0.13u
XN4_3_3 o4_3_3 o4_2_3 gn4 gn4 sg13_lv_nmos w=0.74u l=0.13u
CL4_3_3 o4_3_3 gn4 2f
XP4_3_4 o4_3_4 o4_2_4 ph4 ph4 sg13_lv_pmos w=1.12u l=0.13u
XN4_3_4 o4_3_4 o4_2_4 gn4 gn4 sg13_lv_nmos w=0.74u l=0.13u
CL4_3_4 o4_3_4 gn4 2f
XP4_3_5 o4_3_5 o4_2_5 ph4 ph4 sg13_lv_pmos w=1.12u l=0.13u
XN4_3_5 o4_3_5 o4_2_5 gn4 gn4 sg13_lv_nmos w=0.74u l=0.13u
CL4_3_5 o4_3_5 gn4 2f
XP4_3_6 o4_3_6 o4_2_6 ph4 ph4 sg13_lv_pmos w=1.12u l=0.13u
XN4_3_6 o4_3_6 o4_2_6 gn4 gn4 sg13_lv_nmos w=0.74u l=0.13u
CL4_3_6 o4_3_6 gn4 2f
XP4_3_7 o4_3_7 o4_2_7 ph4 ph4 sg13_lv_pmos w=1.12u l=0.13u
XN4_3_7 o4_3_7 o4_2_7 gn4 gn4 sg13_lv_nmos w=0.74u l=0.13u
CL4_3_7 o4_3_7 gn4 2f
VMG5 gn5 0 0
XP5_1_0 o5_1_0 o4_3_0 ph5 ph5 sg13_lv_pmos w=1.12u l=0.13u
XN5_1_0 o5_1_0 o4_3_0 gn5 gn5 sg13_lv_nmos w=0.74u l=0.13u
CL5_1_0 o5_1_0 gn5 2f
XP5_1_1 o5_1_1 o4_3_1 ph5 ph5 sg13_lv_pmos w=1.12u l=0.13u
XN5_1_1 o5_1_1 o4_3_1 gn5 gn5 sg13_lv_nmos w=0.74u l=0.13u
CL5_1_1 o5_1_1 gn5 2f
XP5_1_2 o5_1_2 o4_3_2 ph5 ph5 sg13_lv_pmos w=1.12u l=0.13u
XN5_1_2 o5_1_2 o4_3_2 gn5 gn5 sg13_lv_nmos w=0.74u l=0.13u
CL5_1_2 o5_1_2 gn5 2f
XP5_1_3 o5_1_3 o4_3_3 ph5 ph5 sg13_lv_pmos w=1.12u l=0.13u
XN5_1_3 o5_1_3 o4_3_3 gn5 gn5 sg13_lv_nmos w=0.74u l=0.13u
CL5_1_3 o5_1_3 gn5 2f
XP5_1_4 o5_1_4 o4_3_4 ph5 ph5 sg13_lv_pmos w=1.12u l=0.13u
XN5_1_4 o5_1_4 o4_3_4 gn5 gn5 sg13_lv_nmos w=0.74u l=0.13u
CL5_1_4 o5_1_4 gn5 2f
XP5_1_5 o5_1_5 o4_3_5 ph5 ph5 sg13_lv_pmos w=1.12u l=0.13u
XN5_1_5 o5_1_5 o4_3_5 gn5 gn5 sg13_lv_nmos w=0.74u l=0.13u
CL5_1_5 o5_1_5 gn5 2f
XP5_1_6 o5_1_6 o4_3_6 ph5 ph5 sg13_lv_pmos w=1.12u l=0.13u
XN5_1_6 o5_1_6 o4_3_6 gn5 gn5 sg13_lv_nmos w=0.74u l=0.13u
CL5_1_6 o5_1_6 gn5 2f
XP5_1_7 o5_1_7 o4_3_7 ph5 ph5 sg13_lv_pmos w=1.12u l=0.13u
XN5_1_7 o5_1_7 o4_3_7 gn5 gn5 sg13_lv_nmos w=0.74u l=0.13u
CL5_1_7 o5_1_7 gn5 2f
XP5_2_0 o5_2_0 o5_1_0 ph5 ph5 sg13_lv_pmos w=1.12u l=0.13u
XN5_2_0 o5_2_0 o5_1_0 gn5 gn5 sg13_lv_nmos w=0.74u l=0.13u
CL5_2_0 o5_2_0 gn5 2f
XP5_2_1 o5_2_1 o5_1_1 ph5 ph5 sg13_lv_pmos w=1.12u l=0.13u
XN5_2_1 o5_2_1 o5_1_1 gn5 gn5 sg13_lv_nmos w=0.74u l=0.13u
CL5_2_1 o5_2_1 gn5 2f
XP5_2_2 o5_2_2 o5_1_2 ph5 ph5 sg13_lv_pmos w=1.12u l=0.13u
XN5_2_2 o5_2_2 o5_1_2 gn5 gn5 sg13_lv_nmos w=0.74u l=0.13u
CL5_2_2 o5_2_2 gn5 2f
XP5_2_3 o5_2_3 o5_1_3 ph5 ph5 sg13_lv_pmos w=1.12u l=0.13u
XN5_2_3 o5_2_3 o5_1_3 gn5 gn5 sg13_lv_nmos w=0.74u l=0.13u
CL5_2_3 o5_2_3 gn5 2f
XP5_2_4 o5_2_4 o5_1_4 ph5 ph5 sg13_lv_pmos w=1.12u l=0.13u
XN5_2_4 o5_2_4 o5_1_4 gn5 gn5 sg13_lv_nmos w=0.74u l=0.13u
CL5_2_4 o5_2_4 gn5 2f
XP5_2_5 o5_2_5 o5_1_5 ph5 ph5 sg13_lv_pmos w=1.12u l=0.13u
XN5_2_5 o5_2_5 o5_1_5 gn5 gn5 sg13_lv_nmos w=0.74u l=0.13u
CL5_2_5 o5_2_5 gn5 2f
XP5_2_6 o5_2_6 o5_1_6 ph5 ph5 sg13_lv_pmos w=1.12u l=0.13u
XN5_2_6 o5_2_6 o5_1_6 gn5 gn5 sg13_lv_nmos w=0.74u l=0.13u
CL5_2_6 o5_2_6 gn5 2f
XP5_2_7 o5_2_7 o5_1_7 ph5 ph5 sg13_lv_pmos w=1.12u l=0.13u
XN5_2_7 o5_2_7 o5_1_7 gn5 gn5 sg13_lv_nmos w=0.74u l=0.13u
CL5_2_7 o5_2_7 gn5 2f
XP5_3_0 o5_3_0 o5_2_0 ph5 ph5 sg13_lv_pmos w=1.12u l=0.13u
XN5_3_0 o5_3_0 o5_2_0 gn5 gn5 sg13_lv_nmos w=0.74u l=0.13u
CL5_3_0 o5_3_0 gn5 2f
XP5_3_1 o5_3_1 o5_2_1 ph5 ph5 sg13_lv_pmos w=1.12u l=0.13u
XN5_3_1 o5_3_1 o5_2_1 gn5 gn5 sg13_lv_nmos w=0.74u l=0.13u
CL5_3_1 o5_3_1 gn5 2f
XP5_3_2 o5_3_2 o5_2_2 ph5 ph5 sg13_lv_pmos w=1.12u l=0.13u
XN5_3_2 o5_3_2 o5_2_2 gn5 gn5 sg13_lv_nmos w=0.74u l=0.13u
CL5_3_2 o5_3_2 gn5 2f
XP5_3_3 o5_3_3 o5_2_3 ph5 ph5 sg13_lv_pmos w=1.12u l=0.13u
XN5_3_3 o5_3_3 o5_2_3 gn5 gn5 sg13_lv_nmos w=0.74u l=0.13u
CL5_3_3 o5_3_3 gn5 2f
XP5_3_4 o5_3_4 o5_2_4 ph5 ph5 sg13_lv_pmos w=1.12u l=0.13u
XN5_3_4 o5_3_4 o5_2_4 gn5 gn5 sg13_lv_nmos w=0.74u l=0.13u
CL5_3_4 o5_3_4 gn5 2f
XP5_3_5 o5_3_5 o5_2_5 ph5 ph5 sg13_lv_pmos w=1.12u l=0.13u
XN5_3_5 o5_3_5 o5_2_5 gn5 gn5 sg13_lv_nmos w=0.74u l=0.13u
CL5_3_5 o5_3_5 gn5 2f
XP5_3_6 o5_3_6 o5_2_6 ph5 ph5 sg13_lv_pmos w=1.12u l=0.13u
XN5_3_6 o5_3_6 o5_2_6 gn5 gn5 sg13_lv_nmos w=0.74u l=0.13u
CL5_3_6 o5_3_6 gn5 2f
XP5_3_7 o5_3_7 o5_2_7 ph5 ph5 sg13_lv_pmos w=1.12u l=0.13u
XN5_3_7 o5_3_7 o5_2_7 gn5 gn5 sg13_lv_nmos w=0.74u l=0.13u
CL5_3_7 o5_3_7 gn5 2f
VMG6 gn6 0 0
XP6_1_0 o6_1_0 o5_3_0 ph6 ph6 sg13_lv_pmos w=1.12u l=0.13u
XN6_1_0 o6_1_0 o5_3_0 gn6 gn6 sg13_lv_nmos w=0.74u l=0.13u
CL6_1_0 o6_1_0 gn6 2f
XP6_1_1 o6_1_1 o5_3_1 ph6 ph6 sg13_lv_pmos w=1.12u l=0.13u
XN6_1_1 o6_1_1 o5_3_1 gn6 gn6 sg13_lv_nmos w=0.74u l=0.13u
CL6_1_1 o6_1_1 gn6 2f
XP6_1_2 o6_1_2 o5_3_2 ph6 ph6 sg13_lv_pmos w=1.12u l=0.13u
XN6_1_2 o6_1_2 o5_3_2 gn6 gn6 sg13_lv_nmos w=0.74u l=0.13u
CL6_1_2 o6_1_2 gn6 2f
XP6_1_3 o6_1_3 o5_3_3 ph6 ph6 sg13_lv_pmos w=1.12u l=0.13u
XN6_1_3 o6_1_3 o5_3_3 gn6 gn6 sg13_lv_nmos w=0.74u l=0.13u
CL6_1_3 o6_1_3 gn6 2f
XP6_1_4 o6_1_4 o5_3_4 ph6 ph6 sg13_lv_pmos w=1.12u l=0.13u
XN6_1_4 o6_1_4 o5_3_4 gn6 gn6 sg13_lv_nmos w=0.74u l=0.13u
CL6_1_4 o6_1_4 gn6 2f
XP6_1_5 o6_1_5 o5_3_5 ph6 ph6 sg13_lv_pmos w=1.12u l=0.13u
XN6_1_5 o6_1_5 o5_3_5 gn6 gn6 sg13_lv_nmos w=0.74u l=0.13u
CL6_1_5 o6_1_5 gn6 2f
XP6_1_6 o6_1_6 o5_3_6 ph6 ph6 sg13_lv_pmos w=1.12u l=0.13u
XN6_1_6 o6_1_6 o5_3_6 gn6 gn6 sg13_lv_nmos w=0.74u l=0.13u
CL6_1_6 o6_1_6 gn6 2f
XP6_1_7 o6_1_7 o5_3_7 ph6 ph6 sg13_lv_pmos w=1.12u l=0.13u
XN6_1_7 o6_1_7 o5_3_7 gn6 gn6 sg13_lv_nmos w=0.74u l=0.13u
CL6_1_7 o6_1_7 gn6 2f
XP6_2_0 o6_2_0 o6_1_0 ph6 ph6 sg13_lv_pmos w=1.12u l=0.13u
XN6_2_0 o6_2_0 o6_1_0 gn6 gn6 sg13_lv_nmos w=0.74u l=0.13u
CL6_2_0 o6_2_0 gn6 2f
XP6_2_1 o6_2_1 o6_1_1 ph6 ph6 sg13_lv_pmos w=1.12u l=0.13u
XN6_2_1 o6_2_1 o6_1_1 gn6 gn6 sg13_lv_nmos w=0.74u l=0.13u
CL6_2_1 o6_2_1 gn6 2f
XP6_2_2 o6_2_2 o6_1_2 ph6 ph6 sg13_lv_pmos w=1.12u l=0.13u
XN6_2_2 o6_2_2 o6_1_2 gn6 gn6 sg13_lv_nmos w=0.74u l=0.13u
CL6_2_2 o6_2_2 gn6 2f
XP6_2_3 o6_2_3 o6_1_3 ph6 ph6 sg13_lv_pmos w=1.12u l=0.13u
XN6_2_3 o6_2_3 o6_1_3 gn6 gn6 sg13_lv_nmos w=0.74u l=0.13u
CL6_2_3 o6_2_3 gn6 2f
XP6_2_4 o6_2_4 o6_1_4 ph6 ph6 sg13_lv_pmos w=1.12u l=0.13u
XN6_2_4 o6_2_4 o6_1_4 gn6 gn6 sg13_lv_nmos w=0.74u l=0.13u
CL6_2_4 o6_2_4 gn6 2f
XP6_2_5 o6_2_5 o6_1_5 ph6 ph6 sg13_lv_pmos w=1.12u l=0.13u
XN6_2_5 o6_2_5 o6_1_5 gn6 gn6 sg13_lv_nmos w=0.74u l=0.13u
CL6_2_5 o6_2_5 gn6 2f
XP6_2_6 o6_2_6 o6_1_6 ph6 ph6 sg13_lv_pmos w=1.12u l=0.13u
XN6_2_6 o6_2_6 o6_1_6 gn6 gn6 sg13_lv_nmos w=0.74u l=0.13u
CL6_2_6 o6_2_6 gn6 2f
XP6_2_7 o6_2_7 o6_1_7 ph6 ph6 sg13_lv_pmos w=1.12u l=0.13u
XN6_2_7 o6_2_7 o6_1_7 gn6 gn6 sg13_lv_nmos w=0.74u l=0.13u
CL6_2_7 o6_2_7 gn6 2f
XP6_3_0 o6_3_0 o6_2_0 ph6 ph6 sg13_lv_pmos w=1.12u l=0.13u
XN6_3_0 o6_3_0 o6_2_0 gn6 gn6 sg13_lv_nmos w=0.74u l=0.13u
CL6_3_0 o6_3_0 gn6 2f
XP6_3_1 o6_3_1 o6_2_1 ph6 ph6 sg13_lv_pmos w=1.12u l=0.13u
XN6_3_1 o6_3_1 o6_2_1 gn6 gn6 sg13_lv_nmos w=0.74u l=0.13u
CL6_3_1 o6_3_1 gn6 2f
XP6_3_2 o6_3_2 o6_2_2 ph6 ph6 sg13_lv_pmos w=1.12u l=0.13u
XN6_3_2 o6_3_2 o6_2_2 gn6 gn6 sg13_lv_nmos w=0.74u l=0.13u
CL6_3_2 o6_3_2 gn6 2f
XP6_3_3 o6_3_3 o6_2_3 ph6 ph6 sg13_lv_pmos w=1.12u l=0.13u
XN6_3_3 o6_3_3 o6_2_3 gn6 gn6 sg13_lv_nmos w=0.74u l=0.13u
CL6_3_3 o6_3_3 gn6 2f
XP6_3_4 o6_3_4 o6_2_4 ph6 ph6 sg13_lv_pmos w=1.12u l=0.13u
XN6_3_4 o6_3_4 o6_2_4 gn6 gn6 sg13_lv_nmos w=0.74u l=0.13u
CL6_3_4 o6_3_4 gn6 2f
XP6_3_5 o6_3_5 o6_2_5 ph6 ph6 sg13_lv_pmos w=1.12u l=0.13u
XN6_3_5 o6_3_5 o6_2_5 gn6 gn6 sg13_lv_nmos w=0.74u l=0.13u
CL6_3_5 o6_3_5 gn6 2f
XP6_3_6 o6_3_6 o6_2_6 ph6 ph6 sg13_lv_pmos w=1.12u l=0.13u
XN6_3_6 o6_3_6 o6_2_6 gn6 gn6 sg13_lv_nmos w=0.74u l=0.13u
CL6_3_6 o6_3_6 gn6 2f
XP6_3_7 o6_3_7 o6_2_7 ph6 ph6 sg13_lv_pmos w=1.12u l=0.13u
XN6_3_7 o6_3_7 o6_2_7 gn6 gn6 sg13_lv_nmos w=0.74u l=0.13u
CL6_3_7 o6_3_7 gn6 2f
CXqph1 xqph1 0 1
BXqph1 0 xqph1 I={ -I(VPH1) }
RXqph1 xqph1 0 0.01
CXeph1 xeph1 0 1
BXeph1 0 xeph1 I={ -V(ph1)*I(VPH1) }
RXeph1 xeph1 0 0.01
CXqg1 xqg1 0 1
BXqg1 0 xqg1 I={ I(VMG1) }
RXqg1 xqg1 0 0.01
CXqph2 xqph2 0 1
BXqph2 0 xqph2 I={ -I(VPH2) }
RXqph2 xqph2 0 0.01
CXeph2 xeph2 0 1
BXeph2 0 xeph2 I={ -V(ph2)*I(VPH2) }
RXeph2 xeph2 0 0.01
CXqg2 xqg2 0 1
BXqg2 0 xqg2 I={ I(VMG2) }
RXqg2 xqg2 0 0.01
CXqph3 xqph3 0 1
BXqph3 0 xqph3 I={ -I(VPH3) }
RXqph3 xqph3 0 0.01
CXeph3 xeph3 0 1
BXeph3 0 xeph3 I={ -V(ph3)*I(VPH3) }
RXeph3 xeph3 0 0.01
CXqg3 xqg3 0 1
BXqg3 0 xqg3 I={ I(VMG3) }
RXqg3 xqg3 0 0.01
CXqph4 xqph4 0 1
BXqph4 0 xqph4 I={ -I(VPH4) }
RXqph4 xqph4 0 0.01
CXeph4 xeph4 0 1
BXeph4 0 xeph4 I={ -V(ph4)*I(VPH4) }
RXeph4 xeph4 0 0.01
CXqg4 xqg4 0 1
BXqg4 0 xqg4 I={ I(VMG4) }
RXqg4 xqg4 0 0.01
CXqph5 xqph5 0 1
BXqph5 0 xqph5 I={ -I(VPH5) }
RXqph5 xqph5 0 0.01
CXeph5 xeph5 0 1
BXeph5 0 xeph5 I={ -V(ph5)*I(VPH5) }
RXeph5 xeph5 0 0.01
CXqg5 xqg5 0 1
BXqg5 0 xqg5 I={ I(VMG5) }
RXqg5 xqg5 0 0.01
CXqph6 xqph6 0 1
BXqph6 0 xqph6 I={ -I(VPH6) }
RXqph6 xqph6 0 0.01
CXeph6 xeph6 0 1
BXeph6 0 xeph6 I={ -V(ph6)*I(VPH6) }
RXeph6 xeph6 0 0.01
CXqg6 xqg6 0 1
BXqg6 0 xqg6 I={ I(VMG6) }
RXqg6 xqg6 0 0.01
.tran 0.1p 1932p 0 0.25p
.measure tran VRK1W2 FIND V(ph1) AT=691.000000p
.measure tran VK1_1_0W2 FIND V(o1_1_0) AT=691.000000p
.measure tran VK1_1_1W2 FIND V(o1_1_1) AT=691.000000p
.measure tran VK1_1_2W2 FIND V(o1_1_2) AT=691.000000p
.measure tran VK1_1_3W2 FIND V(o1_1_3) AT=691.000000p
.measure tran VK1_1_4W2 FIND V(o1_1_4) AT=691.000000p
.measure tran VK1_1_5W2 FIND V(o1_1_5) AT=691.000000p
.measure tran VK1_1_6W2 FIND V(o1_1_6) AT=691.000000p
.measure tran VK1_1_7W2 FIND V(o1_1_7) AT=691.000000p
.measure tran VK1_2_0W2 FIND V(o1_2_0) AT=691.000000p
.measure tran VK1_2_1W2 FIND V(o1_2_1) AT=691.000000p
.measure tran VK1_2_2W2 FIND V(o1_2_2) AT=691.000000p
.measure tran VK1_2_3W2 FIND V(o1_2_3) AT=691.000000p
.measure tran VK1_2_4W2 FIND V(o1_2_4) AT=691.000000p
.measure tran VK1_2_5W2 FIND V(o1_2_5) AT=691.000000p
.measure tran VK1_2_6W2 FIND V(o1_2_6) AT=691.000000p
.measure tran VK1_2_7W2 FIND V(o1_2_7) AT=691.000000p
.measure tran VK1_3_0W2 FIND V(o1_3_0) AT=691.000000p
.measure tran VK1_3_1W2 FIND V(o1_3_1) AT=691.000000p
.measure tran VK1_3_2W2 FIND V(o1_3_2) AT=691.000000p
.measure tran VK1_3_3W2 FIND V(o1_3_3) AT=691.000000p
.measure tran VK1_3_4W2 FIND V(o1_3_4) AT=691.000000p
.measure tran VK1_3_5W2 FIND V(o1_3_5) AT=691.000000p
.measure tran VK1_3_6W2 FIND V(o1_3_6) AT=691.000000p
.measure tran VK1_3_7W2 FIND V(o1_3_7) AT=691.000000p
.measure tran VRK2W2 FIND V(ph2) AT=783.000000p
.measure tran VK2_1_0W2 FIND V(o2_1_0) AT=783.000000p
.measure tran VK2_1_1W2 FIND V(o2_1_1) AT=783.000000p
.measure tran VK2_1_2W2 FIND V(o2_1_2) AT=783.000000p
.measure tran VK2_1_3W2 FIND V(o2_1_3) AT=783.000000p
.measure tran VK2_1_4W2 FIND V(o2_1_4) AT=783.000000p
.measure tran VK2_1_5W2 FIND V(o2_1_5) AT=783.000000p
.measure tran VK2_1_6W2 FIND V(o2_1_6) AT=783.000000p
.measure tran VK2_1_7W2 FIND V(o2_1_7) AT=783.000000p
.measure tran VK2_2_0W2 FIND V(o2_2_0) AT=783.000000p
.measure tran VK2_2_1W2 FIND V(o2_2_1) AT=783.000000p
.measure tran VK2_2_2W2 FIND V(o2_2_2) AT=783.000000p
.measure tran VK2_2_3W2 FIND V(o2_2_3) AT=783.000000p
.measure tran VK2_2_4W2 FIND V(o2_2_4) AT=783.000000p
.measure tran VK2_2_5W2 FIND V(o2_2_5) AT=783.000000p
.measure tran VK2_2_6W2 FIND V(o2_2_6) AT=783.000000p
.measure tran VK2_2_7W2 FIND V(o2_2_7) AT=783.000000p
.measure tran VK2_3_0W2 FIND V(o2_3_0) AT=783.000000p
.measure tran VK2_3_1W2 FIND V(o2_3_1) AT=783.000000p
.measure tran VK2_3_2W2 FIND V(o2_3_2) AT=783.000000p
.measure tran VK2_3_3W2 FIND V(o2_3_3) AT=783.000000p
.measure tran VK2_3_4W2 FIND V(o2_3_4) AT=783.000000p
.measure tran VK2_3_5W2 FIND V(o2_3_5) AT=783.000000p
.measure tran VK2_3_6W2 FIND V(o2_3_6) AT=783.000000p
.measure tran VK2_3_7W2 FIND V(o2_3_7) AT=783.000000p
.measure tran VRK3W2 FIND V(ph3) AT=875.000000p
.measure tran VK3_1_0W2 FIND V(o3_1_0) AT=875.000000p
.measure tran VK3_1_1W2 FIND V(o3_1_1) AT=875.000000p
.measure tran VK3_1_2W2 FIND V(o3_1_2) AT=875.000000p
.measure tran VK3_1_3W2 FIND V(o3_1_3) AT=875.000000p
.measure tran VK3_1_4W2 FIND V(o3_1_4) AT=875.000000p
.measure tran VK3_1_5W2 FIND V(o3_1_5) AT=875.000000p
.measure tran VK3_1_6W2 FIND V(o3_1_6) AT=875.000000p
.measure tran VK3_1_7W2 FIND V(o3_1_7) AT=875.000000p
.measure tran VK3_2_0W2 FIND V(o3_2_0) AT=875.000000p
.measure tran VK3_2_1W2 FIND V(o3_2_1) AT=875.000000p
.measure tran VK3_2_2W2 FIND V(o3_2_2) AT=875.000000p
.measure tran VK3_2_3W2 FIND V(o3_2_3) AT=875.000000p
.measure tran VK3_2_4W2 FIND V(o3_2_4) AT=875.000000p
.measure tran VK3_2_5W2 FIND V(o3_2_5) AT=875.000000p
.measure tran VK3_2_6W2 FIND V(o3_2_6) AT=875.000000p
.measure tran VK3_2_7W2 FIND V(o3_2_7) AT=875.000000p
.measure tran VK3_3_0W2 FIND V(o3_3_0) AT=875.000000p
.measure tran VK3_3_1W2 FIND V(o3_3_1) AT=875.000000p
.measure tran VK3_3_2W2 FIND V(o3_3_2) AT=875.000000p
.measure tran VK3_3_3W2 FIND V(o3_3_3) AT=875.000000p
.measure tran VK3_3_4W2 FIND V(o3_3_4) AT=875.000000p
.measure tran VK3_3_5W2 FIND V(o3_3_5) AT=875.000000p
.measure tran VK3_3_6W2 FIND V(o3_3_6) AT=875.000000p
.measure tran VK3_3_7W2 FIND V(o3_3_7) AT=875.000000p
.measure tran VRK4W2 FIND V(ph4) AT=967.000000p
.measure tran VK4_1_0W2 FIND V(o4_1_0) AT=967.000000p
.measure tran VK4_1_1W2 FIND V(o4_1_1) AT=967.000000p
.measure tran VK4_1_2W2 FIND V(o4_1_2) AT=967.000000p
.measure tran VK4_1_3W2 FIND V(o4_1_3) AT=967.000000p
.measure tran VK4_1_4W2 FIND V(o4_1_4) AT=967.000000p
.measure tran VK4_1_5W2 FIND V(o4_1_5) AT=967.000000p
.measure tran VK4_1_6W2 FIND V(o4_1_6) AT=967.000000p
.measure tran VK4_1_7W2 FIND V(o4_1_7) AT=967.000000p
.measure tran VK4_2_0W2 FIND V(o4_2_0) AT=967.000000p
.measure tran VK4_2_1W2 FIND V(o4_2_1) AT=967.000000p
.measure tran VK4_2_2W2 FIND V(o4_2_2) AT=967.000000p
.measure tran VK4_2_3W2 FIND V(o4_2_3) AT=967.000000p
.measure tran VK4_2_4W2 FIND V(o4_2_4) AT=967.000000p
.measure tran VK4_2_5W2 FIND V(o4_2_5) AT=967.000000p
.measure tran VK4_2_6W2 FIND V(o4_2_6) AT=967.000000p
.measure tran VK4_2_7W2 FIND V(o4_2_7) AT=967.000000p
.measure tran VK4_3_0W2 FIND V(o4_3_0) AT=967.000000p
.measure tran VK4_3_1W2 FIND V(o4_3_1) AT=967.000000p
.measure tran VK4_3_2W2 FIND V(o4_3_2) AT=967.000000p
.measure tran VK4_3_3W2 FIND V(o4_3_3) AT=967.000000p
.measure tran VK4_3_4W2 FIND V(o4_3_4) AT=967.000000p
.measure tran VK4_3_5W2 FIND V(o4_3_5) AT=967.000000p
.measure tran VK4_3_6W2 FIND V(o4_3_6) AT=967.000000p
.measure tran VK4_3_7W2 FIND V(o4_3_7) AT=967.000000p
.measure tran VRK5W2 FIND V(ph5) AT=1059.000000p
.measure tran VK5_1_0W2 FIND V(o5_1_0) AT=1059.000000p
.measure tran VK5_1_1W2 FIND V(o5_1_1) AT=1059.000000p
.measure tran VK5_1_2W2 FIND V(o5_1_2) AT=1059.000000p
.measure tran VK5_1_3W2 FIND V(o5_1_3) AT=1059.000000p
.measure tran VK5_1_4W2 FIND V(o5_1_4) AT=1059.000000p
.measure tran VK5_1_5W2 FIND V(o5_1_5) AT=1059.000000p
.measure tran VK5_1_6W2 FIND V(o5_1_6) AT=1059.000000p
.measure tran VK5_1_7W2 FIND V(o5_1_7) AT=1059.000000p
.measure tran VK5_2_0W2 FIND V(o5_2_0) AT=1059.000000p
.measure tran VK5_2_1W2 FIND V(o5_2_1) AT=1059.000000p
.measure tran VK5_2_2W2 FIND V(o5_2_2) AT=1059.000000p
.measure tran VK5_2_3W2 FIND V(o5_2_3) AT=1059.000000p
.measure tran VK5_2_4W2 FIND V(o5_2_4) AT=1059.000000p
.measure tran VK5_2_5W2 FIND V(o5_2_5) AT=1059.000000p
.measure tran VK5_2_6W2 FIND V(o5_2_6) AT=1059.000000p
.measure tran VK5_2_7W2 FIND V(o5_2_7) AT=1059.000000p
.measure tran VK5_3_0W2 FIND V(o5_3_0) AT=1059.000000p
.measure tran VK5_3_1W2 FIND V(o5_3_1) AT=1059.000000p
.measure tran VK5_3_2W2 FIND V(o5_3_2) AT=1059.000000p
.measure tran VK5_3_3W2 FIND V(o5_3_3) AT=1059.000000p
.measure tran VK5_3_4W2 FIND V(o5_3_4) AT=1059.000000p
.measure tran VK5_3_5W2 FIND V(o5_3_5) AT=1059.000000p
.measure tran VK5_3_6W2 FIND V(o5_3_6) AT=1059.000000p
.measure tran VK5_3_7W2 FIND V(o5_3_7) AT=1059.000000p
.measure tran VRK6W2 FIND V(ph6) AT=1151.000000p
.measure tran VK6_1_0W2 FIND V(o6_1_0) AT=1151.000000p
.measure tran VK6_1_1W2 FIND V(o6_1_1) AT=1151.000000p
.measure tran VK6_1_2W2 FIND V(o6_1_2) AT=1151.000000p
.measure tran VK6_1_3W2 FIND V(o6_1_3) AT=1151.000000p
.measure tran VK6_1_4W2 FIND V(o6_1_4) AT=1151.000000p
.measure tran VK6_1_5W2 FIND V(o6_1_5) AT=1151.000000p
.measure tran VK6_1_6W2 FIND V(o6_1_6) AT=1151.000000p
.measure tran VK6_1_7W2 FIND V(o6_1_7) AT=1151.000000p
.measure tran VK6_2_0W2 FIND V(o6_2_0) AT=1151.000000p
.measure tran VK6_2_1W2 FIND V(o6_2_1) AT=1151.000000p
.measure tran VK6_2_2W2 FIND V(o6_2_2) AT=1151.000000p
.measure tran VK6_2_3W2 FIND V(o6_2_3) AT=1151.000000p
.measure tran VK6_2_4W2 FIND V(o6_2_4) AT=1151.000000p
.measure tran VK6_2_5W2 FIND V(o6_2_5) AT=1151.000000p
.measure tran VK6_2_6W2 FIND V(o6_2_6) AT=1151.000000p
.measure tran VK6_2_7W2 FIND V(o6_2_7) AT=1151.000000p
.measure tran VK6_3_0W2 FIND V(o6_3_0) AT=1151.000000p
.measure tran VK6_3_1W2 FIND V(o6_3_1) AT=1151.000000p
.measure tran VK6_3_2W2 FIND V(o6_3_2) AT=1151.000000p
.measure tran VK6_3_3W2 FIND V(o6_3_3) AT=1151.000000p
.measure tran VK6_3_4W2 FIND V(o6_3_4) AT=1151.000000p
.measure tran VK6_3_5W2 FIND V(o6_3_5) AT=1151.000000p
.measure tran VK6_3_6W2 FIND V(o6_3_6) AT=1151.000000p
.measure tran VK6_3_7W2 FIND V(o6_3_7) AT=1151.000000p
.measure tran VRK1W3 FIND V(ph1) AT=967.000000p
.measure tran VK1_1_0W3 FIND V(o1_1_0) AT=967.000000p
.measure tran VK1_1_1W3 FIND V(o1_1_1) AT=967.000000p
.measure tran VK1_1_2W3 FIND V(o1_1_2) AT=967.000000p
.measure tran VK1_1_3W3 FIND V(o1_1_3) AT=967.000000p
.measure tran VK1_1_4W3 FIND V(o1_1_4) AT=967.000000p
.measure tran VK1_1_5W3 FIND V(o1_1_5) AT=967.000000p
.measure tran VK1_1_6W3 FIND V(o1_1_6) AT=967.000000p
.measure tran VK1_1_7W3 FIND V(o1_1_7) AT=967.000000p
.measure tran VK1_2_0W3 FIND V(o1_2_0) AT=967.000000p
.measure tran VK1_2_1W3 FIND V(o1_2_1) AT=967.000000p
.measure tran VK1_2_2W3 FIND V(o1_2_2) AT=967.000000p
.measure tran VK1_2_3W3 FIND V(o1_2_3) AT=967.000000p
.measure tran VK1_2_4W3 FIND V(o1_2_4) AT=967.000000p
.measure tran VK1_2_5W3 FIND V(o1_2_5) AT=967.000000p
.measure tran VK1_2_6W3 FIND V(o1_2_6) AT=967.000000p
.measure tran VK1_2_7W3 FIND V(o1_2_7) AT=967.000000p
.measure tran VK1_3_0W3 FIND V(o1_3_0) AT=967.000000p
.measure tran VK1_3_1W3 FIND V(o1_3_1) AT=967.000000p
.measure tran VK1_3_2W3 FIND V(o1_3_2) AT=967.000000p
.measure tran VK1_3_3W3 FIND V(o1_3_3) AT=967.000000p
.measure tran VK1_3_4W3 FIND V(o1_3_4) AT=967.000000p
.measure tran VK1_3_5W3 FIND V(o1_3_5) AT=967.000000p
.measure tran VK1_3_6W3 FIND V(o1_3_6) AT=967.000000p
.measure tran VK1_3_7W3 FIND V(o1_3_7) AT=967.000000p
.measure tran VRK2W3 FIND V(ph2) AT=1059.000000p
.measure tran VK2_1_0W3 FIND V(o2_1_0) AT=1059.000000p
.measure tran VK2_1_1W3 FIND V(o2_1_1) AT=1059.000000p
.measure tran VK2_1_2W3 FIND V(o2_1_2) AT=1059.000000p
.measure tran VK2_1_3W3 FIND V(o2_1_3) AT=1059.000000p
.measure tran VK2_1_4W3 FIND V(o2_1_4) AT=1059.000000p
.measure tran VK2_1_5W3 FIND V(o2_1_5) AT=1059.000000p
.measure tran VK2_1_6W3 FIND V(o2_1_6) AT=1059.000000p
.measure tran VK2_1_7W3 FIND V(o2_1_7) AT=1059.000000p
.measure tran VK2_2_0W3 FIND V(o2_2_0) AT=1059.000000p
.measure tran VK2_2_1W3 FIND V(o2_2_1) AT=1059.000000p
.measure tran VK2_2_2W3 FIND V(o2_2_2) AT=1059.000000p
.measure tran VK2_2_3W3 FIND V(o2_2_3) AT=1059.000000p
.measure tran VK2_2_4W3 FIND V(o2_2_4) AT=1059.000000p
.measure tran VK2_2_5W3 FIND V(o2_2_5) AT=1059.000000p
.measure tran VK2_2_6W3 FIND V(o2_2_6) AT=1059.000000p
.measure tran VK2_2_7W3 FIND V(o2_2_7) AT=1059.000000p
.measure tran VK2_3_0W3 FIND V(o2_3_0) AT=1059.000000p
.measure tran VK2_3_1W3 FIND V(o2_3_1) AT=1059.000000p
.measure tran VK2_3_2W3 FIND V(o2_3_2) AT=1059.000000p
.measure tran VK2_3_3W3 FIND V(o2_3_3) AT=1059.000000p
.measure tran VK2_3_4W3 FIND V(o2_3_4) AT=1059.000000p
.measure tran VK2_3_5W3 FIND V(o2_3_5) AT=1059.000000p
.measure tran VK2_3_6W3 FIND V(o2_3_6) AT=1059.000000p
.measure tran VK2_3_7W3 FIND V(o2_3_7) AT=1059.000000p
.measure tran VRK3W3 FIND V(ph3) AT=1151.000000p
.measure tran VK3_1_0W3 FIND V(o3_1_0) AT=1151.000000p
.measure tran VK3_1_1W3 FIND V(o3_1_1) AT=1151.000000p
.measure tran VK3_1_2W3 FIND V(o3_1_2) AT=1151.000000p
.measure tran VK3_1_3W3 FIND V(o3_1_3) AT=1151.000000p
.measure tran VK3_1_4W3 FIND V(o3_1_4) AT=1151.000000p
.measure tran VK3_1_5W3 FIND V(o3_1_5) AT=1151.000000p
.measure tran VK3_1_6W3 FIND V(o3_1_6) AT=1151.000000p
.measure tran VK3_1_7W3 FIND V(o3_1_7) AT=1151.000000p
.measure tran VK3_2_0W3 FIND V(o3_2_0) AT=1151.000000p
.measure tran VK3_2_1W3 FIND V(o3_2_1) AT=1151.000000p
.measure tran VK3_2_2W3 FIND V(o3_2_2) AT=1151.000000p
.measure tran VK3_2_3W3 FIND V(o3_2_3) AT=1151.000000p
.measure tran VK3_2_4W3 FIND V(o3_2_4) AT=1151.000000p
.measure tran VK3_2_5W3 FIND V(o3_2_5) AT=1151.000000p
.measure tran VK3_2_6W3 FIND V(o3_2_6) AT=1151.000000p
.measure tran VK3_2_7W3 FIND V(o3_2_7) AT=1151.000000p
.measure tran VK3_3_0W3 FIND V(o3_3_0) AT=1151.000000p
.measure tran VK3_3_1W3 FIND V(o3_3_1) AT=1151.000000p
.measure tran VK3_3_2W3 FIND V(o3_3_2) AT=1151.000000p
.measure tran VK3_3_3W3 FIND V(o3_3_3) AT=1151.000000p
.measure tran VK3_3_4W3 FIND V(o3_3_4) AT=1151.000000p
.measure tran VK3_3_5W3 FIND V(o3_3_5) AT=1151.000000p
.measure tran VK3_3_6W3 FIND V(o3_3_6) AT=1151.000000p
.measure tran VK3_3_7W3 FIND V(o3_3_7) AT=1151.000000p
.measure tran VRK4W3 FIND V(ph4) AT=1243.000000p
.measure tran VK4_1_0W3 FIND V(o4_1_0) AT=1243.000000p
.measure tran VK4_1_1W3 FIND V(o4_1_1) AT=1243.000000p
.measure tran VK4_1_2W3 FIND V(o4_1_2) AT=1243.000000p
.measure tran VK4_1_3W3 FIND V(o4_1_3) AT=1243.000000p
.measure tran VK4_1_4W3 FIND V(o4_1_4) AT=1243.000000p
.measure tran VK4_1_5W3 FIND V(o4_1_5) AT=1243.000000p
.measure tran VK4_1_6W3 FIND V(o4_1_6) AT=1243.000000p
.measure tran VK4_1_7W3 FIND V(o4_1_7) AT=1243.000000p
.measure tran VK4_2_0W3 FIND V(o4_2_0) AT=1243.000000p
.measure tran VK4_2_1W3 FIND V(o4_2_1) AT=1243.000000p
.measure tran VK4_2_2W3 FIND V(o4_2_2) AT=1243.000000p
.measure tran VK4_2_3W3 FIND V(o4_2_3) AT=1243.000000p
.measure tran VK4_2_4W3 FIND V(o4_2_4) AT=1243.000000p
.measure tran VK4_2_5W3 FIND V(o4_2_5) AT=1243.000000p
.measure tran VK4_2_6W3 FIND V(o4_2_6) AT=1243.000000p
.measure tran VK4_2_7W3 FIND V(o4_2_7) AT=1243.000000p
.measure tran VK4_3_0W3 FIND V(o4_3_0) AT=1243.000000p
.measure tran VK4_3_1W3 FIND V(o4_3_1) AT=1243.000000p
.measure tran VK4_3_2W3 FIND V(o4_3_2) AT=1243.000000p
.measure tran VK4_3_3W3 FIND V(o4_3_3) AT=1243.000000p
.measure tran VK4_3_4W3 FIND V(o4_3_4) AT=1243.000000p
.measure tran VK4_3_5W3 FIND V(o4_3_5) AT=1243.000000p
.measure tran VK4_3_6W3 FIND V(o4_3_6) AT=1243.000000p
.measure tran VK4_3_7W3 FIND V(o4_3_7) AT=1243.000000p
.measure tran VRK5W3 FIND V(ph5) AT=1335.000000p
.measure tran VK5_1_0W3 FIND V(o5_1_0) AT=1335.000000p
.measure tran VK5_1_1W3 FIND V(o5_1_1) AT=1335.000000p
.measure tran VK5_1_2W3 FIND V(o5_1_2) AT=1335.000000p
.measure tran VK5_1_3W3 FIND V(o5_1_3) AT=1335.000000p
.measure tran VK5_1_4W3 FIND V(o5_1_4) AT=1335.000000p
.measure tran VK5_1_5W3 FIND V(o5_1_5) AT=1335.000000p
.measure tran VK5_1_6W3 FIND V(o5_1_6) AT=1335.000000p
.measure tran VK5_1_7W3 FIND V(o5_1_7) AT=1335.000000p
.measure tran VK5_2_0W3 FIND V(o5_2_0) AT=1335.000000p
.measure tran VK5_2_1W3 FIND V(o5_2_1) AT=1335.000000p
.measure tran VK5_2_2W3 FIND V(o5_2_2) AT=1335.000000p
.measure tran VK5_2_3W3 FIND V(o5_2_3) AT=1335.000000p
.measure tran VK5_2_4W3 FIND V(o5_2_4) AT=1335.000000p
.measure tran VK5_2_5W3 FIND V(o5_2_5) AT=1335.000000p
.measure tran VK5_2_6W3 FIND V(o5_2_6) AT=1335.000000p
.measure tran VK5_2_7W3 FIND V(o5_2_7) AT=1335.000000p
.measure tran VK5_3_0W3 FIND V(o5_3_0) AT=1335.000000p
.measure tran VK5_3_1W3 FIND V(o5_3_1) AT=1335.000000p
.measure tran VK5_3_2W3 FIND V(o5_3_2) AT=1335.000000p
.measure tran VK5_3_3W3 FIND V(o5_3_3) AT=1335.000000p
.measure tran VK5_3_4W3 FIND V(o5_3_4) AT=1335.000000p
.measure tran VK5_3_5W3 FIND V(o5_3_5) AT=1335.000000p
.measure tran VK5_3_6W3 FIND V(o5_3_6) AT=1335.000000p
.measure tran VK5_3_7W3 FIND V(o5_3_7) AT=1335.000000p
.measure tran VRK6W3 FIND V(ph6) AT=1427.000000p
.measure tran VK6_1_0W3 FIND V(o6_1_0) AT=1427.000000p
.measure tran VK6_1_1W3 FIND V(o6_1_1) AT=1427.000000p
.measure tran VK6_1_2W3 FIND V(o6_1_2) AT=1427.000000p
.measure tran VK6_1_3W3 FIND V(o6_1_3) AT=1427.000000p
.measure tran VK6_1_4W3 FIND V(o6_1_4) AT=1427.000000p
.measure tran VK6_1_5W3 FIND V(o6_1_5) AT=1427.000000p
.measure tran VK6_1_6W3 FIND V(o6_1_6) AT=1427.000000p
.measure tran VK6_1_7W3 FIND V(o6_1_7) AT=1427.000000p
.measure tran VK6_2_0W3 FIND V(o6_2_0) AT=1427.000000p
.measure tran VK6_2_1W3 FIND V(o6_2_1) AT=1427.000000p
.measure tran VK6_2_2W3 FIND V(o6_2_2) AT=1427.000000p
.measure tran VK6_2_3W3 FIND V(o6_2_3) AT=1427.000000p
.measure tran VK6_2_4W3 FIND V(o6_2_4) AT=1427.000000p
.measure tran VK6_2_5W3 FIND V(o6_2_5) AT=1427.000000p
.measure tran VK6_2_6W3 FIND V(o6_2_6) AT=1427.000000p
.measure tran VK6_2_7W3 FIND V(o6_2_7) AT=1427.000000p
.measure tran VK6_3_0W3 FIND V(o6_3_0) AT=1427.000000p
.measure tran VK6_3_1W3 FIND V(o6_3_1) AT=1427.000000p
.measure tran VK6_3_2W3 FIND V(o6_3_2) AT=1427.000000p
.measure tran VK6_3_3W3 FIND V(o6_3_3) AT=1427.000000p
.measure tran VK6_3_4W3 FIND V(o6_3_4) AT=1427.000000p
.measure tran VK6_3_5W3 FIND V(o6_3_5) AT=1427.000000p
.measure tran VK6_3_6W3 FIND V(o6_3_6) AT=1427.000000p
.measure tran VK6_3_7W3 FIND V(o6_3_7) AT=1427.000000p
.measure tran VRK1W4 FIND V(ph1) AT=1243.000000p
.measure tran VK1_1_0W4 FIND V(o1_1_0) AT=1243.000000p
.measure tran VK1_1_1W4 FIND V(o1_1_1) AT=1243.000000p
.measure tran VK1_1_2W4 FIND V(o1_1_2) AT=1243.000000p
.measure tran VK1_1_3W4 FIND V(o1_1_3) AT=1243.000000p
.measure tran VK1_1_4W4 FIND V(o1_1_4) AT=1243.000000p
.measure tran VK1_1_5W4 FIND V(o1_1_5) AT=1243.000000p
.measure tran VK1_1_6W4 FIND V(o1_1_6) AT=1243.000000p
.measure tran VK1_1_7W4 FIND V(o1_1_7) AT=1243.000000p
.measure tran VK1_2_0W4 FIND V(o1_2_0) AT=1243.000000p
.measure tran VK1_2_1W4 FIND V(o1_2_1) AT=1243.000000p
.measure tran VK1_2_2W4 FIND V(o1_2_2) AT=1243.000000p
.measure tran VK1_2_3W4 FIND V(o1_2_3) AT=1243.000000p
.measure tran VK1_2_4W4 FIND V(o1_2_4) AT=1243.000000p
.measure tran VK1_2_5W4 FIND V(o1_2_5) AT=1243.000000p
.measure tran VK1_2_6W4 FIND V(o1_2_6) AT=1243.000000p
.measure tran VK1_2_7W4 FIND V(o1_2_7) AT=1243.000000p
.measure tran VK1_3_0W4 FIND V(o1_3_0) AT=1243.000000p
.measure tran VK1_3_1W4 FIND V(o1_3_1) AT=1243.000000p
.measure tran VK1_3_2W4 FIND V(o1_3_2) AT=1243.000000p
.measure tran VK1_3_3W4 FIND V(o1_3_3) AT=1243.000000p
.measure tran VK1_3_4W4 FIND V(o1_3_4) AT=1243.000000p
.measure tran VK1_3_5W4 FIND V(o1_3_5) AT=1243.000000p
.measure tran VK1_3_6W4 FIND V(o1_3_6) AT=1243.000000p
.measure tran VK1_3_7W4 FIND V(o1_3_7) AT=1243.000000p
.measure tran VRK2W4 FIND V(ph2) AT=1335.000000p
.measure tran VK2_1_0W4 FIND V(o2_1_0) AT=1335.000000p
.measure tran VK2_1_1W4 FIND V(o2_1_1) AT=1335.000000p
.measure tran VK2_1_2W4 FIND V(o2_1_2) AT=1335.000000p
.measure tran VK2_1_3W4 FIND V(o2_1_3) AT=1335.000000p
.measure tran VK2_1_4W4 FIND V(o2_1_4) AT=1335.000000p
.measure tran VK2_1_5W4 FIND V(o2_1_5) AT=1335.000000p
.measure tran VK2_1_6W4 FIND V(o2_1_6) AT=1335.000000p
.measure tran VK2_1_7W4 FIND V(o2_1_7) AT=1335.000000p
.measure tran VK2_2_0W4 FIND V(o2_2_0) AT=1335.000000p
.measure tran VK2_2_1W4 FIND V(o2_2_1) AT=1335.000000p
.measure tran VK2_2_2W4 FIND V(o2_2_2) AT=1335.000000p
.measure tran VK2_2_3W4 FIND V(o2_2_3) AT=1335.000000p
.measure tran VK2_2_4W4 FIND V(o2_2_4) AT=1335.000000p
.measure tran VK2_2_5W4 FIND V(o2_2_5) AT=1335.000000p
.measure tran VK2_2_6W4 FIND V(o2_2_6) AT=1335.000000p
.measure tran VK2_2_7W4 FIND V(o2_2_7) AT=1335.000000p
.measure tran VK2_3_0W4 FIND V(o2_3_0) AT=1335.000000p
.measure tran VK2_3_1W4 FIND V(o2_3_1) AT=1335.000000p
.measure tran VK2_3_2W4 FIND V(o2_3_2) AT=1335.000000p
.measure tran VK2_3_3W4 FIND V(o2_3_3) AT=1335.000000p
.measure tran VK2_3_4W4 FIND V(o2_3_4) AT=1335.000000p
.measure tran VK2_3_5W4 FIND V(o2_3_5) AT=1335.000000p
.measure tran VK2_3_6W4 FIND V(o2_3_6) AT=1335.000000p
.measure tran VK2_3_7W4 FIND V(o2_3_7) AT=1335.000000p
.measure tran VRK3W4 FIND V(ph3) AT=1427.000000p
.measure tran VK3_1_0W4 FIND V(o3_1_0) AT=1427.000000p
.measure tran VK3_1_1W4 FIND V(o3_1_1) AT=1427.000000p
.measure tran VK3_1_2W4 FIND V(o3_1_2) AT=1427.000000p
.measure tran VK3_1_3W4 FIND V(o3_1_3) AT=1427.000000p
.measure tran VK3_1_4W4 FIND V(o3_1_4) AT=1427.000000p
.measure tran VK3_1_5W4 FIND V(o3_1_5) AT=1427.000000p
.measure tran VK3_1_6W4 FIND V(o3_1_6) AT=1427.000000p
.measure tran VK3_1_7W4 FIND V(o3_1_7) AT=1427.000000p
.measure tran VK3_2_0W4 FIND V(o3_2_0) AT=1427.000000p
.measure tran VK3_2_1W4 FIND V(o3_2_1) AT=1427.000000p
.measure tran VK3_2_2W4 FIND V(o3_2_2) AT=1427.000000p
.measure tran VK3_2_3W4 FIND V(o3_2_3) AT=1427.000000p
.measure tran VK3_2_4W4 FIND V(o3_2_4) AT=1427.000000p
.measure tran VK3_2_5W4 FIND V(o3_2_5) AT=1427.000000p
.measure tran VK3_2_6W4 FIND V(o3_2_6) AT=1427.000000p
.measure tran VK3_2_7W4 FIND V(o3_2_7) AT=1427.000000p
.measure tran VK3_3_0W4 FIND V(o3_3_0) AT=1427.000000p
.measure tran VK3_3_1W4 FIND V(o3_3_1) AT=1427.000000p
.measure tran VK3_3_2W4 FIND V(o3_3_2) AT=1427.000000p
.measure tran VK3_3_3W4 FIND V(o3_3_3) AT=1427.000000p
.measure tran VK3_3_4W4 FIND V(o3_3_4) AT=1427.000000p
.measure tran VK3_3_5W4 FIND V(o3_3_5) AT=1427.000000p
.measure tran VK3_3_6W4 FIND V(o3_3_6) AT=1427.000000p
.measure tran VK3_3_7W4 FIND V(o3_3_7) AT=1427.000000p
.measure tran VRK4W4 FIND V(ph4) AT=1519.000000p
.measure tran VK4_1_0W4 FIND V(o4_1_0) AT=1519.000000p
.measure tran VK4_1_1W4 FIND V(o4_1_1) AT=1519.000000p
.measure tran VK4_1_2W4 FIND V(o4_1_2) AT=1519.000000p
.measure tran VK4_1_3W4 FIND V(o4_1_3) AT=1519.000000p
.measure tran VK4_1_4W4 FIND V(o4_1_4) AT=1519.000000p
.measure tran VK4_1_5W4 FIND V(o4_1_5) AT=1519.000000p
.measure tran VK4_1_6W4 FIND V(o4_1_6) AT=1519.000000p
.measure tran VK4_1_7W4 FIND V(o4_1_7) AT=1519.000000p
.measure tran VK4_2_0W4 FIND V(o4_2_0) AT=1519.000000p
.measure tran VK4_2_1W4 FIND V(o4_2_1) AT=1519.000000p
.measure tran VK4_2_2W4 FIND V(o4_2_2) AT=1519.000000p
.measure tran VK4_2_3W4 FIND V(o4_2_3) AT=1519.000000p
.measure tran VK4_2_4W4 FIND V(o4_2_4) AT=1519.000000p
.measure tran VK4_2_5W4 FIND V(o4_2_5) AT=1519.000000p
.measure tran VK4_2_6W4 FIND V(o4_2_6) AT=1519.000000p
.measure tran VK4_2_7W4 FIND V(o4_2_7) AT=1519.000000p
.measure tran VK4_3_0W4 FIND V(o4_3_0) AT=1519.000000p
.measure tran VK4_3_1W4 FIND V(o4_3_1) AT=1519.000000p
.measure tran VK4_3_2W4 FIND V(o4_3_2) AT=1519.000000p
.measure tran VK4_3_3W4 FIND V(o4_3_3) AT=1519.000000p
.measure tran VK4_3_4W4 FIND V(o4_3_4) AT=1519.000000p
.measure tran VK4_3_5W4 FIND V(o4_3_5) AT=1519.000000p
.measure tran VK4_3_6W4 FIND V(o4_3_6) AT=1519.000000p
.measure tran VK4_3_7W4 FIND V(o4_3_7) AT=1519.000000p
.measure tran VRK5W4 FIND V(ph5) AT=1611.000000p
.measure tran VK5_1_0W4 FIND V(o5_1_0) AT=1611.000000p
.measure tran VK5_1_1W4 FIND V(o5_1_1) AT=1611.000000p
.measure tran VK5_1_2W4 FIND V(o5_1_2) AT=1611.000000p
.measure tran VK5_1_3W4 FIND V(o5_1_3) AT=1611.000000p
.measure tran VK5_1_4W4 FIND V(o5_1_4) AT=1611.000000p
.measure tran VK5_1_5W4 FIND V(o5_1_5) AT=1611.000000p
.measure tran VK5_1_6W4 FIND V(o5_1_6) AT=1611.000000p
.measure tran VK5_1_7W4 FIND V(o5_1_7) AT=1611.000000p
.measure tran VK5_2_0W4 FIND V(o5_2_0) AT=1611.000000p
.measure tran VK5_2_1W4 FIND V(o5_2_1) AT=1611.000000p
.measure tran VK5_2_2W4 FIND V(o5_2_2) AT=1611.000000p
.measure tran VK5_2_3W4 FIND V(o5_2_3) AT=1611.000000p
.measure tran VK5_2_4W4 FIND V(o5_2_4) AT=1611.000000p
.measure tran VK5_2_5W4 FIND V(o5_2_5) AT=1611.000000p
.measure tran VK5_2_6W4 FIND V(o5_2_6) AT=1611.000000p
.measure tran VK5_2_7W4 FIND V(o5_2_7) AT=1611.000000p
.measure tran VK5_3_0W4 FIND V(o5_3_0) AT=1611.000000p
.measure tran VK5_3_1W4 FIND V(o5_3_1) AT=1611.000000p
.measure tran VK5_3_2W4 FIND V(o5_3_2) AT=1611.000000p
.measure tran VK5_3_3W4 FIND V(o5_3_3) AT=1611.000000p
.measure tran VK5_3_4W4 FIND V(o5_3_4) AT=1611.000000p
.measure tran VK5_3_5W4 FIND V(o5_3_5) AT=1611.000000p
.measure tran VK5_3_6W4 FIND V(o5_3_6) AT=1611.000000p
.measure tran VK5_3_7W4 FIND V(o5_3_7) AT=1611.000000p
.measure tran VRK6W4 FIND V(ph6) AT=1703.000000p
.measure tran VK6_1_0W4 FIND V(o6_1_0) AT=1703.000000p
.measure tran VK6_1_1W4 FIND V(o6_1_1) AT=1703.000000p
.measure tran VK6_1_2W4 FIND V(o6_1_2) AT=1703.000000p
.measure tran VK6_1_3W4 FIND V(o6_1_3) AT=1703.000000p
.measure tran VK6_1_4W4 FIND V(o6_1_4) AT=1703.000000p
.measure tran VK6_1_5W4 FIND V(o6_1_5) AT=1703.000000p
.measure tran VK6_1_6W4 FIND V(o6_1_6) AT=1703.000000p
.measure tran VK6_1_7W4 FIND V(o6_1_7) AT=1703.000000p
.measure tran VK6_2_0W4 FIND V(o6_2_0) AT=1703.000000p
.measure tran VK6_2_1W4 FIND V(o6_2_1) AT=1703.000000p
.measure tran VK6_2_2W4 FIND V(o6_2_2) AT=1703.000000p
.measure tran VK6_2_3W4 FIND V(o6_2_3) AT=1703.000000p
.measure tran VK6_2_4W4 FIND V(o6_2_4) AT=1703.000000p
.measure tran VK6_2_5W4 FIND V(o6_2_5) AT=1703.000000p
.measure tran VK6_2_6W4 FIND V(o6_2_6) AT=1703.000000p
.measure tran VK6_2_7W4 FIND V(o6_2_7) AT=1703.000000p
.measure tran VK6_3_0W4 FIND V(o6_3_0) AT=1703.000000p
.measure tran VK6_3_1W4 FIND V(o6_3_1) AT=1703.000000p
.measure tran VK6_3_2W4 FIND V(o6_3_2) AT=1703.000000p
.measure tran VK6_3_3W4 FIND V(o6_3_3) AT=1703.000000p
.measure tran VK6_3_4W4 FIND V(o6_3_4) AT=1703.000000p
.measure tran VK6_3_5W4 FIND V(o6_3_5) AT=1703.000000p
.measure tran VK6_3_6W4 FIND V(o6_3_6) AT=1703.000000p
.measure tran VK6_3_7W4 FIND V(o6_3_7) AT=1703.000000p
.measure tran QPH1T2 FIND V(xqph1) AT=553.000000p
.measure tran EPH1T2 FIND V(xeph1) AT=553.000000p
.measure tran QPH1R2 FIND V(xqph1) AT=645.000000p
.measure tran EPH1R2 FIND V(xeph1) AT=645.000000p
.measure tran QPH1H2 FIND V(xqph1) AT=737.000000p
.measure tran EPH1H2 FIND V(xeph1) AT=737.000000p
.measure tran QPH1T3 FIND V(xqph1) AT=829.000000p
.measure tran EPH1T3 FIND V(xeph1) AT=829.000000p
.measure tran QPH1R3 FIND V(xqph1) AT=921.000000p
.measure tran EPH1R3 FIND V(xeph1) AT=921.000000p
.measure tran QPH1H3 FIND V(xqph1) AT=1013.000000p
.measure tran EPH1H3 FIND V(xeph1) AT=1013.000000p
.measure tran QPH1T4 FIND V(xqph1) AT=1105.000000p
.measure tran EPH1T4 FIND V(xeph1) AT=1105.000000p
.measure tran QPH1R4 FIND V(xqph1) AT=1197.000000p
.measure tran EPH1R4 FIND V(xeph1) AT=1197.000000p
.measure tran QPH1H4 FIND V(xqph1) AT=1289.000000p
.measure tran EPH1H4 FIND V(xeph1) AT=1289.000000p
.measure tran QPH1T5 FIND V(xqph1) AT=1381.000000p
.measure tran EPH1T5 FIND V(xeph1) AT=1381.000000p
.measure tran QPH2T2 FIND V(xqph2) AT=645.000000p
.measure tran EPH2T2 FIND V(xeph2) AT=645.000000p
.measure tran QPH2R2 FIND V(xqph2) AT=737.000000p
.measure tran EPH2R2 FIND V(xeph2) AT=737.000000p
.measure tran QPH2H2 FIND V(xqph2) AT=829.000000p
.measure tran EPH2H2 FIND V(xeph2) AT=829.000000p
.measure tran QPH2T3 FIND V(xqph2) AT=921.000000p
.measure tran EPH2T3 FIND V(xeph2) AT=921.000000p
.measure tran QPH2R3 FIND V(xqph2) AT=1013.000000p
.measure tran EPH2R3 FIND V(xeph2) AT=1013.000000p
.measure tran QPH2H3 FIND V(xqph2) AT=1105.000000p
.measure tran EPH2H3 FIND V(xeph2) AT=1105.000000p
.measure tran QPH2T4 FIND V(xqph2) AT=1197.000000p
.measure tran EPH2T4 FIND V(xeph2) AT=1197.000000p
.measure tran QPH2R4 FIND V(xqph2) AT=1289.000000p
.measure tran EPH2R4 FIND V(xeph2) AT=1289.000000p
.measure tran QPH2H4 FIND V(xqph2) AT=1381.000000p
.measure tran EPH2H4 FIND V(xeph2) AT=1381.000000p
.measure tran QPH2T5 FIND V(xqph2) AT=1473.000000p
.measure tran EPH2T5 FIND V(xeph2) AT=1473.000000p
.measure tran QPH3T2 FIND V(xqph3) AT=737.000000p
.measure tran EPH3T2 FIND V(xeph3) AT=737.000000p
.measure tran QPH3R2 FIND V(xqph3) AT=829.000000p
.measure tran EPH3R2 FIND V(xeph3) AT=829.000000p
.measure tran QPH3H2 FIND V(xqph3) AT=921.000000p
.measure tran EPH3H2 FIND V(xeph3) AT=921.000000p
.measure tran QPH3T3 FIND V(xqph3) AT=1013.000000p
.measure tran EPH3T3 FIND V(xeph3) AT=1013.000000p
.measure tran QPH3R3 FIND V(xqph3) AT=1105.000000p
.measure tran EPH3R3 FIND V(xeph3) AT=1105.000000p
.measure tran QPH3H3 FIND V(xqph3) AT=1197.000000p
.measure tran EPH3H3 FIND V(xeph3) AT=1197.000000p
.measure tran QPH3T4 FIND V(xqph3) AT=1289.000000p
.measure tran EPH3T4 FIND V(xeph3) AT=1289.000000p
.measure tran QPH3R4 FIND V(xqph3) AT=1381.000000p
.measure tran EPH3R4 FIND V(xeph3) AT=1381.000000p
.measure tran QPH3H4 FIND V(xqph3) AT=1473.000000p
.measure tran EPH3H4 FIND V(xeph3) AT=1473.000000p
.measure tran QPH3T5 FIND V(xqph3) AT=1565.000000p
.measure tran EPH3T5 FIND V(xeph3) AT=1565.000000p
.measure tran QPH4T2 FIND V(xqph4) AT=829.000000p
.measure tran EPH4T2 FIND V(xeph4) AT=829.000000p
.measure tran QPH4R2 FIND V(xqph4) AT=921.000000p
.measure tran EPH4R2 FIND V(xeph4) AT=921.000000p
.measure tran QPH4H2 FIND V(xqph4) AT=1013.000000p
.measure tran EPH4H2 FIND V(xeph4) AT=1013.000000p
.measure tran QPH4T3 FIND V(xqph4) AT=1105.000000p
.measure tran EPH4T3 FIND V(xeph4) AT=1105.000000p
.measure tran QPH4R3 FIND V(xqph4) AT=1197.000000p
.measure tran EPH4R3 FIND V(xeph4) AT=1197.000000p
.measure tran QPH4H3 FIND V(xqph4) AT=1289.000000p
.measure tran EPH4H3 FIND V(xeph4) AT=1289.000000p
.measure tran QPH4T4 FIND V(xqph4) AT=1381.000000p
.measure tran EPH4T4 FIND V(xeph4) AT=1381.000000p
.measure tran QPH4R4 FIND V(xqph4) AT=1473.000000p
.measure tran EPH4R4 FIND V(xeph4) AT=1473.000000p
.measure tran QPH4H4 FIND V(xqph4) AT=1565.000000p
.measure tran EPH4H4 FIND V(xeph4) AT=1565.000000p
.measure tran QPH4T5 FIND V(xqph4) AT=1657.000000p
.measure tran EPH4T5 FIND V(xeph4) AT=1657.000000p
.measure tran QPH5T2 FIND V(xqph5) AT=921.000000p
.measure tran EPH5T2 FIND V(xeph5) AT=921.000000p
.measure tran QPH5R2 FIND V(xqph5) AT=1013.000000p
.measure tran EPH5R2 FIND V(xeph5) AT=1013.000000p
.measure tran QPH5H2 FIND V(xqph5) AT=1105.000000p
.measure tran EPH5H2 FIND V(xeph5) AT=1105.000000p
.measure tran QPH5T3 FIND V(xqph5) AT=1197.000000p
.measure tran EPH5T3 FIND V(xeph5) AT=1197.000000p
.measure tran QPH5R3 FIND V(xqph5) AT=1289.000000p
.measure tran EPH5R3 FIND V(xeph5) AT=1289.000000p
.measure tran QPH5H3 FIND V(xqph5) AT=1381.000000p
.measure tran EPH5H3 FIND V(xeph5) AT=1381.000000p
.measure tran QPH5T4 FIND V(xqph5) AT=1473.000000p
.measure tran EPH5T4 FIND V(xeph5) AT=1473.000000p
.measure tran QPH5R4 FIND V(xqph5) AT=1565.000000p
.measure tran EPH5R4 FIND V(xeph5) AT=1565.000000p
.measure tran QPH5H4 FIND V(xqph5) AT=1657.000000p
.measure tran EPH5H4 FIND V(xeph5) AT=1657.000000p
.measure tran QPH5T5 FIND V(xqph5) AT=1749.000000p
.measure tran EPH5T5 FIND V(xeph5) AT=1749.000000p
.measure tran QPH6T2 FIND V(xqph6) AT=1013.000000p
.measure tran EPH6T2 FIND V(xeph6) AT=1013.000000p
.measure tran QPH6R2 FIND V(xqph6) AT=1105.000000p
.measure tran EPH6R2 FIND V(xeph6) AT=1105.000000p
.measure tran QPH6H2 FIND V(xqph6) AT=1197.000000p
.measure tran EPH6H2 FIND V(xeph6) AT=1197.000000p
.measure tran QPH6T3 FIND V(xqph6) AT=1289.000000p
.measure tran EPH6T3 FIND V(xeph6) AT=1289.000000p
.measure tran QPH6R3 FIND V(xqph6) AT=1381.000000p
.measure tran EPH6R3 FIND V(xeph6) AT=1381.000000p
.measure tran QPH6H3 FIND V(xqph6) AT=1473.000000p
.measure tran EPH6H3 FIND V(xeph6) AT=1473.000000p
.measure tran QPH6T4 FIND V(xqph6) AT=1565.000000p
.measure tran EPH6T4 FIND V(xeph6) AT=1565.000000p
.measure tran QPH6R4 FIND V(xqph6) AT=1657.000000p
.measure tran EPH6R4 FIND V(xeph6) AT=1657.000000p
.measure tran QPH6H4 FIND V(xqph6) AT=1749.000000p
.measure tran EPH6H4 FIND V(xeph6) AT=1749.000000p
.measure tran QPH6T5 FIND V(xqph6) AT=1841.000000p
.measure tran EPH6T5 FIND V(xeph6) AT=1841.000000p
.print tran V(ph1) V(ph2) V(ph3) V(ph4) V(ph5) V(ph6) V(o1_1_0) V(o1_1_1) V(o1_1_2) V(o1_1_3) V(o1_1_4) V(o1_1_5) V(o1_1_6) V(o1_1_7) V(o1_2_0) V(o1_2_1) V(o1_2_2) V(o1_2_3) V(o1_2_4) V(o1_2_5) V(o1_2_6) V(o1_2_7) V(o1_3_0) V(o1_3_1) V(o1_3_2) V(o1_3_3) V(o1_3_4) V(o1_3_5) V(o1_3_6) V(o1_3_7) V(o2_1_0) V(o2_1_1) V(o2_1_2) V(o2_1_3) V(o2_1_4) V(o2_1_5) V(o2_1_6) V(o2_1_7) V(o2_2_0) V(o2_2_1) V(o2_2_2) V(o2_2_3) V(o2_2_4) V(o2_2_5) V(o2_2_6) V(o2_2_7) V(o2_3_0) V(o2_3_1) V(o2_3_2) V(o2_3_3) V(o2_3_4) V(o2_3_5) V(o2_3_6) V(o2_3_7) V(o3_1_0) V(o3_1_1) V(o3_1_2) V(o3_1_3) V(o3_1_4) V(o3_1_5) V(o3_1_6) V(o3_1_7) V(o3_2_0) V(o3_2_1) V(o3_2_2) V(o3_2_3) V(o3_2_4) V(o3_2_5) V(o3_2_6) V(o3_2_7) V(o3_3_0) V(o3_3_1) V(o3_3_2) V(o3_3_3) V(o3_3_4) V(o3_3_5) V(o3_3_6) V(o3_3_7) V(o4_1_0) V(o4_1_1) V(o4_1_2) V(o4_1_3) V(o4_1_4) V(o4_1_5) V(o4_1_6) V(o4_1_7) V(o4_2_0) V(o4_2_1) V(o4_2_2) V(o4_2_3) V(o4_2_4) V(o4_2_5) V(o4_2_6) V(o4_2_7) V(o4_3_0) V(o4_3_1) V(o4_3_2) V(o4_3_3) V(o4_3_4) V(o4_3_5) V(o4_3_6) V(o4_3_7) V(o5_1_0) V(o5_1_1) V(o5_1_2) V(o5_1_3) V(o5_1_4) V(o5_1_5) V(o5_1_6) V(o5_1_7) V(o5_2_0) V(o5_2_1) V(o5_2_2) V(o5_2_3) V(o5_2_4) V(o5_2_5) V(o5_2_6) V(o5_2_7) V(o5_3_0) V(o5_3_1) V(o5_3_2) V(o5_3_3) V(o5_3_4) V(o5_3_5) V(o5_3_6) V(o5_3_7) V(o6_1_0) V(o6_1_1) V(o6_1_2) V(o6_1_3) V(o6_1_4) V(o6_1_5) V(o6_1_6) V(o6_1_7) V(o6_2_0) V(o6_2_1) V(o6_2_2) V(o6_2_3) V(o6_2_4) V(o6_2_5) V(o6_2_6) V(o6_2_7) V(o6_3_0) V(o6_3_1) V(o6_3_2) V(o6_3_3) V(o6_3_4) V(o6_3_5) V(o6_3_6) V(o6_3_7) I(VPH1) I(VPH2) I(VPH3) I(VPH4) I(VPH5) I(VPH6) I(VMG1) I(VMG2) I(VMG3) I(VMG4) I(VMG5) I(VMG6) I(VAIR1) I(VAIR2) I(VAIR3) I(VAIR4) I(VAIR5) I(VAIR6) I(VH1) I(VH2) I(VH3) I(VH4) I(VH5) I(VH6) I(VF1) I(VF2) I(VF3) I(VF4) I(VF5) I(VF6)
.end
