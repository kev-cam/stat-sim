* qal/mblocks xyce_crc_g0_tt92_nw6
.hdl "/usr/local/share/xyce/verilog-a/psp103/psp103.va"
.include "/usr/local/src/kestrel/sim/models/sg13g2_psp103_tt.lib"
.include "/usr/local/src/stat-sim/qal/sg13lv_compat.sp"
.OPTIONS TIMEINT METHOD=GEAR RELTOL=1e-6 ABSTOL=1e-15 CHGTOL=1e-17
VPH1 phs1 0 PWL(0 0 92p 1.65 184p 1.65 276p 0 368p 1.65 460p 1.65 552p 0 644p 1.65 736p 1.65 828p 0 920p 1.65 1012p 1.65 1104p 0 1196p 1.65 1288p 1.65 1380p 0 1472p 1.65 1564p 1.65 1656p 0 1748p 1.65 1840p 1.65 1932p 0 2024p 1.65 2116p 1.65 2208p 0 2300p 1.65 2392p 1.65)
RS1 phs1 ph1 0.001
VMG1 gn1 0 0
VPH2 phs2 0 PWL(0 1.65 92p 0 184p 1.65 276p 1.65 368p 0 460p 1.65 552p 1.65 644p 0 736p 1.65 828p 1.65 920p 0 1012p 1.65 1104p 1.65 1196p 0 1288p 1.65 1380p 1.65 1472p 0 1564p 1.65 1656p 1.65 1748p 0 1840p 1.65 1932p 1.65 2024p 0 2116p 1.65 2208p 1.65)
RS2 phs2 ph2 0.001
VMG2 gn2 0 0
VPH3 phs3 0 PWL(0 1.65 92p 1.65 184p 0 276p 1.65 368p 1.65 460p 0 552p 1.65 644p 1.65 736p 0 828p 1.65 920p 1.65 1012p 0 1104p 1.65 1196p 1.65 1288p 0 1380p 1.65 1472p 1.65 1564p 0 1656p 1.65 1748p 1.65 1840p 0 1932p 1.65 2024p 1.65 2116p 0 2208p 1.65 2300p 1.65)
RS3 phs3 ph3 0.001
VMG3 gn3 0 0
VPH4 phs4 0 PWL(0 0 92p 1.65 184p 1.65 276p 0 368p 1.65 460p 1.65 552p 0 644p 1.65 736p 1.65 828p 0 920p 1.65 1012p 1.65 1104p 0 1196p 1.65 1288p 1.65 1380p 0 1472p 1.65 1564p 1.65 1656p 0 1748p 1.65 1840p 1.65 1932p 0 2024p 1.65 2116p 1.65 2208p 0 2300p 1.65 2392p 1.65)
RS4 phs4 ph4 0.001
VMG4 gn4 0 0
VI_s0 s0 0 PWL(0 0 275p 0 277p 1.65 1379p 1.65 1381p 0)
VI_sn0 sn0 0 PWL(0 1.65 275p 1.65 277p 0 1379p 0 1381p 1.65)
VI_s1 s1 0 PWL(0 0 827p 0 829p 1.65 1379p 1.65 1381p 0)
VI_sn1 sn1 0 PWL(0 1.65 827p 1.65 829p 0 1379p 0 1381p 1.65)
VI_s2 s2 0 PWL(0 1.65 551p 1.65 553p 0 827p 0 829p 1.65 1103p 1.65 1105p 0 1379p 0 1381p 1.65)
VI_sn2 sn2 0 PWL(0 0 551p 0 553p 1.65 827p 1.65 829p 0 1103p 0 1105p 1.65 1379p 1.65 1381p 0)
VI_s3 s3 0 PWL(0 0 275p 0 277p 1.65 827p 1.65 829p 0)
VI_sn3 sn3 0 PWL(0 1.65 275p 1.65 277p 0 827p 0 829p 1.65)
VI_s4 s4 0 PWL(0 0 275p 0 277p 1.65)
VI_sn4 sn4 0 PWL(0 1.65 275p 1.65 277p 0)
VI_s5 s5 0 PWL(0 1.65 275p 1.65 277p 0)
VI_sn5 sn5 0 PWL(0 0 275p 0 277p 1.65)
VI_s6 s6 0 PWL(0 0 275p 0 277p 1.65 551p 1.65 553p 0 1103p 0 1105p 1.65 1379p 1.65 1381p 0)
VI_sn6 sn6 0 PWL(0 1.65 275p 1.65 277p 0 551p 0 553p 1.65 1103p 1.65 1105p 0 1379p 0 1381p 1.65)
VI_s7 s7 0 PWL(0 1.65 275p 1.65 277p 0 1103p 0 1105p 1.65)
VI_sn7 sn7 0 PWL(0 0 275p 0 277p 1.65 1103p 1.65 1105p 0)
VI_s8 s8 0 PWL(0 0 827p 0 829p 1.65 1103p 1.65 1105p 0)
VI_sn8 sn8 0 PWL(0 1.65 827p 1.65 829p 0 1103p 0 1105p 1.65)
VI_s9 s9 0 PWL(0 1.65 275p 1.65 277p 0 551p 0 553p 1.65 827p 1.65 829p 0)
VI_sn9 sn9 0 PWL(0 0 275p 0 277p 1.65 551p 1.65 553p 0 827p 0 829p 1.65)
VI_s10 s10 0 PWL(0 1.65 1379p 1.65 1381p 0)
VI_sn10 sn10 0 PWL(0 0 1379p 0 1381p 1.65)
VI_s11 s11 0 PWL(0 0 275p 0 277p 1.65 551p 1.65 553p 0 827p 0 829p 1.65 1379p 1.65 1381p 0)
VI_sn11 sn11 0 PWL(0 1.65 275p 1.65 277p 0 551p 0 553p 1.65 827p 1.65 829p 0 1379p 0 1381p 1.65)
VI_s12 s12 0 PWL(0 1.65 551p 1.65 553p 0 827p 0 829p 1.65 1103p 1.65 1105p 0)
VI_sn12 sn12 0 PWL(0 0 551p 0 553p 1.65 827p 1.65 829p 0 1103p 0 1105p 1.65)
VI_s13 s13 0 PWL(0 0 827p 0 829p 1.65 1103p 1.65 1105p 0 1379p 0 1381p 1.65)
VI_sn13 sn13 0 PWL(0 1.65 827p 1.65 829p 0 1103p 0 1105p 1.65 1379p 1.65 1381p 0)
VI_s14 s14 0 PWL(0 0 275p 0 277p 1.65 827p 1.65 829p 0 1379p 0 1381p 1.65)
VI_sn14 sn14 0 PWL(0 1.65 275p 1.65 277p 0 827p 0 829p 1.65 1379p 1.65 1381p 0)
VI_s15 s15 0 PWL(0 0 827p 0 829p 1.65 1379p 1.65 1381p 0)
VI_sn15 sn15 0 PWL(0 1.65 827p 1.65 829p 0 1379p 0 1381p 1.65)
VI_s16 s16 0 PWL(0 1.65 275p 1.65 277p 0 551p 0 553p 1.65 827p 1.65 829p 0 1379p 0 1381p 1.65)
VI_sn16 sn16 0 PWL(0 0 275p 0 277p 1.65 551p 1.65 553p 0 827p 0 829p 1.65 1379p 1.65 1381p 0)
VI_s17 s17 0 PWL(0 0 275p 0 277p 1.65 551p 1.65 553p 0 827p 0 829p 1.65 1103p 1.65 1105p 0 1379p 0 1381p 1.65)
VI_sn17 sn17 0 PWL(0 1.65 275p 1.65 277p 0 551p 0 553p 1.65 827p 1.65 829p 0 1103p 0 1105p 1.65 1379p 1.65 1381p 0)
VI_s18 s18 0 PWL(0 0 275p 0 277p 1.65 827p 1.65 829p 0 1103p 0 1105p 1.65)
VI_sn18 sn18 0 PWL(0 1.65 275p 1.65 277p 0 827p 0 829p 1.65 1103p 1.65 1105p 0)
VI_s19 s19 0 PWL(0 0 1103p 0 1105p 1.65 1379p 1.65 1381p 0)
VI_sn19 sn19 0 PWL(0 1.65 1103p 1.65 1105p 0 1379p 0 1381p 1.65)
VI_s20 s20 0 PWL(0 1.65 1103p 1.65 1105p 0 1379p 0 1381p 1.65)
VI_sn20 sn20 0 PWL(0 0 1103p 0 1105p 1.65 1379p 1.65 1381p 0)
VI_s21 s21 0 PWL(0 0 275p 0 277p 1.65 551p 1.65 553p 0 1103p 0 1105p 1.65 1379p 1.65 1381p 0)
VI_sn21 sn21 0 PWL(0 1.65 275p 1.65 277p 0 551p 0 553p 1.65 1103p 1.65 1105p 0 1379p 0 1381p 1.65)
VI_s22 s22 0 PWL(0 1.65 275p 1.65 277p 0 551p 0 553p 1.65 827p 1.65 829p 0 1103p 0 1105p 1.65 1379p 1.65 1381p 0)
VI_sn22 sn22 0 PWL(0 0 275p 0 277p 1.65 551p 1.65 553p 0 827p 0 829p 1.65 1103p 1.65 1105p 0 1379p 0 1381p 1.65)
VI_s23 s23 0 PWL(0 0 275p 0 277p 1.65 1103p 1.65 1105p 0 1379p 0 1381p 1.65)
VI_sn23 sn23 0 PWL(0 1.65 275p 1.65 277p 0 1103p 0 1105p 1.65 1379p 1.65 1381p 0)
VI_s24 s24 0 PWL(0 0 551p 0 553p 1.65)
VI_sn24 sn24 0 PWL(0 1.65 551p 1.65 553p 0)
VI_s25 s25 0 PWL(0 0 827p 0 829p 1.65)
VI_sn25 sn25 0 PWL(0 1.65 827p 1.65 829p 0)
VI_s26 s26 0 PWL(0 1.65 275p 1.65 277p 0 1103p 0 1105p 1.65 1379p 1.65 1381p 0)
VI_sn26 sn26 0 PWL(0 0 275p 0 277p 1.65 1103p 1.65 1105p 0 1379p 0 1381p 1.65)
VI_s27 s27 0 PWL(0 1.65 1103p 1.65 1105p 0)
VI_sn27 sn27 0 PWL(0 0 1103p 0 1105p 1.65)
VI_s28 s28 0 PWL(0 0 551p 0 553p 1.65 1103p 1.65 1105p 0)
VI_sn28 sn28 0 PWL(0 1.65 551p 1.65 553p 0 1103p 0 1105p 1.65)
VI_s29 s29 0 PWL(0 0 275p 0 277p 1.65 551p 1.65 553p 0 827p 0 829p 1.65)
VI_sn29 sn29 0 PWL(0 1.65 275p 1.65 277p 0 551p 0 553p 1.65 827p 1.65 829p 0)
VI_s30 s30 0 PWL(0 1.65 275p 1.65 277p 0 551p 0 553p 1.65 827p 1.65 829p 0)
VI_sn30 sn30 0 PWL(0 0 275p 0 277p 1.65 551p 1.65 553p 0 827p 0 829p 1.65)
VI_s31 s31 0 PWL(0 0 275p 0 277p 1.65 551p 1.65 553p 0 827p 0 829p 1.65 1103p 1.65 1105p 0 1379p 0 1381p 1.65)
VI_sn31 sn31 0 PWL(0 1.65 275p 1.65 277p 0 551p 0 553p 1.65 827p 1.65 829p 0 1103p 0 1105p 1.65 1379p 1.65 1381p 0)
VI_d0 d0 0 PWL(0 1.65 275p 1.65 277p 0 827p 0 829p 1.65 1103p 1.65 1105p 0 1379p 0 1381p 1.65)
VI_dn0 dn0 0 PWL(0 0 275p 0 277p 1.65 827p 1.65 829p 0 1103p 0 1105p 1.65 1379p 1.65 1381p 0)
VI_d1 d1 0 PWL(0 1.65 275p 1.65 277p 0)
VI_dn1 dn1 0 PWL(0 0 275p 0 277p 1.65)
VI_d2 d2 0 PWL(0 0 275p 0 277p 1.65 827p 1.65 829p 0 1103p 0 1105p 1.65)
VI_dn2 dn2 0 PWL(0 1.65 275p 1.65 277p 0 827p 0 829p 1.65 1103p 1.65 1105p 0)
VI_d3 d3 0 PWL(0 1.65 551p 1.65 553p 0 1103p 0 1105p 1.65)
VI_dn3 dn3 0 PWL(0 0 551p 0 553p 1.65 1103p 1.65 1105p 0)
VI_d4 d4 0 PWL(0 0 275p 0 277p 1.65 551p 1.65 553p 0 1103p 0 1105p 1.65)
VI_dn4 dn4 0 PWL(0 1.65 275p 1.65 277p 0 551p 0 553p 1.65 1103p 1.65 1105p 0)
VI_d5 d5 0 PWL(0 0 551p 0 553p 1.65 1103p 1.65 1105p 0)
VI_dn5 dn5 0 PWL(0 1.65 551p 1.65 553p 0 1103p 0 1105p 1.65)
VI_d6 d6 0 PWL(0 0 275p 0 277p 1.65 551p 1.65 553p 0)
VI_dn6 dn6 0 PWL(0 1.65 275p 1.65 277p 0 551p 0 553p 1.65)
VI_d7 d7 0 PWL(0 1.65 1103p 1.65 1105p 0)
VI_dn7 dn7 0 PWL(0 0 1103p 0 1105p 1.65)
VI_d8 d8 0 PWL(0 1.65 551p 1.65 553p 0 827p 0 829p 1.65 1103p 1.65 1105p 0)
VI_dn8 dn8 0 PWL(0 0 551p 0 553p 1.65 827p 1.65 829p 0 1103p 0 1105p 1.65)
VI_d9 d9 0 PWL(0 1.65 551p 1.65 553p 0 1103p 0 1105p 1.65 1379p 1.65 1381p 0)
VI_dn9 dn9 0 PWL(0 0 551p 0 553p 1.65 1103p 1.65 1105p 0 1379p 0 1381p 1.65)
VI_d10 d10 0 PWL(0 1.65 275p 1.65 277p 0 1103p 0 1105p 1.65 1379p 1.65 1381p 0)
VI_dn10 dn10 0 PWL(0 0 275p 0 277p 1.65 1103p 1.65 1105p 0 1379p 0 1381p 1.65)
VI_d11 d11 0 PWL(0 1.65 275p 1.65 277p 0 827p 0 829p 1.65 1103p 1.65 1105p 0)
VI_dn11 dn11 0 PWL(0 0 275p 0 277p 1.65 827p 1.65 829p 0 1103p 0 1105p 1.65)
VI_d12 d12 0 PWL(0 1.65 827p 1.65 829p 0 1379p 0 1381p 1.65)
VI_dn12 dn12 0 PWL(0 0 827p 0 829p 1.65 1379p 1.65 1381p 0)
VI_d13 d13 0 PWL(0 0 551p 0 553p 1.65 1103p 1.65 1105p 0)
VI_dn13 dn13 0 PWL(0 1.65 551p 1.65 553p 0 1103p 0 1105p 1.65)
VI_d14 d14 0 PWL(0 0 551p 0 553p 1.65)
VI_dn14 dn14 0 PWL(0 1.65 551p 1.65 553p 0)
VI_d15 d15 0 PWL(0 0 551p 0 553p 1.65 1103p 1.65 1105p 0 1379p 0 1381p 1.65)
VI_dn15 dn15 0 PWL(0 1.65 551p 1.65 553p 0 1103p 0 1105p 1.65 1379p 1.65 1381p 0)
VI_d16 d16 0 PWL(0 0 827p 0 829p 1.65)
VI_dn16 dn16 0 PWL(0 1.65 827p 1.65 829p 0)
VI_d17 d17 0 PWL(0 1.65 551p 1.65 553p 0 1379p 0 1381p 1.65)
VI_dn17 dn17 0 PWL(0 0 551p 0 553p 1.65 1379p 1.65 1381p 0)
VI_d18 d18 0 PWL(0 1.65 551p 1.65 553p 0 1379p 0 1381p 1.65)
VI_dn18 dn18 0 PWL(0 0 551p 0 553p 1.65 1379p 1.65 1381p 0)
VI_d19 d19 0 PWL(0 1.65 275p 1.65 277p 0 827p 0 829p 1.65 1103p 1.65 1105p 0 1379p 0 1381p 1.65)
VI_dn19 dn19 0 PWL(0 0 275p 0 277p 1.65 827p 1.65 829p 0 1103p 0 1105p 1.65 1379p 1.65 1381p 0)
VI_d20 d20 0 PWL(0 0 275p 0 277p 1.65 551p 1.65 553p 0 1103p 0 1105p 1.65 1379p 1.65 1381p 0)
VI_dn20 dn20 0 PWL(0 1.65 275p 1.65 277p 0 551p 0 553p 1.65 1103p 1.65 1105p 0 1379p 0 1381p 1.65)
VI_d21 d21 0 PWL(0 1.65 827p 1.65 829p 0 1103p 0 1105p 1.65)
VI_dn21 dn21 0 PWL(0 0 827p 0 829p 1.65 1103p 1.65 1105p 0)
VI_d22 d22 0 PWL(0 1.65 275p 1.65 277p 0 827p 0 829p 1.65 1379p 1.65 1381p 0)
VI_dn22 dn22 0 PWL(0 0 275p 0 277p 1.65 827p 1.65 829p 0 1379p 0 1381p 1.65)
VI_d23 d23 0 PWL(0 1.65 827p 1.65 829p 0 1103p 0 1105p 1.65 1379p 1.65 1381p 0)
VI_dn23 dn23 0 PWL(0 0 827p 0 829p 1.65 1103p 1.65 1105p 0 1379p 0 1381p 1.65)
VI_d24 d24 0 PWL(0 0 275p 0 277p 1.65 551p 1.65 553p 0 827p 0 829p 1.65 1379p 1.65 1381p 0)
VI_dn24 dn24 0 PWL(0 1.65 275p 1.65 277p 0 551p 0 553p 1.65 827p 1.65 829p 0 1379p 0 1381p 1.65)
VI_d25 d25 0 PWL(0 0 827p 0 829p 1.65 1103p 1.65 1105p 0)
VI_dn25 dn25 0 PWL(0 1.65 827p 1.65 829p 0 1103p 0 1105p 1.65)
VI_d26 d26 0 PWL(0 0 275p 0 277p 1.65 827p 1.65 829p 0 1103p 0 1105p 1.65)
VI_dn26 dn26 0 PWL(0 1.65 275p 1.65 277p 0 827p 0 829p 1.65 1103p 1.65 1105p 0)
VI_d27 d27 0 PWL(0 1.65 551p 1.65 553p 0 1103p 0 1105p 1.65)
VI_dn27 dn27 0 PWL(0 0 551p 0 553p 1.65 1103p 1.65 1105p 0)
VI_d28 d28 0 PWL(0 0 275p 0 277p 1.65 1103p 1.65 1105p 0)
VI_dn28 dn28 0 PWL(0 1.65 275p 1.65 277p 0 1103p 0 1105p 1.65)
VI_d29 d29 0 PWL(0 1.65 551p 1.65 553p 0 1379p 0 1381p 1.65)
VI_dn29 dn29 0 PWL(0 0 551p 0 553p 1.65 1379p 1.65 1381p 0)
VI_d30 d30 0 PWL(0 0 551p 0 553p 1.65 1103p 1.65 1105p 0)
VI_dn30 dn30 0 PWL(0 1.65 551p 1.65 553p 0 1103p 0 1105p 1.65)
VI_d31 d31 0 PWL(0 1.65 275p 1.65 277p 0 551p 0 553p 1.65 827p 1.65 829p 0 1103p 0 1105p 1.65 1379p 1.65 1381p 0)
VI_dn31 dn31 0 PWL(0 0 275p 0 277p 1.65 551p 1.65 553p 0 827p 0 829p 1.65 1103p 1.65 1105p 0 1379p 0 1381p 1.65)
XPA_n1 n1 s0 ph1 ph1 sg13_lv_pmos w=1.12u l=0.13u
XPB_n1 n1 sn6 ph1 ph1 sg13_lv_pmos w=1.12u l=0.13u
XNA_n1 n1 s0 m_n1 gn1 sg13_lv_nmos w=0.74u l=0.13u
XNB_n1 m_n1 sn6 gn1 gn1 sg13_lv_nmos w=0.74u l=0.13u
CL_n1 n1 gn1 2f
XPA_n10 n10 s9 ph1 ph1 sg13_lv_pmos w=1.12u l=0.13u
XPB_n10 n10 s10 ph1 ph1 sg13_lv_pmos w=1.12u l=0.13u
XNA_n10 n10 s9 m_n10 gn1 sg13_lv_nmos w=0.74u l=0.13u
XNB_n10 m_n10 s10 gn1 gn1 sg13_lv_nmos w=0.74u l=0.13u
CL_n10 n10 gn1 2f
XPA_n100 n100 d21 ph1 ph1 sg13_lv_pmos w=1.12u l=0.13u
XPB_n100 n100 d22 ph1 ph1 sg13_lv_pmos w=1.12u l=0.13u
XNA_n100 n100 d21 m_n100 gn1 sg13_lv_nmos w=0.74u l=0.13u
XNB_n100 m_n100 d22 gn1 gn1 sg13_lv_nmos w=0.74u l=0.13u
CL_n100 n100 gn1 2f
XPA_n101 n101 dn21 ph1 ph1 sg13_lv_pmos w=1.12u l=0.13u
XPB_n101 n101 dn22 ph1 ph1 sg13_lv_pmos w=1.12u l=0.13u
XNA_n101 n101 dn21 m_n101 gn1 sg13_lv_nmos w=0.74u l=0.13u
XNB_n101 m_n101 dn22 gn1 gn1 sg13_lv_nmos w=0.74u l=0.13u
CL_n101 n101 gn1 2f
XPA_n103 n103 d25 ph1 ph1 sg13_lv_pmos w=1.12u l=0.13u
XPB_n103 n103 dn31 ph1 ph1 sg13_lv_pmos w=1.12u l=0.13u
XNA_n103 n103 d25 m_n103 gn1 sg13_lv_nmos w=0.74u l=0.13u
XNB_n103 m_n103 dn31 gn1 gn1 sg13_lv_nmos w=0.74u l=0.13u
CL_n103 n103 gn1 2f
XPA_n1033 n1033 s1 ph1 ph1 sg13_lv_pmos w=1.12u l=0.13u
XPB_n1033 n1033 sn2 ph1 ph1 sg13_lv_pmos w=1.12u l=0.13u
XNA_n1033 n1033 s1 m_n1033 gn1 sg13_lv_nmos w=0.74u l=0.13u
XNB_n1033 m_n1033 sn2 gn1 gn1 sg13_lv_nmos w=0.74u l=0.13u
CL_n1033 n1033 gn1 2f
XPA_n1034 n1034 sn1 ph1 ph1 sg13_lv_pmos w=1.12u l=0.13u
XPB_n1034 n1034 s2 ph1 ph1 sg13_lv_pmos w=1.12u l=0.13u
XNA_n1034 n1034 sn1 m_n1034 gn1 sg13_lv_nmos w=0.74u l=0.13u
XNB_n1034 m_n1034 s2 gn1 gn1 sg13_lv_nmos w=0.74u l=0.13u
CL_n1034 n1034 gn1 2f
XPA_n1036 n1036 s1 ph1 ph1 sg13_lv_pmos w=1.12u l=0.13u
XPB_n1036 n1036 s2 ph1 ph1 sg13_lv_pmos w=1.12u l=0.13u
XNA_n1036 n1036 s1 m_n1036 gn1 sg13_lv_nmos w=0.74u l=0.13u
XNB_n1036 m_n1036 s2 gn1 gn1 sg13_lv_nmos w=0.74u l=0.13u
CL_n1036 n1036 gn1 2f
XPA_n1037 n1037 sn1 ph1 ph1 sg13_lv_pmos w=1.12u l=0.13u
XPB_n1037 n1037 sn2 ph1 ph1 sg13_lv_pmos w=1.12u l=0.13u
XNA_n1037 n1037 sn1 m_n1037 gn1 sg13_lv_nmos w=0.74u l=0.13u
XNB_n1037 m_n1037 sn2 gn1 gn1 sg13_lv_nmos w=0.74u l=0.13u
CL_n1037 n1037 gn1 2f
XPA_n1039 n1039 s4 ph1 ph1 sg13_lv_pmos w=1.12u l=0.13u
XPB_n1039 n1039 sn5 ph1 ph1 sg13_lv_pmos w=1.12u l=0.13u
XNA_n1039 n1039 s4 m_n1039 gn1 sg13_lv_nmos w=0.74u l=0.13u
XNB_n1039 m_n1039 sn5 gn1 gn1 sg13_lv_nmos w=0.74u l=0.13u
CL_n1039 n1039 gn1 2f
XPA_n104 n104 dn25 ph1 ph1 sg13_lv_pmos w=1.12u l=0.13u
XPB_n104 n104 d31 ph1 ph1 sg13_lv_pmos w=1.12u l=0.13u
XNA_n104 n104 dn25 m_n104 gn1 sg13_lv_nmos w=0.74u l=0.13u
XNB_n104 m_n104 d31 gn1 gn1 sg13_lv_nmos w=0.74u l=0.13u
CL_n104 n104 gn1 2f
XPA_n1040 n1040 sn4 ph1 ph1 sg13_lv_pmos w=1.12u l=0.13u
XPB_n1040 n1040 s5 ph1 ph1 sg13_lv_pmos w=1.12u l=0.13u
XNA_n1040 n1040 sn4 m_n1040 gn1 sg13_lv_nmos w=0.74u l=0.13u
XNB_n1040 m_n1040 s5 gn1 gn1 sg13_lv_nmos w=0.74u l=0.13u
CL_n1040 n1040 gn1 2f
XPA_n1042 n1042 s4 ph1 ph1 sg13_lv_pmos w=1.12u l=0.13u
XPB_n1042 n1042 s5 ph1 ph1 sg13_lv_pmos w=1.12u l=0.13u
XNA_n1042 n1042 s4 m_n1042 gn1 sg13_lv_nmos w=0.74u l=0.13u
XNB_n1042 m_n1042 s5 gn1 gn1 sg13_lv_nmos w=0.74u l=0.13u
CL_n1042 n1042 gn1 2f
XPA_n1043 n1043 sn4 ph1 ph1 sg13_lv_pmos w=1.12u l=0.13u
XPB_n1043 n1043 sn5 ph1 ph1 sg13_lv_pmos w=1.12u l=0.13u
XNA_n1043 n1043 sn4 m_n1043 gn1 sg13_lv_nmos w=0.74u l=0.13u
XNB_n1043 m_n1043 sn5 gn1 gn1 sg13_lv_nmos w=0.74u l=0.13u
CL_n1043 n1043 gn1 2f
XPA_n1045 n1045 s6 ph1 ph1 sg13_lv_pmos w=1.12u l=0.13u
XPB_n1045 n1045 sn7 ph1 ph1 sg13_lv_pmos w=1.12u l=0.13u
XNA_n1045 n1045 s6 m_n1045 gn1 sg13_lv_nmos w=0.74u l=0.13u
XNB_n1045 m_n1045 sn7 gn1 gn1 sg13_lv_nmos w=0.74u l=0.13u
CL_n1045 n1045 gn1 2f
XPA_n1046 n1046 sn6 ph1 ph1 sg13_lv_pmos w=1.12u l=0.13u
XPB_n1046 n1046 s7 ph1 ph1 sg13_lv_pmos w=1.12u l=0.13u
XNA_n1046 n1046 sn6 m_n1046 gn1 sg13_lv_nmos w=0.74u l=0.13u
XNB_n1046 m_n1046 s7 gn1 gn1 sg13_lv_nmos w=0.74u l=0.13u
CL_n1046 n1046 gn1 2f
XPA_n1048 n1048 s6 ph1 ph1 sg13_lv_pmos w=1.12u l=0.13u
XPB_n1048 n1048 s7 ph1 ph1 sg13_lv_pmos w=1.12u l=0.13u
XNA_n1048 n1048 s6 m_n1048 gn1 sg13_lv_nmos w=0.74u l=0.13u
XNB_n1048 m_n1048 s7 gn1 gn1 sg13_lv_nmos w=0.74u l=0.13u
CL_n1048 n1048 gn1 2f
XPA_n1049 n1049 sn6 ph1 ph1 sg13_lv_pmos w=1.12u l=0.13u
XPB_n1049 n1049 sn7 ph1 ph1 sg13_lv_pmos w=1.12u l=0.13u
XNA_n1049 n1049 sn6 m_n1049 gn1 sg13_lv_nmos w=0.74u l=0.13u
XNB_n1049 m_n1049 sn7 gn1 gn1 sg13_lv_nmos w=0.74u l=0.13u
CL_n1049 n1049 gn1 2f
XPA_n1051 n1051 s8 ph1 ph1 sg13_lv_pmos w=1.12u l=0.13u
XPB_n1051 n1051 sn11 ph1 ph1 sg13_lv_pmos w=1.12u l=0.13u
XNA_n1051 n1051 s8 m_n1051 gn1 sg13_lv_nmos w=0.74u l=0.13u
XNB_n1051 m_n1051 sn11 gn1 gn1 sg13_lv_nmos w=0.74u l=0.13u
CL_n1051 n1051 gn1 2f
XPA_n1052 n1052 sn8 ph1 ph1 sg13_lv_pmos w=1.12u l=0.13u
XPB_n1052 n1052 s11 ph1 ph1 sg13_lv_pmos w=1.12u l=0.13u
XNA_n1052 n1052 sn8 m_n1052 gn1 sg13_lv_nmos w=0.74u l=0.13u
XNB_n1052 m_n1052 s11 gn1 gn1 sg13_lv_nmos w=0.74u l=0.13u
CL_n1052 n1052 gn1 2f
XPA_n1054 n1054 s8 ph1 ph1 sg13_lv_pmos w=1.12u l=0.13u
XPB_n1054 n1054 s11 ph1 ph1 sg13_lv_pmos w=1.12u l=0.13u
XNA_n1054 n1054 s8 m_n1054 gn1 sg13_lv_nmos w=0.74u l=0.13u
XNB_n1054 m_n1054 s11 gn1 gn1 sg13_lv_nmos w=0.74u l=0.13u
CL_n1054 n1054 gn1 2f
XPA_n1055 n1055 sn8 ph1 ph1 sg13_lv_pmos w=1.12u l=0.13u
XPB_n1055 n1055 sn11 ph1 ph1 sg13_lv_pmos w=1.12u l=0.13u
XNA_n1055 n1055 sn8 m_n1055 gn1 sg13_lv_nmos w=0.74u l=0.13u
XNB_n1055 m_n1055 sn11 gn1 gn1 sg13_lv_nmos w=0.74u l=0.13u
CL_n1055 n1055 gn1 2f
XPA_n1057 n1057 s14 ph1 ph1 sg13_lv_pmos w=1.12u l=0.13u
XPB_n1057 n1057 sn20 ph1 ph1 sg13_lv_pmos w=1.12u l=0.13u
XNA_n1057 n1057 s14 m_n1057 gn1 sg13_lv_nmos w=0.74u l=0.13u
XNB_n1057 m_n1057 sn20 gn1 gn1 sg13_lv_nmos w=0.74u l=0.13u
CL_n1057 n1057 gn1 2f
XPA_n1058 n1058 sn14 ph1 ph1 sg13_lv_pmos w=1.12u l=0.13u
XPB_n1058 n1058 s20 ph1 ph1 sg13_lv_pmos w=1.12u l=0.13u
XNA_n1058 n1058 sn14 m_n1058 gn1 sg13_lv_nmos w=0.74u l=0.13u
XNB_n1058 m_n1058 s20 gn1 gn1 sg13_lv_nmos w=0.74u l=0.13u
CL_n1058 n1058 gn1 2f
XPA_n106 n106 d25 ph1 ph1 sg13_lv_pmos w=1.12u l=0.13u
XPB_n106 n106 d31 ph1 ph1 sg13_lv_pmos w=1.12u l=0.13u
XNA_n106 n106 d25 m_n106 gn1 sg13_lv_nmos w=0.74u l=0.13u
XNB_n106 m_n106 d31 gn1 gn1 sg13_lv_nmos w=0.74u l=0.13u
CL_n106 n106 gn1 2f
XPA_n1060 n1060 s14 ph1 ph1 sg13_lv_pmos w=1.12u l=0.13u
XPB_n1060 n1060 s20 ph1 ph1 sg13_lv_pmos w=1.12u l=0.13u
XNA_n1060 n1060 s14 m_n1060 gn1 sg13_lv_nmos w=0.74u l=0.13u
XNB_n1060 m_n1060 s20 gn1 gn1 sg13_lv_nmos w=0.74u l=0.13u
CL_n1060 n1060 gn1 2f
XPA_n1061 n1061 sn14 ph1 ph1 sg13_lv_pmos w=1.12u l=0.13u
XPB_n1061 n1061 sn20 ph1 ph1 sg13_lv_pmos w=1.12u l=0.13u
XNA_n1061 n1061 sn14 m_n1061 gn1 sg13_lv_nmos w=0.74u l=0.13u
XNB_n1061 m_n1061 sn20 gn1 gn1 sg13_lv_nmos w=0.74u l=0.13u
CL_n1061 n1061 gn1 2f
XPA_n1063 n1063 s21 ph1 ph1 sg13_lv_pmos w=1.12u l=0.13u
XPB_n1063 n1063 sn22 ph1 ph1 sg13_lv_pmos w=1.12u l=0.13u
XNA_n1063 n1063 s21 m_n1063 gn1 sg13_lv_nmos w=0.74u l=0.13u
XNB_n1063 m_n1063 sn22 gn1 gn1 sg13_lv_nmos w=0.74u l=0.13u
CL_n1063 n1063 gn1 2f
XPA_n1064 n1064 sn21 ph1 ph1 sg13_lv_pmos w=1.12u l=0.13u
XPB_n1064 n1064 s22 ph1 ph1 sg13_lv_pmos w=1.12u l=0.13u
XNA_n1064 n1064 sn21 m_n1064 gn1 sg13_lv_nmos w=0.74u l=0.13u
XNB_n1064 m_n1064 s22 gn1 gn1 sg13_lv_nmos w=0.74u l=0.13u
CL_n1064 n1064 gn1 2f
XPA_n1066 n1066 s21 ph1 ph1 sg13_lv_pmos w=1.12u l=0.13u
XPB_n1066 n1066 s22 ph1 ph1 sg13_lv_pmos w=1.12u l=0.13u
XNA_n1066 n1066 s21 m_n1066 gn1 sg13_lv_nmos w=0.74u l=0.13u
XNB_n1066 m_n1066 s22 gn1 gn1 sg13_lv_nmos w=0.74u l=0.13u
CL_n1066 n1066 gn1 2f
XPA_n1067 n1067 sn21 ph1 ph1 sg13_lv_pmos w=1.12u l=0.13u
XPB_n1067 n1067 sn22 ph1 ph1 sg13_lv_pmos w=1.12u l=0.13u
XNA_n1067 n1067 sn21 m_n1067 gn1 sg13_lv_nmos w=0.74u l=0.13u
XNB_n1067 m_n1067 sn22 gn1 gn1 sg13_lv_nmos w=0.74u l=0.13u
CL_n1067 n1067 gn1 2f
XPA_n1069 n1069 s25 ph1 ph1 sg13_lv_pmos w=1.12u l=0.13u
XPB_n1069 n1069 sn29 ph1 ph1 sg13_lv_pmos w=1.12u l=0.13u
XNA_n1069 n1069 s25 m_n1069 gn1 sg13_lv_nmos w=0.74u l=0.13u
XNB_n1069 m_n1069 sn29 gn1 gn1 sg13_lv_nmos w=0.74u l=0.13u
CL_n1069 n1069 gn1 2f
XPA_n107 n107 dn25 ph1 ph1 sg13_lv_pmos w=1.12u l=0.13u
XPB_n107 n107 dn31 ph1 ph1 sg13_lv_pmos w=1.12u l=0.13u
XNA_n107 n107 dn25 m_n107 gn1 sg13_lv_nmos w=0.74u l=0.13u
XNB_n107 m_n107 dn31 gn1 gn1 sg13_lv_nmos w=0.74u l=0.13u
CL_n107 n107 gn1 2f
XPA_n1070 n1070 sn25 ph1 ph1 sg13_lv_pmos w=1.12u l=0.13u
XPB_n1070 n1070 s29 ph1 ph1 sg13_lv_pmos w=1.12u l=0.13u
XNA_n1070 n1070 sn25 m_n1070 gn1 sg13_lv_nmos w=0.74u l=0.13u
XNB_n1070 m_n1070 s29 gn1 gn1 sg13_lv_nmos w=0.74u l=0.13u
CL_n1070 n1070 gn1 2f
XPA_n1072 n1072 s25 ph1 ph1 sg13_lv_pmos w=1.12u l=0.13u
XPB_n1072 n1072 s29 ph1 ph1 sg13_lv_pmos w=1.12u l=0.13u
XNA_n1072 n1072 s25 m_n1072 gn1 sg13_lv_nmos w=0.74u l=0.13u
XNB_n1072 m_n1072 s29 gn1 gn1 sg13_lv_nmos w=0.74u l=0.13u
CL_n1072 n1072 gn1 2f
XPA_n1073 n1073 sn25 ph1 ph1 sg13_lv_pmos w=1.12u l=0.13u
XPB_n1073 n1073 sn29 ph1 ph1 sg13_lv_pmos w=1.12u l=0.13u
XNA_n1073 n1073 sn25 m_n1073 gn1 sg13_lv_nmos w=0.74u l=0.13u
XNB_n1073 m_n1073 sn29 gn1 gn1 sg13_lv_nmos w=0.74u l=0.13u
CL_n1073 n1073 gn1 2f
XPA_n1075 n1075 s30 ph1 ph1 sg13_lv_pmos w=1.12u l=0.13u
XPB_n1075 n1075 dn1 ph1 ph1 sg13_lv_pmos w=1.12u l=0.13u
XNA_n1075 n1075 s30 m_n1075 gn1 sg13_lv_nmos w=0.74u l=0.13u
XNB_n1075 m_n1075 dn1 gn1 gn1 sg13_lv_nmos w=0.74u l=0.13u
CL_n1075 n1075 gn1 2f
XPA_n1076 n1076 sn30 ph1 ph1 sg13_lv_pmos w=1.12u l=0.13u
XPB_n1076 n1076 d1 ph1 ph1 sg13_lv_pmos w=1.12u l=0.13u
XNA_n1076 n1076 sn30 m_n1076 gn1 sg13_lv_nmos w=0.74u l=0.13u
XNB_n1076 m_n1076 d1 gn1 gn1 sg13_lv_nmos w=0.74u l=0.13u
CL_n1076 n1076 gn1 2f
XPA_n1078 n1078 s30 ph1 ph1 sg13_lv_pmos w=1.12u l=0.13u
XPB_n1078 n1078 d1 ph1 ph1 sg13_lv_pmos w=1.12u l=0.13u
XNA_n1078 n1078 s30 m_n1078 gn1 sg13_lv_nmos w=0.74u l=0.13u
XNB_n1078 m_n1078 d1 gn1 gn1 sg13_lv_nmos w=0.74u l=0.13u
CL_n1078 n1078 gn1 2f
XPA_n1079 n1079 sn30 ph1 ph1 sg13_lv_pmos w=1.12u l=0.13u
XPB_n1079 n1079 dn1 ph1 ph1 sg13_lv_pmos w=1.12u l=0.13u
XNA_n1079 n1079 sn30 m_n1079 gn1 sg13_lv_nmos w=0.74u l=0.13u
XNB_n1079 m_n1079 dn1 gn1 gn1 sg13_lv_nmos w=0.74u l=0.13u
CL_n1079 n1079 gn1 2f
XPA_n1081 n1081 d2 ph1 ph1 sg13_lv_pmos w=1.12u l=0.13u
XPB_n1081 n1081 dn6 ph1 ph1 sg13_lv_pmos w=1.12u l=0.13u
XNA_n1081 n1081 d2 m_n1081 gn1 sg13_lv_nmos w=0.74u l=0.13u
XNB_n1081 m_n1081 dn6 gn1 gn1 sg13_lv_nmos w=0.74u l=0.13u
CL_n1081 n1081 gn1 2f
XPA_n1082 n1082 dn2 ph1 ph1 sg13_lv_pmos w=1.12u l=0.13u
XPB_n1082 n1082 d6 ph1 ph1 sg13_lv_pmos w=1.12u l=0.13u
XNA_n1082 n1082 dn2 m_n1082 gn1 sg13_lv_nmos w=0.74u l=0.13u
XNB_n1082 m_n1082 d6 gn1 gn1 sg13_lv_nmos w=0.74u l=0.13u
CL_n1082 n1082 gn1 2f
XPA_n1084 n1084 d2 ph1 ph1 sg13_lv_pmos w=1.12u l=0.13u
XPB_n1084 n1084 d6 ph1 ph1 sg13_lv_pmos w=1.12u l=0.13u
XNA_n1084 n1084 d2 m_n1084 gn1 sg13_lv_nmos w=0.74u l=0.13u
XNB_n1084 m_n1084 d6 gn1 gn1 sg13_lv_nmos w=0.74u l=0.13u
CL_n1084 n1084 gn1 2f
XPA_n1085 n1085 dn2 ph1 ph1 sg13_lv_pmos w=1.12u l=0.13u
XPB_n1085 n1085 dn6 ph1 ph1 sg13_lv_pmos w=1.12u l=0.13u
XNA_n1085 n1085 dn2 m_n1085 gn1 sg13_lv_nmos w=0.74u l=0.13u
XNB_n1085 m_n1085 dn6 gn1 gn1 sg13_lv_nmos w=0.74u l=0.13u
CL_n1085 n1085 gn1 2f
XPA_n1087 n1087 d9 ph1 ph1 sg13_lv_pmos w=1.12u l=0.13u
XPB_n1087 n1087 dn10 ph1 ph1 sg13_lv_pmos w=1.12u l=0.13u
XNA_n1087 n1087 d9 m_n1087 gn1 sg13_lv_nmos w=0.74u l=0.13u
XNB_n1087 m_n1087 dn10 gn1 gn1 sg13_lv_nmos w=0.74u l=0.13u
CL_n1087 n1087 gn1 2f
XPA_n1088 n1088 dn9 ph1 ph1 sg13_lv_pmos w=1.12u l=0.13u
XPB_n1088 n1088 d10 ph1 ph1 sg13_lv_pmos w=1.12u l=0.13u
XNA_n1088 n1088 dn9 m_n1088 gn1 sg13_lv_nmos w=0.74u l=0.13u
XNB_n1088 m_n1088 d10 gn1 gn1 sg13_lv_nmos w=0.74u l=0.13u
CL_n1088 n1088 gn1 2f
XPA_n1090 n1090 d9 ph1 ph1 sg13_lv_pmos w=1.12u l=0.13u
XPB_n1090 n1090 d10 ph1 ph1 sg13_lv_pmos w=1.12u l=0.13u
XNA_n1090 n1090 d9 m_n1090 gn1 sg13_lv_nmos w=0.74u l=0.13u
XNB_n1090 m_n1090 d10 gn1 gn1 sg13_lv_nmos w=0.74u l=0.13u
CL_n1090 n1090 gn1 2f
XPA_n1091 n1091 dn9 ph1 ph1 sg13_lv_pmos w=1.12u l=0.13u
XPB_n1091 n1091 dn10 ph1 ph1 sg13_lv_pmos w=1.12u l=0.13u
XNA_n1091 n1091 dn9 m_n1091 gn1 sg13_lv_nmos w=0.74u l=0.13u
XNB_n1091 m_n1091 dn10 gn1 gn1 sg13_lv_nmos w=0.74u l=0.13u
CL_n1091 n1091 gn1 2f
XPA_n1093 n1093 d11 ph1 ph1 sg13_lv_pmos w=1.12u l=0.13u
XPB_n1093 n1093 dn17 ph1 ph1 sg13_lv_pmos w=1.12u l=0.13u
XNA_n1093 n1093 d11 m_n1093 gn1 sg13_lv_nmos w=0.74u l=0.13u
XNB_n1093 m_n1093 dn17 gn1 gn1 sg13_lv_nmos w=0.74u l=0.13u
CL_n1093 n1093 gn1 2f
XPA_n1094 n1094 dn11 ph1 ph1 sg13_lv_pmos w=1.12u l=0.13u
XPB_n1094 n1094 d17 ph1 ph1 sg13_lv_pmos w=1.12u l=0.13u
XNA_n1094 n1094 dn11 m_n1094 gn1 sg13_lv_nmos w=0.74u l=0.13u
XNB_n1094 m_n1094 d17 gn1 gn1 sg13_lv_nmos w=0.74u l=0.13u
CL_n1094 n1094 gn1 2f
XPA_n1096 n1096 d11 ph1 ph1 sg13_lv_pmos w=1.12u l=0.13u
XPB_n1096 n1096 d17 ph1 ph1 sg13_lv_pmos w=1.12u l=0.13u
XNA_n1096 n1096 d11 m_n1096 gn1 sg13_lv_nmos w=0.74u l=0.13u
XNB_n1096 m_n1096 d17 gn1 gn1 sg13_lv_nmos w=0.74u l=0.13u
CL_n1096 n1096 gn1 2f
XPA_n1097 n1097 dn11 ph1 ph1 sg13_lv_pmos w=1.12u l=0.13u
XPB_n1097 n1097 dn17 ph1 ph1 sg13_lv_pmos w=1.12u l=0.13u
XNA_n1097 n1097 dn11 m_n1097 gn1 sg13_lv_nmos w=0.74u l=0.13u
XNB_n1097 m_n1097 dn17 gn1 gn1 sg13_lv_nmos w=0.74u l=0.13u
CL_n1097 n1097 gn1 2f
XPA_n1099 n1099 d20 ph1 ph1 sg13_lv_pmos w=1.12u l=0.13u
XPB_n1099 n1099 dn23 ph1 ph1 sg13_lv_pmos w=1.12u l=0.13u
XNA_n1099 n1099 d20 m_n1099 gn1 sg13_lv_nmos w=0.74u l=0.13u
XNB_n1099 m_n1099 dn23 gn1 gn1 sg13_lv_nmos w=0.74u l=0.13u
CL_n1099 n1099 gn1 2f
XPA_n11 n11 sn9 ph1 ph1 sg13_lv_pmos w=1.12u l=0.13u
XPB_n11 n11 sn10 ph1 ph1 sg13_lv_pmos w=1.12u l=0.13u
XNA_n11 n11 sn9 m_n11 gn1 sg13_lv_nmos w=0.74u l=0.13u
XNB_n11 m_n11 sn10 gn1 gn1 sg13_lv_nmos w=0.74u l=0.13u
CL_n11 n11 gn1 2f
XPA_n1100 n1100 dn20 ph1 ph1 sg13_lv_pmos w=1.12u l=0.13u
XPB_n1100 n1100 d23 ph1 ph1 sg13_lv_pmos w=1.12u l=0.13u
XNA_n1100 n1100 dn20 m_n1100 gn1 sg13_lv_nmos w=0.74u l=0.13u
XNB_n1100 m_n1100 d23 gn1 gn1 sg13_lv_nmos w=0.74u l=0.13u
CL_n1100 n1100 gn1 2f
XPA_n1102 n1102 d20 ph1 ph1 sg13_lv_pmos w=1.12u l=0.13u
XPB_n1102 n1102 d23 ph1 ph1 sg13_lv_pmos w=1.12u l=0.13u
XNA_n1102 n1102 d20 m_n1102 gn1 sg13_lv_nmos w=0.74u l=0.13u
XNB_n1102 m_n1102 d23 gn1 gn1 sg13_lv_nmos w=0.74u l=0.13u
CL_n1102 n1102 gn1 2f
XPA_n1103 n1103 dn20 ph1 ph1 sg13_lv_pmos w=1.12u l=0.13u
XPB_n1103 n1103 dn23 ph1 ph1 sg13_lv_pmos w=1.12u l=0.13u
XNA_n1103 n1103 dn20 m_n1103 gn1 sg13_lv_nmos w=0.74u l=0.13u
XNB_n1103 m_n1103 dn23 gn1 gn1 sg13_lv_nmos w=0.74u l=0.13u
CL_n1103 n1103 gn1 2f
XPA_n1105 n1105 d24 ph1 ph1 sg13_lv_pmos w=1.12u l=0.13u
XPB_n1105 n1105 dn25 ph1 ph1 sg13_lv_pmos w=1.12u l=0.13u
XNA_n1105 n1105 d24 m_n1105 gn1 sg13_lv_nmos w=0.74u l=0.13u
XNB_n1105 m_n1105 dn25 gn1 gn1 sg13_lv_nmos w=0.74u l=0.13u
CL_n1105 n1105 gn1 2f
XPA_n1106 n1106 dn24 ph1 ph1 sg13_lv_pmos w=1.12u l=0.13u
XPB_n1106 n1106 d25 ph1 ph1 sg13_lv_pmos w=1.12u l=0.13u
XNA_n1106 n1106 dn24 m_n1106 gn1 sg13_lv_nmos w=0.74u l=0.13u
XNB_n1106 m_n1106 d25 gn1 gn1 sg13_lv_nmos w=0.74u l=0.13u
CL_n1106 n1106 gn1 2f
XPA_n1108 n1108 d24 ph1 ph1 sg13_lv_pmos w=1.12u l=0.13u
XPB_n1108 n1108 d25 ph1 ph1 sg13_lv_pmos w=1.12u l=0.13u
XNA_n1108 n1108 d24 m_n1108 gn1 sg13_lv_nmos w=0.74u l=0.13u
XNB_n1108 m_n1108 d25 gn1 gn1 sg13_lv_nmos w=0.74u l=0.13u
CL_n1108 n1108 gn1 2f
XPA_n1109 n1109 dn24 ph1 ph1 sg13_lv_pmos w=1.12u l=0.13u
XPB_n1109 n1109 dn25 ph1 ph1 sg13_lv_pmos w=1.12u l=0.13u
XNA_n1109 n1109 dn24 m_n1109 gn1 sg13_lv_nmos w=0.74u l=0.13u
XNB_n1109 m_n1109 dn25 gn1 gn1 sg13_lv_nmos w=0.74u l=0.13u
CL_n1109 n1109 gn1 2f
XPA_n1111 n1111 d26 ph1 ph1 sg13_lv_pmos w=1.12u l=0.13u
XPB_n1111 n1111 dn27 ph1 ph1 sg13_lv_pmos w=1.12u l=0.13u
XNA_n1111 n1111 d26 m_n1111 gn1 sg13_lv_nmos w=0.74u l=0.13u
XNB_n1111 m_n1111 dn27 gn1 gn1 sg13_lv_nmos w=0.74u l=0.13u
CL_n1111 n1111 gn1 2f
XPA_n1112 n1112 dn26 ph1 ph1 sg13_lv_pmos w=1.12u l=0.13u
XPB_n1112 n1112 d27 ph1 ph1 sg13_lv_pmos w=1.12u l=0.13u
XNA_n1112 n1112 dn26 m_n1112 gn1 sg13_lv_nmos w=0.74u l=0.13u
XNB_n1112 m_n1112 d27 gn1 gn1 sg13_lv_nmos w=0.74u l=0.13u
CL_n1112 n1112 gn1 2f
XPA_n1114 n1114 d26 ph1 ph1 sg13_lv_pmos w=1.12u l=0.13u
XPB_n1114 n1114 d27 ph1 ph1 sg13_lv_pmos w=1.12u l=0.13u
XNA_n1114 n1114 d26 m_n1114 gn1 sg13_lv_nmos w=0.74u l=0.13u
XNB_n1114 m_n1114 d27 gn1 gn1 sg13_lv_nmos w=0.74u l=0.13u
CL_n1114 n1114 gn1 2f
XPA_n1115 n1115 dn26 ph1 ph1 sg13_lv_pmos w=1.12u l=0.13u
XPB_n1115 n1115 dn27 ph1 ph1 sg13_lv_pmos w=1.12u l=0.13u
XNA_n1115 n1115 dn26 m_n1115 gn1 sg13_lv_nmos w=0.74u l=0.13u
XNB_n1115 m_n1115 dn27 gn1 gn1 sg13_lv_nmos w=0.74u l=0.13u
CL_n1115 n1115 gn1 2f
XPA_n1159 n1159 d29 ph1 ph1 sg13_lv_pmos w=1.12u l=0.13u
XPB_n1159 n1159 dn30 ph1 ph1 sg13_lv_pmos w=1.12u l=0.13u
XNA_n1159 n1159 d29 m_n1159 gn1 sg13_lv_nmos w=0.74u l=0.13u
XNB_n1159 m_n1159 dn30 gn1 gn1 sg13_lv_nmos w=0.74u l=0.13u
CL_n1159 n1159 gn1 2f
XPA_n1160 n1160 dn29 ph1 ph1 sg13_lv_pmos w=1.12u l=0.13u
XPB_n1160 n1160 d30 ph1 ph1 sg13_lv_pmos w=1.12u l=0.13u
XNA_n1160 n1160 dn29 m_n1160 gn1 sg13_lv_nmos w=0.74u l=0.13u
XNB_n1160 m_n1160 d30 gn1 gn1 sg13_lv_nmos w=0.74u l=0.13u
CL_n1160 n1160 gn1 2f
XPA_n1162 n1162 d29 ph1 ph1 sg13_lv_pmos w=1.12u l=0.13u
XPB_n1162 n1162 d30 ph1 ph1 sg13_lv_pmos w=1.12u l=0.13u
XNA_n1162 n1162 d29 m_n1162 gn1 sg13_lv_nmos w=0.74u l=0.13u
XNB_n1162 m_n1162 d30 gn1 gn1 sg13_lv_nmos w=0.74u l=0.13u
CL_n1162 n1162 gn1 2f
XPA_n1163 n1163 dn29 ph1 ph1 sg13_lv_pmos w=1.12u l=0.13u
XPB_n1163 n1163 dn30 ph1 ph1 sg13_lv_pmos w=1.12u l=0.13u
XNA_n1163 n1163 dn29 m_n1163 gn1 sg13_lv_nmos w=0.74u l=0.13u
XNB_n1163 m_n1163 dn30 gn1 gn1 sg13_lv_nmos w=0.74u l=0.13u
CL_n1163 n1163 gn1 2f
XPA_n1207 n1207 s0 ph1 ph1 sg13_lv_pmos w=1.12u l=0.13u
XPB_n1207 n1207 sn2 ph1 ph1 sg13_lv_pmos w=1.12u l=0.13u
XNA_n1207 n1207 s0 m_n1207 gn1 sg13_lv_nmos w=0.74u l=0.13u
XNB_n1207 m_n1207 sn2 gn1 gn1 sg13_lv_nmos w=0.74u l=0.13u
CL_n1207 n1207 gn1 2f
XPA_n1208 n1208 sn0 ph1 ph1 sg13_lv_pmos w=1.12u l=0.13u
XPB_n1208 n1208 s2 ph1 ph1 sg13_lv_pmos w=1.12u l=0.13u
XNA_n1208 n1208 sn0 m_n1208 gn1 sg13_lv_nmos w=0.74u l=0.13u
XNB_n1208 m_n1208 s2 gn1 gn1 sg13_lv_nmos w=0.74u l=0.13u
CL_n1208 n1208 gn1 2f
XPA_n1210 n1210 s0 ph1 ph1 sg13_lv_pmos w=1.12u l=0.13u
XPB_n1210 n1210 s2 ph1 ph1 sg13_lv_pmos w=1.12u l=0.13u
XNA_n1210 n1210 s0 m_n1210 gn1 sg13_lv_nmos w=0.74u l=0.13u
XNB_n1210 m_n1210 s2 gn1 gn1 sg13_lv_nmos w=0.74u l=0.13u
CL_n1210 n1210 gn1 2f
XPA_n1211 n1211 sn0 ph1 ph1 sg13_lv_pmos w=1.12u l=0.13u
XPB_n1211 n1211 sn2 ph1 ph1 sg13_lv_pmos w=1.12u l=0.13u
XNA_n1211 n1211 sn0 m_n1211 gn1 sg13_lv_nmos w=0.74u l=0.13u
XNB_n1211 m_n1211 sn2 gn1 gn1 sg13_lv_nmos w=0.74u l=0.13u
CL_n1211 n1211 gn1 2f
XPA_n1213 n1213 s3 ph1 ph1 sg13_lv_pmos w=1.12u l=0.13u
XPB_n1213 n1213 sn5 ph1 ph1 sg13_lv_pmos w=1.12u l=0.13u
XNA_n1213 n1213 s3 m_n1213 gn1 sg13_lv_nmos w=0.74u l=0.13u
XNB_n1213 m_n1213 sn5 gn1 gn1 sg13_lv_nmos w=0.74u l=0.13u
CL_n1213 n1213 gn1 2f
XPA_n1214 n1214 sn3 ph1 ph1 sg13_lv_pmos w=1.12u l=0.13u
XPB_n1214 n1214 s5 ph1 ph1 sg13_lv_pmos w=1.12u l=0.13u
XNA_n1214 n1214 sn3 m_n1214 gn1 sg13_lv_nmos w=0.74u l=0.13u
XNB_n1214 m_n1214 s5 gn1 gn1 sg13_lv_nmos w=0.74u l=0.13u
CL_n1214 n1214 gn1 2f
XPA_n1216 n1216 s3 ph1 ph1 sg13_lv_pmos w=1.12u l=0.13u
XPB_n1216 n1216 s5 ph1 ph1 sg13_lv_pmos w=1.12u l=0.13u
XNA_n1216 n1216 s3 m_n1216 gn1 sg13_lv_nmos w=0.74u l=0.13u
XNB_n1216 m_n1216 s5 gn1 gn1 sg13_lv_nmos w=0.74u l=0.13u
CL_n1216 n1216 gn1 2f
XPA_n1217 n1217 sn3 ph1 ph1 sg13_lv_pmos w=1.12u l=0.13u
XPB_n1217 n1217 sn5 ph1 ph1 sg13_lv_pmos w=1.12u l=0.13u
XNA_n1217 n1217 sn3 m_n1217 gn1 sg13_lv_nmos w=0.74u l=0.13u
XNB_n1217 m_n1217 sn5 gn1 gn1 sg13_lv_nmos w=0.74u l=0.13u
CL_n1217 n1217 gn1 2f
XPA_n1219 n1219 s7 ph1 ph1 sg13_lv_pmos w=1.12u l=0.13u
XPB_n1219 n1219 sn8 ph1 ph1 sg13_lv_pmos w=1.12u l=0.13u
XNA_n1219 n1219 s7 m_n1219 gn1 sg13_lv_nmos w=0.74u l=0.13u
XNB_n1219 m_n1219 sn8 gn1 gn1 sg13_lv_nmos w=0.74u l=0.13u
CL_n1219 n1219 gn1 2f
XPA_n1220 n1220 sn7 ph1 ph1 sg13_lv_pmos w=1.12u l=0.13u
XPB_n1220 n1220 s8 ph1 ph1 sg13_lv_pmos w=1.12u l=0.13u
XNA_n1220 n1220 sn7 m_n1220 gn1 sg13_lv_nmos w=0.74u l=0.13u
XNB_n1220 m_n1220 s8 gn1 gn1 sg13_lv_nmos w=0.74u l=0.13u
CL_n1220 n1220 gn1 2f
XPA_n1222 n1222 s7 ph1 ph1 sg13_lv_pmos w=1.12u l=0.13u
XPB_n1222 n1222 s8 ph1 ph1 sg13_lv_pmos w=1.12u l=0.13u
XNA_n1222 n1222 s7 m_n1222 gn1 sg13_lv_nmos w=0.74u l=0.13u
XNB_n1222 m_n1222 s8 gn1 gn1 sg13_lv_nmos w=0.74u l=0.13u
CL_n1222 n1222 gn1 2f
XPA_n1223 n1223 sn7 ph1 ph1 sg13_lv_pmos w=1.12u l=0.13u
XPB_n1223 n1223 sn8 ph1 ph1 sg13_lv_pmos w=1.12u l=0.13u
XNA_n1223 n1223 sn7 m_n1223 gn1 sg13_lv_nmos w=0.74u l=0.13u
XNB_n1223 m_n1223 sn8 gn1 gn1 sg13_lv_nmos w=0.74u l=0.13u
CL_n1223 n1223 gn1 2f
XPA_n1225 n1225 s10 ph1 ph1 sg13_lv_pmos w=1.12u l=0.13u
XPB_n1225 n1225 sn15 ph1 ph1 sg13_lv_pmos w=1.12u l=0.13u
XNA_n1225 n1225 s10 m_n1225 gn1 sg13_lv_nmos w=0.74u l=0.13u
XNB_n1225 m_n1225 sn15 gn1 gn1 sg13_lv_nmos w=0.74u l=0.13u
CL_n1225 n1225 gn1 2f
XPA_n1226 n1226 sn10 ph1 ph1 sg13_lv_pmos w=1.12u l=0.13u
XPB_n1226 n1226 s15 ph1 ph1 sg13_lv_pmos w=1.12u l=0.13u
XNA_n1226 n1226 sn10 m_n1226 gn1 sg13_lv_nmos w=0.74u l=0.13u
XNB_n1226 m_n1226 s15 gn1 gn1 sg13_lv_nmos w=0.74u l=0.13u
CL_n1226 n1226 gn1 2f
XPA_n1228 n1228 s10 ph1 ph1 sg13_lv_pmos w=1.12u l=0.13u
XPB_n1228 n1228 s15 ph1 ph1 sg13_lv_pmos w=1.12u l=0.13u
XNA_n1228 n1228 s10 m_n1228 gn1 sg13_lv_nmos w=0.74u l=0.13u
XNB_n1228 m_n1228 s15 gn1 gn1 sg13_lv_nmos w=0.74u l=0.13u
CL_n1228 n1228 gn1 2f
XPA_n1229 n1229 sn10 ph1 ph1 sg13_lv_pmos w=1.12u l=0.13u
XPB_n1229 n1229 sn15 ph1 ph1 sg13_lv_pmos w=1.12u l=0.13u
XNA_n1229 n1229 sn10 m_n1229 gn1 sg13_lv_nmos w=0.74u l=0.13u
XNB_n1229 m_n1229 sn15 gn1 gn1 sg13_lv_nmos w=0.74u l=0.13u
CL_n1229 n1229 gn1 2f
XPA_n1231 n1231 s16 ph1 ph1 sg13_lv_pmos w=1.12u l=0.13u
XPB_n1231 n1231 sn21 ph1 ph1 sg13_lv_pmos w=1.12u l=0.13u
XNA_n1231 n1231 s16 m_n1231 gn1 sg13_lv_nmos w=0.74u l=0.13u
XNB_n1231 m_n1231 sn21 gn1 gn1 sg13_lv_nmos w=0.74u l=0.13u
CL_n1231 n1231 gn1 2f
XPA_n1232 n1232 sn16 ph1 ph1 sg13_lv_pmos w=1.12u l=0.13u
XPB_n1232 n1232 s21 ph1 ph1 sg13_lv_pmos w=1.12u l=0.13u
XNA_n1232 n1232 sn16 m_n1232 gn1 sg13_lv_nmos w=0.74u l=0.13u
XNB_n1232 m_n1232 s21 gn1 gn1 sg13_lv_nmos w=0.74u l=0.13u
CL_n1232 n1232 gn1 2f
XPA_n1234 n1234 s16 ph1 ph1 sg13_lv_pmos w=1.12u l=0.13u
XPB_n1234 n1234 s21 ph1 ph1 sg13_lv_pmos w=1.12u l=0.13u
XNA_n1234 n1234 s16 m_n1234 gn1 sg13_lv_nmos w=0.74u l=0.13u
XNB_n1234 m_n1234 s21 gn1 gn1 sg13_lv_nmos w=0.74u l=0.13u
CL_n1234 n1234 gn1 2f
XPA_n1235 n1235 sn16 ph1 ph1 sg13_lv_pmos w=1.12u l=0.13u
XPB_n1235 n1235 sn21 ph1 ph1 sg13_lv_pmos w=1.12u l=0.13u
XNA_n1235 n1235 sn16 m_n1235 gn1 sg13_lv_nmos w=0.74u l=0.13u
XNB_n1235 m_n1235 sn21 gn1 gn1 sg13_lv_nmos w=0.74u l=0.13u
CL_n1235 n1235 gn1 2f
XPA_n1237 n1237 s22 ph1 ph1 sg13_lv_pmos w=1.12u l=0.13u
XPB_n1237 n1237 sn23 ph1 ph1 sg13_lv_pmos w=1.12u l=0.13u
XNA_n1237 n1237 s22 m_n1237 gn1 sg13_lv_nmos w=0.74u l=0.13u
XNB_n1237 m_n1237 sn23 gn1 gn1 sg13_lv_nmos w=0.74u l=0.13u
CL_n1237 n1237 gn1 2f
XPA_n1238 n1238 sn22 ph1 ph1 sg13_lv_pmos w=1.12u l=0.13u
XPB_n1238 n1238 s23 ph1 ph1 sg13_lv_pmos w=1.12u l=0.13u
XNA_n1238 n1238 sn22 m_n1238 gn1 sg13_lv_nmos w=0.74u l=0.13u
XNB_n1238 m_n1238 s23 gn1 gn1 sg13_lv_nmos w=0.74u l=0.13u
CL_n1238 n1238 gn1 2f
XPA_n1240 n1240 s22 ph1 ph1 sg13_lv_pmos w=1.12u l=0.13u
XPB_n1240 n1240 s23 ph1 ph1 sg13_lv_pmos w=1.12u l=0.13u
XNA_n1240 n1240 s22 m_n1240 gn1 sg13_lv_nmos w=0.74u l=0.13u
XNB_n1240 m_n1240 s23 gn1 gn1 sg13_lv_nmos w=0.74u l=0.13u
CL_n1240 n1240 gn1 2f
XPA_n1241 n1241 sn22 ph1 ph1 sg13_lv_pmos w=1.12u l=0.13u
XPB_n1241 n1241 sn23 ph1 ph1 sg13_lv_pmos w=1.12u l=0.13u
XNA_n1241 n1241 sn22 m_n1241 gn1 sg13_lv_nmos w=0.74u l=0.13u
XNB_n1241 m_n1241 sn23 gn1 gn1 sg13_lv_nmos w=0.74u l=0.13u
CL_n1241 n1241 gn1 2f
XPA_n1243 n1243 s24 ph1 ph1 sg13_lv_pmos w=1.12u l=0.13u
XPB_n1243 n1243 sn25 ph1 ph1 sg13_lv_pmos w=1.12u l=0.13u
XNA_n1243 n1243 s24 m_n1243 gn1 sg13_lv_nmos w=0.74u l=0.13u
XNB_n1243 m_n1243 sn25 gn1 gn1 sg13_lv_nmos w=0.74u l=0.13u
CL_n1243 n1243 gn1 2f
XPA_n1244 n1244 sn24 ph1 ph1 sg13_lv_pmos w=1.12u l=0.13u
XPB_n1244 n1244 s25 ph1 ph1 sg13_lv_pmos w=1.12u l=0.13u
XNA_n1244 n1244 sn24 m_n1244 gn1 sg13_lv_nmos w=0.74u l=0.13u
XNB_n1244 m_n1244 s25 gn1 gn1 sg13_lv_nmos w=0.74u l=0.13u
CL_n1244 n1244 gn1 2f
XPA_n1246 n1246 s24 ph1 ph1 sg13_lv_pmos w=1.12u l=0.13u
XPB_n1246 n1246 s25 ph1 ph1 sg13_lv_pmos w=1.12u l=0.13u
XNA_n1246 n1246 s24 m_n1246 gn1 sg13_lv_nmos w=0.74u l=0.13u
XNB_n1246 m_n1246 s25 gn1 gn1 sg13_lv_nmos w=0.74u l=0.13u
CL_n1246 n1246 gn1 2f
XPA_n1247 n1247 sn24 ph1 ph1 sg13_lv_pmos w=1.12u l=0.13u
XPB_n1247 n1247 sn25 ph1 ph1 sg13_lv_pmos w=1.12u l=0.13u
XNA_n1247 n1247 sn24 m_n1247 gn1 sg13_lv_nmos w=0.74u l=0.13u
XNB_n1247 m_n1247 sn25 gn1 gn1 sg13_lv_nmos w=0.74u l=0.13u
CL_n1247 n1247 gn1 2f
XPA_n1249 n1249 s28 ph1 ph1 sg13_lv_pmos w=1.12u l=0.13u
XPB_n1249 n1249 sn29 ph1 ph1 sg13_lv_pmos w=1.12u l=0.13u
XNA_n1249 n1249 s28 m_n1249 gn1 sg13_lv_nmos w=0.74u l=0.13u
XNB_n1249 m_n1249 sn29 gn1 gn1 sg13_lv_nmos w=0.74u l=0.13u
CL_n1249 n1249 gn1 2f
XPA_n1250 n1250 sn28 ph1 ph1 sg13_lv_pmos w=1.12u l=0.13u
XPB_n1250 n1250 s29 ph1 ph1 sg13_lv_pmos w=1.12u l=0.13u
XNA_n1250 n1250 sn28 m_n1250 gn1 sg13_lv_nmos w=0.74u l=0.13u
XNB_n1250 m_n1250 s29 gn1 gn1 sg13_lv_nmos w=0.74u l=0.13u
CL_n1250 n1250 gn1 2f
XPA_n1252 n1252 s28 ph1 ph1 sg13_lv_pmos w=1.12u l=0.13u
XPB_n1252 n1252 s29 ph1 ph1 sg13_lv_pmos w=1.12u l=0.13u
XNA_n1252 n1252 s28 m_n1252 gn1 sg13_lv_nmos w=0.74u l=0.13u
XNB_n1252 m_n1252 s29 gn1 gn1 sg13_lv_nmos w=0.74u l=0.13u
CL_n1252 n1252 gn1 2f
XPA_n1253 n1253 sn28 ph1 ph1 sg13_lv_pmos w=1.12u l=0.13u
XPB_n1253 n1253 sn29 ph1 ph1 sg13_lv_pmos w=1.12u l=0.13u
XNA_n1253 n1253 sn28 m_n1253 gn1 sg13_lv_nmos w=0.74u l=0.13u
XNB_n1253 m_n1253 sn29 gn1 gn1 sg13_lv_nmos w=0.74u l=0.13u
CL_n1253 n1253 gn1 2f
XPA_n1255 n1255 d2 ph1 ph1 sg13_lv_pmos w=1.12u l=0.13u
XPB_n1255 n1255 dn3 ph1 ph1 sg13_lv_pmos w=1.12u l=0.13u
XNA_n1255 n1255 d2 m_n1255 gn1 sg13_lv_nmos w=0.74u l=0.13u
XNB_n1255 m_n1255 dn3 gn1 gn1 sg13_lv_nmos w=0.74u l=0.13u
CL_n1255 n1255 gn1 2f
XPA_n1256 n1256 dn2 ph1 ph1 sg13_lv_pmos w=1.12u l=0.13u
XPB_n1256 n1256 d3 ph1 ph1 sg13_lv_pmos w=1.12u l=0.13u
XNA_n1256 n1256 dn2 m_n1256 gn1 sg13_lv_nmos w=0.74u l=0.13u
XNB_n1256 m_n1256 d3 gn1 gn1 sg13_lv_nmos w=0.74u l=0.13u
CL_n1256 n1256 gn1 2f
XPA_n1258 n1258 d2 ph1 ph1 sg13_lv_pmos w=1.12u l=0.13u
XPB_n1258 n1258 d3 ph1 ph1 sg13_lv_pmos w=1.12u l=0.13u
XNA_n1258 n1258 d2 m_n1258 gn1 sg13_lv_nmos w=0.74u l=0.13u
XNB_n1258 m_n1258 d3 gn1 gn1 sg13_lv_nmos w=0.74u l=0.13u
CL_n1258 n1258 gn1 2f
XPA_n1259 n1259 dn2 ph1 ph1 sg13_lv_pmos w=1.12u l=0.13u
XPB_n1259 n1259 dn3 ph1 ph1 sg13_lv_pmos w=1.12u l=0.13u
XNA_n1259 n1259 dn2 m_n1259 gn1 sg13_lv_nmos w=0.74u l=0.13u
XNB_n1259 m_n1259 dn3 gn1 gn1 sg13_lv_nmos w=0.74u l=0.13u
CL_n1259 n1259 gn1 2f
XPA_n1261 n1261 d6 ph1 ph1 sg13_lv_pmos w=1.12u l=0.13u
XPB_n1261 n1261 dn7 ph1 ph1 sg13_lv_pmos w=1.12u l=0.13u
XNA_n1261 n1261 d6 m_n1261 gn1 sg13_lv_nmos w=0.74u l=0.13u
XNB_n1261 m_n1261 dn7 gn1 gn1 sg13_lv_nmos w=0.74u l=0.13u
CL_n1261 n1261 gn1 2f
XPA_n1262 n1262 dn6 ph1 ph1 sg13_lv_pmos w=1.12u l=0.13u
XPB_n1262 n1262 d7 ph1 ph1 sg13_lv_pmos w=1.12u l=0.13u
XNA_n1262 n1262 dn6 m_n1262 gn1 sg13_lv_nmos w=0.74u l=0.13u
XNB_n1262 m_n1262 d7 gn1 gn1 sg13_lv_nmos w=0.74u l=0.13u
CL_n1262 n1262 gn1 2f
XPA_n1264 n1264 d6 ph1 ph1 sg13_lv_pmos w=1.12u l=0.13u
XPB_n1264 n1264 d7 ph1 ph1 sg13_lv_pmos w=1.12u l=0.13u
XNA_n1264 n1264 d6 m_n1264 gn1 sg13_lv_nmos w=0.74u l=0.13u
XNB_n1264 m_n1264 d7 gn1 gn1 sg13_lv_nmos w=0.74u l=0.13u
CL_n1264 n1264 gn1 2f
XPA_n1265 n1265 dn6 ph1 ph1 sg13_lv_pmos w=1.12u l=0.13u
XPB_n1265 n1265 dn7 ph1 ph1 sg13_lv_pmos w=1.12u l=0.13u
XNA_n1265 n1265 dn6 m_n1265 gn1 sg13_lv_nmos w=0.74u l=0.13u
XNB_n1265 m_n1265 dn7 gn1 gn1 sg13_lv_nmos w=0.74u l=0.13u
CL_n1265 n1265 gn1 2f
XPA_n1267 n1267 d8 ph1 ph1 sg13_lv_pmos w=1.12u l=0.13u
XPB_n1267 n1267 dn9 ph1 ph1 sg13_lv_pmos w=1.12u l=0.13u
XNA_n1267 n1267 d8 m_n1267 gn1 sg13_lv_nmos w=0.74u l=0.13u
XNB_n1267 m_n1267 dn9 gn1 gn1 sg13_lv_nmos w=0.74u l=0.13u
CL_n1267 n1267 gn1 2f
XPA_n1268 n1268 dn8 ph1 ph1 sg13_lv_pmos w=1.12u l=0.13u
XPB_n1268 n1268 d9 ph1 ph1 sg13_lv_pmos w=1.12u l=0.13u
XNA_n1268 n1268 dn8 m_n1268 gn1 sg13_lv_nmos w=0.74u l=0.13u
XNB_n1268 m_n1268 d9 gn1 gn1 sg13_lv_nmos w=0.74u l=0.13u
CL_n1268 n1268 gn1 2f
XPA_n1270 n1270 d8 ph1 ph1 sg13_lv_pmos w=1.12u l=0.13u
XPB_n1270 n1270 d9 ph1 ph1 sg13_lv_pmos w=1.12u l=0.13u
XNA_n1270 n1270 d8 m_n1270 gn1 sg13_lv_nmos w=0.74u l=0.13u
XNB_n1270 m_n1270 d9 gn1 gn1 sg13_lv_nmos w=0.74u l=0.13u
CL_n1270 n1270 gn1 2f
XPA_n1271 n1271 dn8 ph1 ph1 sg13_lv_pmos w=1.12u l=0.13u
XPB_n1271 n1271 dn9 ph1 ph1 sg13_lv_pmos w=1.12u l=0.13u
XNA_n1271 n1271 dn8 m_n1271 gn1 sg13_lv_nmos w=0.74u l=0.13u
XNB_n1271 m_n1271 dn9 gn1 gn1 sg13_lv_nmos w=0.74u l=0.13u
CL_n1271 n1271 gn1 2f
XPA_n1273 n1273 d10 ph1 ph1 sg13_lv_pmos w=1.12u l=0.13u
XPB_n1273 n1273 dn15 ph1 ph1 sg13_lv_pmos w=1.12u l=0.13u
XNA_n1273 n1273 d10 m_n1273 gn1 sg13_lv_nmos w=0.74u l=0.13u
XNB_n1273 m_n1273 dn15 gn1 gn1 sg13_lv_nmos w=0.74u l=0.13u
CL_n1273 n1273 gn1 2f
XPA_n1274 n1274 dn10 ph1 ph1 sg13_lv_pmos w=1.12u l=0.13u
XPB_n1274 n1274 d15 ph1 ph1 sg13_lv_pmos w=1.12u l=0.13u
XNA_n1274 n1274 dn10 m_n1274 gn1 sg13_lv_nmos w=0.74u l=0.13u
XNB_n1274 m_n1274 d15 gn1 gn1 sg13_lv_nmos w=0.74u l=0.13u
CL_n1274 n1274 gn1 2f
XPA_n1276 n1276 d10 ph1 ph1 sg13_lv_pmos w=1.12u l=0.13u
XPB_n1276 n1276 d15 ph1 ph1 sg13_lv_pmos w=1.12u l=0.13u
XNA_n1276 n1276 d10 m_n1276 gn1 sg13_lv_nmos w=0.74u l=0.13u
XNB_n1276 m_n1276 d15 gn1 gn1 sg13_lv_nmos w=0.74u l=0.13u
CL_n1276 n1276 gn1 2f
XPA_n1277 n1277 dn10 ph1 ph1 sg13_lv_pmos w=1.12u l=0.13u
XPB_n1277 n1277 dn15 ph1 ph1 sg13_lv_pmos w=1.12u l=0.13u
XNA_n1277 n1277 dn10 m_n1277 gn1 sg13_lv_nmos w=0.74u l=0.13u
XNB_n1277 m_n1277 dn15 gn1 gn1 sg13_lv_nmos w=0.74u l=0.13u
CL_n1277 n1277 gn1 2f
XPA_n1279 n1279 d16 ph1 ph1 sg13_lv_pmos w=1.12u l=0.13u
XPB_n1279 n1279 dn21 ph1 ph1 sg13_lv_pmos w=1.12u l=0.13u
XNA_n1279 n1279 d16 m_n1279 gn1 sg13_lv_nmos w=0.74u l=0.13u
XNB_n1279 m_n1279 dn21 gn1 gn1 sg13_lv_nmos w=0.74u l=0.13u
CL_n1279 n1279 gn1 2f
XPA_n1280 n1280 dn16 ph1 ph1 sg13_lv_pmos w=1.12u l=0.13u
XPB_n1280 n1280 d21 ph1 ph1 sg13_lv_pmos w=1.12u l=0.13u
XNA_n1280 n1280 dn16 m_n1280 gn1 sg13_lv_nmos w=0.74u l=0.13u
XNB_n1280 m_n1280 d21 gn1 gn1 sg13_lv_nmos w=0.74u l=0.13u
CL_n1280 n1280 gn1 2f
XPA_n1282 n1282 d16 ph1 ph1 sg13_lv_pmos w=1.12u l=0.13u
XPB_n1282 n1282 d21 ph1 ph1 sg13_lv_pmos w=1.12u l=0.13u
XNA_n1282 n1282 d16 m_n1282 gn1 sg13_lv_nmos w=0.74u l=0.13u
XNB_n1282 m_n1282 d21 gn1 gn1 sg13_lv_nmos w=0.74u l=0.13u
CL_n1282 n1282 gn1 2f
XPA_n1283 n1283 dn16 ph1 ph1 sg13_lv_pmos w=1.12u l=0.13u
XPB_n1283 n1283 dn21 ph1 ph1 sg13_lv_pmos w=1.12u l=0.13u
XNA_n1283 n1283 dn16 m_n1283 gn1 sg13_lv_nmos w=0.74u l=0.13u
XNB_n1283 m_n1283 dn21 gn1 gn1 sg13_lv_nmos w=0.74u l=0.13u
CL_n1283 n1283 gn1 2f
XPA_n1285 n1285 d23 ph1 ph1 sg13_lv_pmos w=1.12u l=0.13u
XPB_n1285 n1285 dn24 ph1 ph1 sg13_lv_pmos w=1.12u l=0.13u
XNA_n1285 n1285 d23 m_n1285 gn1 sg13_lv_nmos w=0.74u l=0.13u
XNB_n1285 m_n1285 dn24 gn1 gn1 sg13_lv_nmos w=0.74u l=0.13u
CL_n1285 n1285 gn1 2f
XPA_n1286 n1286 dn23 ph1 ph1 sg13_lv_pmos w=1.12u l=0.13u
XPB_n1286 n1286 d24 ph1 ph1 sg13_lv_pmos w=1.12u l=0.13u
XNA_n1286 n1286 dn23 m_n1286 gn1 sg13_lv_nmos w=0.74u l=0.13u
XNB_n1286 m_n1286 d24 gn1 gn1 sg13_lv_nmos w=0.74u l=0.13u
CL_n1286 n1286 gn1 2f
XPA_n1288 n1288 d23 ph1 ph1 sg13_lv_pmos w=1.12u l=0.13u
XPB_n1288 n1288 d24 ph1 ph1 sg13_lv_pmos w=1.12u l=0.13u
XNA_n1288 n1288 d23 m_n1288 gn1 sg13_lv_nmos w=0.74u l=0.13u
XNB_n1288 m_n1288 d24 gn1 gn1 sg13_lv_nmos w=0.74u l=0.13u
CL_n1288 n1288 gn1 2f
XPA_n1289 n1289 dn23 ph1 ph1 sg13_lv_pmos w=1.12u l=0.13u
XPB_n1289 n1289 dn24 ph1 ph1 sg13_lv_pmos w=1.12u l=0.13u
XNA_n1289 n1289 dn23 m_n1289 gn1 sg13_lv_nmos w=0.74u l=0.13u
XNB_n1289 m_n1289 dn24 gn1 gn1 sg13_lv_nmos w=0.74u l=0.13u
CL_n1289 n1289 gn1 2f
XPA_n1291 n1291 d26 ph1 ph1 sg13_lv_pmos w=1.12u l=0.13u
XPB_n1291 n1291 dn28 ph1 ph1 sg13_lv_pmos w=1.12u l=0.13u
XNA_n1291 n1291 d26 m_n1291 gn1 sg13_lv_nmos w=0.74u l=0.13u
XNB_n1291 m_n1291 dn28 gn1 gn1 sg13_lv_nmos w=0.74u l=0.13u
CL_n1291 n1291 gn1 2f
XPA_n1292 n1292 dn26 ph1 ph1 sg13_lv_pmos w=1.12u l=0.13u
XPB_n1292 n1292 d28 ph1 ph1 sg13_lv_pmos w=1.12u l=0.13u
XNA_n1292 n1292 dn26 m_n1292 gn1 sg13_lv_nmos w=0.74u l=0.13u
XNB_n1292 m_n1292 d28 gn1 gn1 sg13_lv_nmos w=0.74u l=0.13u
CL_n1292 n1292 gn1 2f
XPA_n1294 n1294 d26 ph1 ph1 sg13_lv_pmos w=1.12u l=0.13u
XPB_n1294 n1294 d28 ph1 ph1 sg13_lv_pmos w=1.12u l=0.13u
XNA_n1294 n1294 d26 m_n1294 gn1 sg13_lv_nmos w=0.74u l=0.13u
XNB_n1294 m_n1294 d28 gn1 gn1 sg13_lv_nmos w=0.74u l=0.13u
CL_n1294 n1294 gn1 2f
XPA_n1295 n1295 dn26 ph1 ph1 sg13_lv_pmos w=1.12u l=0.13u
XPB_n1295 n1295 dn28 ph1 ph1 sg13_lv_pmos w=1.12u l=0.13u
XNA_n1295 n1295 dn26 m_n1295 gn1 sg13_lv_nmos w=0.74u l=0.13u
XNB_n1295 m_n1295 dn28 gn1 gn1 sg13_lv_nmos w=0.74u l=0.13u
CL_n1295 n1295 gn1 2f
XPA_n1297 n1297 d29 ph1 ph1 sg13_lv_pmos w=1.12u l=0.13u
XPB_n1297 n1297 dn31 ph1 ph1 sg13_lv_pmos w=1.12u l=0.13u
XNA_n1297 n1297 d29 m_n1297 gn1 sg13_lv_nmos w=0.74u l=0.13u
XNB_n1297 m_n1297 dn31 gn1 gn1 sg13_lv_nmos w=0.74u l=0.13u
CL_n1297 n1297 gn1 2f
XPA_n1298 n1298 dn29 ph1 ph1 sg13_lv_pmos w=1.12u l=0.13u
XPB_n1298 n1298 d31 ph1 ph1 sg13_lv_pmos w=1.12u l=0.13u
XNA_n1298 n1298 dn29 m_n1298 gn1 sg13_lv_nmos w=0.74u l=0.13u
XNB_n1298 m_n1298 d31 gn1 gn1 sg13_lv_nmos w=0.74u l=0.13u
CL_n1298 n1298 gn1 2f
XPA_n13 n13 s12 ph1 ph1 sg13_lv_pmos w=1.12u l=0.13u
XPB_n13 n13 sn16 ph1 ph1 sg13_lv_pmos w=1.12u l=0.13u
XNA_n13 n13 s12 m_n13 gn1 sg13_lv_nmos w=0.74u l=0.13u
XNB_n13 m_n13 sn16 gn1 gn1 sg13_lv_nmos w=0.74u l=0.13u
CL_n13 n13 gn1 2f
XPA_n1300 n1300 d29 ph1 ph1 sg13_lv_pmos w=1.12u l=0.13u
XPB_n1300 n1300 d31 ph1 ph1 sg13_lv_pmos w=1.12u l=0.13u
XNA_n1300 n1300 d29 m_n1300 gn1 sg13_lv_nmos w=0.74u l=0.13u
XNB_n1300 m_n1300 d31 gn1 gn1 sg13_lv_nmos w=0.74u l=0.13u
CL_n1300 n1300 gn1 2f
XPA_n1301 n1301 dn29 ph1 ph1 sg13_lv_pmos w=1.12u l=0.13u
XPB_n1301 n1301 dn31 ph1 ph1 sg13_lv_pmos w=1.12u l=0.13u
XNA_n1301 n1301 dn29 m_n1301 gn1 sg13_lv_nmos w=0.74u l=0.13u
XNB_n1301 m_n1301 dn31 gn1 gn1 sg13_lv_nmos w=0.74u l=0.13u
CL_n1301 n1301 gn1 2f
XPA_n14 n14 sn12 ph1 ph1 sg13_lv_pmos w=1.12u l=0.13u
XPB_n14 n14 s16 ph1 ph1 sg13_lv_pmos w=1.12u l=0.13u
XNA_n14 n14 sn12 m_n14 gn1 sg13_lv_nmos w=0.74u l=0.13u
XNB_n14 m_n14 s16 gn1 gn1 sg13_lv_nmos w=0.74u l=0.13u
CL_n14 n14 gn1 2f
XPA_n151 n151 s0 ph1 ph1 sg13_lv_pmos w=1.12u l=0.13u
XPB_n151 n151 sn1 ph1 ph1 sg13_lv_pmos w=1.12u l=0.13u
XNA_n151 n151 s0 m_n151 gn1 sg13_lv_nmos w=0.74u l=0.13u
XNB_n151 m_n151 sn1 gn1 gn1 sg13_lv_nmos w=0.74u l=0.13u
CL_n151 n151 gn1 2f
XPA_n152 n152 sn0 ph1 ph1 sg13_lv_pmos w=1.12u l=0.13u
XPB_n152 n152 s1 ph1 ph1 sg13_lv_pmos w=1.12u l=0.13u
XNA_n152 n152 sn0 m_n152 gn1 sg13_lv_nmos w=0.74u l=0.13u
XNB_n152 m_n152 s1 gn1 gn1 sg13_lv_nmos w=0.74u l=0.13u
CL_n152 n152 gn1 2f
XPA_n154 n154 s0 ph1 ph1 sg13_lv_pmos w=1.12u l=0.13u
XPB_n154 n154 s1 ph1 ph1 sg13_lv_pmos w=1.12u l=0.13u
XNA_n154 n154 s0 m_n154 gn1 sg13_lv_nmos w=0.74u l=0.13u
XNB_n154 m_n154 s1 gn1 gn1 sg13_lv_nmos w=0.74u l=0.13u
CL_n154 n154 gn1 2f
XPA_n155 n155 sn0 ph1 ph1 sg13_lv_pmos w=1.12u l=0.13u
XPB_n155 n155 sn1 ph1 ph1 sg13_lv_pmos w=1.12u l=0.13u
XNA_n155 n155 sn0 m_n155 gn1 sg13_lv_nmos w=0.74u l=0.13u
XNB_n155 m_n155 sn1 gn1 gn1 sg13_lv_nmos w=0.74u l=0.13u
CL_n155 n155 gn1 2f
XPA_n157 n157 s6 ph1 ph1 sg13_lv_pmos w=1.12u l=0.13u
XPB_n157 n157 sn7 ph1 ph1 sg13_lv_pmos w=1.12u l=0.13u
XNA_n157 n157 s6 m_n157 gn1 sg13_lv_nmos w=0.74u l=0.13u
XNB_n157 m_n157 sn7 gn1 gn1 sg13_lv_nmos w=0.74u l=0.13u
CL_n157 n157 gn1 2f
XPA_n158 n158 sn6 ph1 ph1 sg13_lv_pmos w=1.12u l=0.13u
XPB_n158 n158 s7 ph1 ph1 sg13_lv_pmos w=1.12u l=0.13u
XNA_n158 n158 sn6 m_n158 gn1 sg13_lv_nmos w=0.74u l=0.13u
XNB_n158 m_n158 s7 gn1 gn1 sg13_lv_nmos w=0.74u l=0.13u
CL_n158 n158 gn1 2f
XPA_n16 n16 s12 ph1 ph1 sg13_lv_pmos w=1.12u l=0.13u
XPB_n16 n16 s16 ph1 ph1 sg13_lv_pmos w=1.12u l=0.13u
XNA_n16 n16 s12 m_n16 gn1 sg13_lv_nmos w=0.74u l=0.13u
XNB_n16 m_n16 s16 gn1 gn1 sg13_lv_nmos w=0.74u l=0.13u
CL_n16 n16 gn1 2f
XPA_n160 n160 s6 ph1 ph1 sg13_lv_pmos w=1.12u l=0.13u
XPB_n160 n160 s7 ph1 ph1 sg13_lv_pmos w=1.12u l=0.13u
XNA_n160 n160 s6 m_n160 gn1 sg13_lv_nmos w=0.74u l=0.13u
XNB_n160 m_n160 s7 gn1 gn1 sg13_lv_nmos w=0.74u l=0.13u
CL_n160 n160 gn1 2f
XPA_n161 n161 sn6 ph1 ph1 sg13_lv_pmos w=1.12u l=0.13u
XPB_n161 n161 sn7 ph1 ph1 sg13_lv_pmos w=1.12u l=0.13u
XNA_n161 n161 sn6 m_n161 gn1 sg13_lv_nmos w=0.74u l=0.13u
XNB_n161 m_n161 sn7 gn1 gn1 sg13_lv_nmos w=0.74u l=0.13u
CL_n161 n161 gn1 2f
XPA_n163 n163 s9 ph1 ph1 sg13_lv_pmos w=1.12u l=0.13u
XPB_n163 n163 sn11 ph1 ph1 sg13_lv_pmos w=1.12u l=0.13u
XNA_n163 n163 s9 m_n163 gn1 sg13_lv_nmos w=0.74u l=0.13u
XNB_n163 m_n163 sn11 gn1 gn1 sg13_lv_nmos w=0.74u l=0.13u
CL_n163 n163 gn1 2f
XPA_n164 n164 sn9 ph1 ph1 sg13_lv_pmos w=1.12u l=0.13u
XPB_n164 n164 s11 ph1 ph1 sg13_lv_pmos w=1.12u l=0.13u
XNA_n164 n164 sn9 m_n164 gn1 sg13_lv_nmos w=0.74u l=0.13u
XNB_n164 m_n164 s11 gn1 gn1 sg13_lv_nmos w=0.74u l=0.13u
CL_n164 n164 gn1 2f
XPA_n166 n166 s9 ph1 ph1 sg13_lv_pmos w=1.12u l=0.13u
XPB_n166 n166 s11 ph1 ph1 sg13_lv_pmos w=1.12u l=0.13u
XNA_n166 n166 s9 m_n166 gn1 sg13_lv_nmos w=0.74u l=0.13u
XNB_n166 m_n166 s11 gn1 gn1 sg13_lv_nmos w=0.74u l=0.13u
CL_n166 n166 gn1 2f
XPA_n167 n167 sn9 ph1 ph1 sg13_lv_pmos w=1.12u l=0.13u
XPB_n167 n167 sn11 ph1 ph1 sg13_lv_pmos w=1.12u l=0.13u
XNA_n167 n167 sn9 m_n167 gn1 sg13_lv_nmos w=0.74u l=0.13u
XNB_n167 m_n167 sn11 gn1 gn1 sg13_lv_nmos w=0.74u l=0.13u
CL_n167 n167 gn1 2f
XPA_n169 n169 s12 ph1 ph1 sg13_lv_pmos w=1.12u l=0.13u
XPB_n169 n169 sn13 ph1 ph1 sg13_lv_pmos w=1.12u l=0.13u
XNA_n169 n169 s12 m_n169 gn1 sg13_lv_nmos w=0.74u l=0.13u
XNB_n169 m_n169 sn13 gn1 gn1 sg13_lv_nmos w=0.74u l=0.13u
CL_n169 n169 gn1 2f
XPA_n17 n17 sn12 ph1 ph1 sg13_lv_pmos w=1.12u l=0.13u
XPB_n17 n17 sn16 ph1 ph1 sg13_lv_pmos w=1.12u l=0.13u
XNA_n17 n17 sn12 m_n17 gn1 sg13_lv_nmos w=0.74u l=0.13u
XNB_n17 m_n17 sn16 gn1 gn1 sg13_lv_nmos w=0.74u l=0.13u
CL_n17 n17 gn1 2f
XPA_n170 n170 sn12 ph1 ph1 sg13_lv_pmos w=1.12u l=0.13u
XPB_n170 n170 s13 ph1 ph1 sg13_lv_pmos w=1.12u l=0.13u
XNA_n170 n170 sn12 m_n170 gn1 sg13_lv_nmos w=0.74u l=0.13u
XNB_n170 m_n170 s13 gn1 gn1 sg13_lv_nmos w=0.74u l=0.13u
CL_n170 n170 gn1 2f
XPA_n172 n172 s12 ph1 ph1 sg13_lv_pmos w=1.12u l=0.13u
XPB_n172 n172 s13 ph1 ph1 sg13_lv_pmos w=1.12u l=0.13u
XNA_n172 n172 s12 m_n172 gn1 sg13_lv_nmos w=0.74u l=0.13u
XNB_n172 m_n172 s13 gn1 gn1 sg13_lv_nmos w=0.74u l=0.13u
CL_n172 n172 gn1 2f
XPA_n173 n173 sn12 ph1 ph1 sg13_lv_pmos w=1.12u l=0.13u
XPB_n173 n173 sn13 ph1 ph1 sg13_lv_pmos w=1.12u l=0.13u
XNA_n173 n173 sn12 m_n173 gn1 sg13_lv_nmos w=0.74u l=0.13u
XNB_n173 m_n173 sn13 gn1 gn1 sg13_lv_nmos w=0.74u l=0.13u
CL_n173 n173 gn1 2f
XPA_n175 n175 s16 ph1 ph1 sg13_lv_pmos w=1.12u l=0.13u
XPB_n175 n175 sn17 ph1 ph1 sg13_lv_pmos w=1.12u l=0.13u
XNA_n175 n175 s16 m_n175 gn1 sg13_lv_nmos w=0.74u l=0.13u
XNB_n175 m_n175 sn17 gn1 gn1 sg13_lv_nmos w=0.74u l=0.13u
CL_n175 n175 gn1 2f
XPA_n176 n176 sn16 ph1 ph1 sg13_lv_pmos w=1.12u l=0.13u
XPB_n176 n176 s17 ph1 ph1 sg13_lv_pmos w=1.12u l=0.13u
XNA_n176 n176 sn16 m_n176 gn1 sg13_lv_nmos w=0.74u l=0.13u
XNB_n176 m_n176 s17 gn1 gn1 sg13_lv_nmos w=0.74u l=0.13u
CL_n176 n176 gn1 2f
XPA_n178 n178 s16 ph1 ph1 sg13_lv_pmos w=1.12u l=0.13u
XPB_n178 n178 s17 ph1 ph1 sg13_lv_pmos w=1.12u l=0.13u
XNA_n178 n178 s16 m_n178 gn1 sg13_lv_nmos w=0.74u l=0.13u
XNB_n178 m_n178 s17 gn1 gn1 sg13_lv_nmos w=0.74u l=0.13u
CL_n178 n178 gn1 2f
XPA_n179 n179 sn16 ph1 ph1 sg13_lv_pmos w=1.12u l=0.13u
XPB_n179 n179 sn17 ph1 ph1 sg13_lv_pmos w=1.12u l=0.13u
XNA_n179 n179 sn16 m_n179 gn1 sg13_lv_nmos w=0.74u l=0.13u
XNB_n179 m_n179 sn17 gn1 gn1 sg13_lv_nmos w=0.74u l=0.13u
CL_n179 n179 gn1 2f
XPA_n181 n181 s24 ph1 ph1 sg13_lv_pmos w=1.12u l=0.13u
XPB_n181 n181 sn27 ph1 ph1 sg13_lv_pmos w=1.12u l=0.13u
XNA_n181 n181 s24 m_n181 gn1 sg13_lv_nmos w=0.74u l=0.13u
XNB_n181 m_n181 sn27 gn1 gn1 sg13_lv_nmos w=0.74u l=0.13u
CL_n181 n181 gn1 2f
XPA_n182 n182 sn24 ph1 ph1 sg13_lv_pmos w=1.12u l=0.13u
XPB_n182 n182 s27 ph1 ph1 sg13_lv_pmos w=1.12u l=0.13u
XNA_n182 n182 sn24 m_n182 gn1 sg13_lv_nmos w=0.74u l=0.13u
XNB_n182 m_n182 s27 gn1 gn1 sg13_lv_nmos w=0.74u l=0.13u
CL_n182 n182 gn1 2f
XPA_n184 n184 s24 ph1 ph1 sg13_lv_pmos w=1.12u l=0.13u
XPB_n184 n184 s27 ph1 ph1 sg13_lv_pmos w=1.12u l=0.13u
XNA_n184 n184 s24 m_n184 gn1 sg13_lv_nmos w=0.74u l=0.13u
XNB_n184 m_n184 s27 gn1 gn1 sg13_lv_nmos w=0.74u l=0.13u
CL_n184 n184 gn1 2f
XPA_n185 n185 sn24 ph1 ph1 sg13_lv_pmos w=1.12u l=0.13u
XPB_n185 n185 sn27 ph1 ph1 sg13_lv_pmos w=1.12u l=0.13u
XNA_n185 n185 sn24 m_n185 gn1 sg13_lv_nmos w=0.74u l=0.13u
XNB_n185 m_n185 sn27 gn1 gn1 sg13_lv_nmos w=0.74u l=0.13u
CL_n185 n185 gn1 2f
XPA_n187 n187 s28 ph1 ph1 sg13_lv_pmos w=1.12u l=0.13u
XPB_n187 n187 dn3 ph1 ph1 sg13_lv_pmos w=1.12u l=0.13u
XNA_n187 n187 s28 m_n187 gn1 sg13_lv_nmos w=0.74u l=0.13u
XNB_n187 m_n187 dn3 gn1 gn1 sg13_lv_nmos w=0.74u l=0.13u
CL_n187 n187 gn1 2f
XPA_n188 n188 sn28 ph1 ph1 sg13_lv_pmos w=1.12u l=0.13u
XPB_n188 n188 d3 ph1 ph1 sg13_lv_pmos w=1.12u l=0.13u
XNA_n188 n188 sn28 m_n188 gn1 sg13_lv_nmos w=0.74u l=0.13u
XNB_n188 m_n188 d3 gn1 gn1 sg13_lv_nmos w=0.74u l=0.13u
CL_n188 n188 gn1 2f
XPA_n19 n19 s24 ph1 ph1 sg13_lv_pmos w=1.12u l=0.13u
XPB_n19 n19 sn25 ph1 ph1 sg13_lv_pmos w=1.12u l=0.13u
XNA_n19 n19 s24 m_n19 gn1 sg13_lv_nmos w=0.74u l=0.13u
XNB_n19 m_n19 sn25 gn1 gn1 sg13_lv_nmos w=0.74u l=0.13u
CL_n19 n19 gn1 2f
XPA_n190 n190 s28 ph1 ph1 sg13_lv_pmos w=1.12u l=0.13u
XPB_n190 n190 d3 ph1 ph1 sg13_lv_pmos w=1.12u l=0.13u
XNA_n190 n190 s28 m_n190 gn1 sg13_lv_nmos w=0.74u l=0.13u
XNB_n190 m_n190 d3 gn1 gn1 sg13_lv_nmos w=0.74u l=0.13u
CL_n190 n190 gn1 2f
XPA_n191 n191 sn28 ph1 ph1 sg13_lv_pmos w=1.12u l=0.13u
XPB_n191 n191 dn3 ph1 ph1 sg13_lv_pmos w=1.12u l=0.13u
XNA_n191 n191 sn28 m_n191 gn1 sg13_lv_nmos w=0.74u l=0.13u
XNB_n191 m_n191 dn3 gn1 gn1 sg13_lv_nmos w=0.74u l=0.13u
CL_n191 n191 gn1 2f
XPA_n193 n193 d4 ph1 ph1 sg13_lv_pmos w=1.12u l=0.13u
XPB_n193 n193 dn7 ph1 ph1 sg13_lv_pmos w=1.12u l=0.13u
XNA_n193 n193 d4 m_n193 gn1 sg13_lv_nmos w=0.74u l=0.13u
XNB_n193 m_n193 dn7 gn1 gn1 sg13_lv_nmos w=0.74u l=0.13u
CL_n193 n193 gn1 2f
XPA_n194 n194 dn4 ph1 ph1 sg13_lv_pmos w=1.12u l=0.13u
XPB_n194 n194 d7 ph1 ph1 sg13_lv_pmos w=1.12u l=0.13u
XNA_n194 n194 dn4 m_n194 gn1 sg13_lv_nmos w=0.74u l=0.13u
XNB_n194 m_n194 d7 gn1 gn1 sg13_lv_nmos w=0.74u l=0.13u
CL_n194 n194 gn1 2f
XPA_n196 n196 d4 ph1 ph1 sg13_lv_pmos w=1.12u l=0.13u
XPB_n196 n196 d7 ph1 ph1 sg13_lv_pmos w=1.12u l=0.13u
XNA_n196 n196 d4 m_n196 gn1 sg13_lv_nmos w=0.74u l=0.13u
XNB_n196 m_n196 d7 gn1 gn1 sg13_lv_nmos w=0.74u l=0.13u
CL_n196 n196 gn1 2f
XPA_n197 n197 dn4 ph1 ph1 sg13_lv_pmos w=1.12u l=0.13u
XPB_n197 n197 dn7 ph1 ph1 sg13_lv_pmos w=1.12u l=0.13u
XNA_n197 n197 dn4 m_n197 gn1 sg13_lv_nmos w=0.74u l=0.13u
XNB_n197 m_n197 dn7 gn1 gn1 sg13_lv_nmos w=0.74u l=0.13u
CL_n197 n197 gn1 2f
XPA_n199 n199 d14 ph1 ph1 sg13_lv_pmos w=1.12u l=0.13u
XPB_n199 n199 dn15 ph1 ph1 sg13_lv_pmos w=1.12u l=0.13u
XNA_n199 n199 d14 m_n199 gn1 sg13_lv_nmos w=0.74u l=0.13u
XNB_n199 m_n199 dn15 gn1 gn1 sg13_lv_nmos w=0.74u l=0.13u
CL_n199 n199 gn1 2f
XPA_n2 n2 sn0 ph1 ph1 sg13_lv_pmos w=1.12u l=0.13u
XPB_n2 n2 s6 ph1 ph1 sg13_lv_pmos w=1.12u l=0.13u
XNA_n2 n2 sn0 m_n2 gn1 sg13_lv_nmos w=0.74u l=0.13u
XNB_n2 m_n2 s6 gn1 gn1 sg13_lv_nmos w=0.74u l=0.13u
CL_n2 n2 gn1 2f
XPA_n20 n20 sn24 ph1 ph1 sg13_lv_pmos w=1.12u l=0.13u
XPB_n20 n20 s25 ph1 ph1 sg13_lv_pmos w=1.12u l=0.13u
XNA_n20 n20 sn24 m_n20 gn1 sg13_lv_nmos w=0.74u l=0.13u
XNB_n20 m_n20 s25 gn1 gn1 sg13_lv_nmos w=0.74u l=0.13u
CL_n20 n20 gn1 2f
XPA_n200 n200 dn14 ph1 ph1 sg13_lv_pmos w=1.12u l=0.13u
XPB_n200 n200 d15 ph1 ph1 sg13_lv_pmos w=1.12u l=0.13u
XNA_n200 n200 dn14 m_n200 gn1 sg13_lv_nmos w=0.74u l=0.13u
XNB_n200 m_n200 d15 gn1 gn1 sg13_lv_nmos w=0.74u l=0.13u
CL_n200 n200 gn1 2f
XPA_n202 n202 d14 ph1 ph1 sg13_lv_pmos w=1.12u l=0.13u
XPB_n202 n202 d15 ph1 ph1 sg13_lv_pmos w=1.12u l=0.13u
XNA_n202 n202 d14 m_n202 gn1 sg13_lv_nmos w=0.74u l=0.13u
XNB_n202 m_n202 d15 gn1 gn1 sg13_lv_nmos w=0.74u l=0.13u
CL_n202 n202 gn1 2f
XPA_n203 n203 dn14 ph1 ph1 sg13_lv_pmos w=1.12u l=0.13u
XPB_n203 n203 dn15 ph1 ph1 sg13_lv_pmos w=1.12u l=0.13u
XNA_n203 n203 dn14 m_n203 gn1 sg13_lv_nmos w=0.74u l=0.13u
XNB_n203 m_n203 dn15 gn1 gn1 sg13_lv_nmos w=0.74u l=0.13u
CL_n203 n203 gn1 2f
XPA_n205 n205 d18 ph1 ph1 sg13_lv_pmos w=1.12u l=0.13u
XPB_n205 n205 dn19 ph1 ph1 sg13_lv_pmos w=1.12u l=0.13u
XNA_n205 n205 d18 m_n205 gn1 sg13_lv_nmos w=0.74u l=0.13u
XNB_n205 m_n205 dn19 gn1 gn1 sg13_lv_nmos w=0.74u l=0.13u
CL_n205 n205 gn1 2f
XPA_n206 n206 dn18 ph1 ph1 sg13_lv_pmos w=1.12u l=0.13u
XPB_n206 n206 d19 ph1 ph1 sg13_lv_pmos w=1.12u l=0.13u
XNA_n206 n206 dn18 m_n206 gn1 sg13_lv_nmos w=0.74u l=0.13u
XNB_n206 m_n206 d19 gn1 gn1 sg13_lv_nmos w=0.74u l=0.13u
CL_n206 n206 gn1 2f
XPA_n208 n208 d18 ph1 ph1 sg13_lv_pmos w=1.12u l=0.13u
XPB_n208 n208 d19 ph1 ph1 sg13_lv_pmos w=1.12u l=0.13u
XNA_n208 n208 d18 m_n208 gn1 sg13_lv_nmos w=0.74u l=0.13u
XNB_n208 m_n208 d19 gn1 gn1 sg13_lv_nmos w=0.74u l=0.13u
CL_n208 n208 gn1 2f
XPA_n209 n209 dn18 ph1 ph1 sg13_lv_pmos w=1.12u l=0.13u
XPB_n209 n209 dn19 ph1 ph1 sg13_lv_pmos w=1.12u l=0.13u
XNA_n209 n209 dn18 m_n209 gn1 sg13_lv_nmos w=0.74u l=0.13u
XNB_n209 m_n209 dn19 gn1 gn1 sg13_lv_nmos w=0.74u l=0.13u
CL_n209 n209 gn1 2f
XPA_n22 n22 s24 ph1 ph1 sg13_lv_pmos w=1.12u l=0.13u
XPB_n22 n22 s25 ph1 ph1 sg13_lv_pmos w=1.12u l=0.13u
XNA_n22 n22 s24 m_n22 gn1 sg13_lv_nmos w=0.74u l=0.13u
XNB_n22 m_n22 s25 gn1 gn1 sg13_lv_nmos w=0.74u l=0.13u
CL_n22 n22 gn1 2f
XPA_n23 n23 sn24 ph1 ph1 sg13_lv_pmos w=1.12u l=0.13u
XPB_n23 n23 sn25 ph1 ph1 sg13_lv_pmos w=1.12u l=0.13u
XNA_n23 n23 sn24 m_n23 gn1 sg13_lv_nmos w=0.74u l=0.13u
XNB_n23 m_n23 sn25 gn1 gn1 sg13_lv_nmos w=0.74u l=0.13u
CL_n23 n23 gn1 2f
XPA_n241 n241 d20 ph1 ph1 sg13_lv_pmos w=1.12u l=0.13u
XPB_n241 n241 dn22 ph1 ph1 sg13_lv_pmos w=1.12u l=0.13u
XNA_n241 n241 d20 m_n241 gn1 sg13_lv_nmos w=0.74u l=0.13u
XNB_n241 m_n241 dn22 gn1 gn1 sg13_lv_nmos w=0.74u l=0.13u
CL_n241 n241 gn1 2f
XPA_n242 n242 dn20 ph1 ph1 sg13_lv_pmos w=1.12u l=0.13u
XPB_n242 n242 d22 ph1 ph1 sg13_lv_pmos w=1.12u l=0.13u
XNA_n242 n242 dn20 m_n242 gn1 sg13_lv_nmos w=0.74u l=0.13u
XNB_n242 m_n242 d22 gn1 gn1 sg13_lv_nmos w=0.74u l=0.13u
CL_n242 n242 gn1 2f
XPA_n244 n244 d20 ph1 ph1 sg13_lv_pmos w=1.12u l=0.13u
XPB_n244 n244 d22 ph1 ph1 sg13_lv_pmos w=1.12u l=0.13u
XNA_n244 n244 d20 m_n244 gn1 sg13_lv_nmos w=0.74u l=0.13u
XNB_n244 m_n244 d22 gn1 gn1 sg13_lv_nmos w=0.74u l=0.13u
CL_n244 n244 gn1 2f
XPA_n245 n245 dn20 ph1 ph1 sg13_lv_pmos w=1.12u l=0.13u
XPB_n245 n245 dn22 ph1 ph1 sg13_lv_pmos w=1.12u l=0.13u
XNA_n245 n245 dn20 m_n245 gn1 sg13_lv_nmos w=0.74u l=0.13u
XNB_n245 m_n245 dn22 gn1 gn1 sg13_lv_nmos w=0.74u l=0.13u
CL_n245 n245 gn1 2f
XPA_n247 n247 d24 ph1 ph1 sg13_lv_pmos w=1.12u l=0.13u
XPB_n247 n247 dn25 ph1 ph1 sg13_lv_pmos w=1.12u l=0.13u
XNA_n247 n247 d24 m_n247 gn1 sg13_lv_nmos w=0.74u l=0.13u
XNB_n247 m_n247 dn25 gn1 gn1 sg13_lv_nmos w=0.74u l=0.13u
CL_n247 n247 gn1 2f
XPA_n248 n248 dn24 ph1 ph1 sg13_lv_pmos w=1.12u l=0.13u
XPB_n248 n248 d25 ph1 ph1 sg13_lv_pmos w=1.12u l=0.13u
XNA_n248 n248 dn24 m_n248 gn1 sg13_lv_nmos w=0.74u l=0.13u
XNB_n248 m_n248 d25 gn1 gn1 sg13_lv_nmos w=0.74u l=0.13u
CL_n248 n248 gn1 2f
XPA_n25 n25 s26 ph1 ph1 sg13_lv_pmos w=1.12u l=0.13u
XPB_n25 n25 sn28 ph1 ph1 sg13_lv_pmos w=1.12u l=0.13u
XNA_n25 n25 s26 m_n25 gn1 sg13_lv_nmos w=0.74u l=0.13u
XNB_n25 m_n25 sn28 gn1 gn1 sg13_lv_nmos w=0.74u l=0.13u
CL_n25 n25 gn1 2f
XPA_n250 n250 d24 ph1 ph1 sg13_lv_pmos w=1.12u l=0.13u
XPB_n250 n250 d25 ph1 ph1 sg13_lv_pmos w=1.12u l=0.13u
XNA_n250 n250 d24 m_n250 gn1 sg13_lv_nmos w=0.74u l=0.13u
XNB_n250 m_n250 d25 gn1 gn1 sg13_lv_nmos w=0.74u l=0.13u
CL_n250 n250 gn1 2f
XPA_n251 n251 dn24 ph1 ph1 sg13_lv_pmos w=1.12u l=0.13u
XPB_n251 n251 dn25 ph1 ph1 sg13_lv_pmos w=1.12u l=0.13u
XNA_n251 n251 dn24 m_n251 gn1 sg13_lv_nmos w=0.74u l=0.13u
XNB_n251 m_n251 dn25 gn1 gn1 sg13_lv_nmos w=0.74u l=0.13u
CL_n251 n251 gn1 2f
XPA_n253 n253 d30 ph1 ph1 sg13_lv_pmos w=1.12u l=0.13u
XPB_n253 n253 dn31 ph1 ph1 sg13_lv_pmos w=1.12u l=0.13u
XNA_n253 n253 d30 m_n253 gn1 sg13_lv_nmos w=0.74u l=0.13u
XNB_n253 m_n253 dn31 gn1 gn1 sg13_lv_nmos w=0.74u l=0.13u
CL_n253 n253 gn1 2f
XPA_n254 n254 dn30 ph1 ph1 sg13_lv_pmos w=1.12u l=0.13u
XPB_n254 n254 d31 ph1 ph1 sg13_lv_pmos w=1.12u l=0.13u
XNA_n254 n254 dn30 m_n254 gn1 sg13_lv_nmos w=0.74u l=0.13u
XNB_n254 m_n254 d31 gn1 gn1 sg13_lv_nmos w=0.74u l=0.13u
CL_n254 n254 gn1 2f
XPA_n256 n256 d30 ph1 ph1 sg13_lv_pmos w=1.12u l=0.13u
XPB_n256 n256 d31 ph1 ph1 sg13_lv_pmos w=1.12u l=0.13u
XNA_n256 n256 d30 m_n256 gn1 sg13_lv_nmos w=0.74u l=0.13u
XNB_n256 m_n256 d31 gn1 gn1 sg13_lv_nmos w=0.74u l=0.13u
CL_n256 n256 gn1 2f
XPA_n257 n257 dn30 ph1 ph1 sg13_lv_pmos w=1.12u l=0.13u
XPB_n257 n257 dn31 ph1 ph1 sg13_lv_pmos w=1.12u l=0.13u
XNA_n257 n257 dn30 m_n257 gn1 sg13_lv_nmos w=0.74u l=0.13u
XNB_n257 m_n257 dn31 gn1 gn1 sg13_lv_nmos w=0.74u l=0.13u
CL_n257 n257 gn1 2f
XPA_n26 n26 sn26 ph1 ph1 sg13_lv_pmos w=1.12u l=0.13u
XPB_n26 n26 s28 ph1 ph1 sg13_lv_pmos w=1.12u l=0.13u
XNA_n26 n26 sn26 m_n26 gn1 sg13_lv_nmos w=0.74u l=0.13u
XNB_n26 m_n26 s28 gn1 gn1 sg13_lv_nmos w=0.74u l=0.13u
CL_n26 n26 gn1 2f
XPA_n28 n28 s26 ph1 ph1 sg13_lv_pmos w=1.12u l=0.13u
XPB_n28 n28 s28 ph1 ph1 sg13_lv_pmos w=1.12u l=0.13u
XNA_n28 n28 s26 m_n28 gn1 sg13_lv_nmos w=0.74u l=0.13u
XNB_n28 m_n28 s28 gn1 gn1 sg13_lv_nmos w=0.74u l=0.13u
CL_n28 n28 gn1 2f
XPA_n29 n29 sn26 ph1 ph1 sg13_lv_pmos w=1.12u l=0.13u
XPB_n29 n29 sn28 ph1 ph1 sg13_lv_pmos w=1.12u l=0.13u
XNA_n29 n29 sn26 m_n29 gn1 sg13_lv_nmos w=0.74u l=0.13u
XNB_n29 m_n29 sn28 gn1 gn1 sg13_lv_nmos w=0.74u l=0.13u
CL_n29 n29 gn1 2f
XPA_n301 n301 s0 ph1 ph1 sg13_lv_pmos w=1.12u l=0.13u
XPB_n301 n301 sn1 ph1 ph1 sg13_lv_pmos w=1.12u l=0.13u
XNA_n301 n301 s0 m_n301 gn1 sg13_lv_nmos w=0.74u l=0.13u
XNB_n301 m_n301 sn1 gn1 gn1 sg13_lv_nmos w=0.74u l=0.13u
CL_n301 n301 gn1 2f
XPA_n302 n302 sn0 ph1 ph1 sg13_lv_pmos w=1.12u l=0.13u
XPB_n302 n302 s1 ph1 ph1 sg13_lv_pmos w=1.12u l=0.13u
XNA_n302 n302 sn0 m_n302 gn1 sg13_lv_nmos w=0.74u l=0.13u
XNB_n302 m_n302 s1 gn1 gn1 sg13_lv_nmos w=0.74u l=0.13u
CL_n302 n302 gn1 2f
XPA_n304 n304 s0 ph1 ph1 sg13_lv_pmos w=1.12u l=0.13u
XPB_n304 n304 s1 ph1 ph1 sg13_lv_pmos w=1.12u l=0.13u
XNA_n304 n304 s0 m_n304 gn1 sg13_lv_nmos w=0.74u l=0.13u
XNB_n304 m_n304 s1 gn1 gn1 sg13_lv_nmos w=0.74u l=0.13u
CL_n304 n304 gn1 2f
XPA_n305 n305 sn0 ph1 ph1 sg13_lv_pmos w=1.12u l=0.13u
XPB_n305 n305 sn1 ph1 ph1 sg13_lv_pmos w=1.12u l=0.13u
XNA_n305 n305 sn0 m_n305 gn1 sg13_lv_nmos w=0.74u l=0.13u
XNB_n305 m_n305 sn1 gn1 gn1 sg13_lv_nmos w=0.74u l=0.13u
CL_n305 n305 gn1 2f
XPA_n307 n307 s2 ph1 ph1 sg13_lv_pmos w=1.12u l=0.13u
XPB_n307 n307 sn6 ph1 ph1 sg13_lv_pmos w=1.12u l=0.13u
XNA_n307 n307 s2 m_n307 gn1 sg13_lv_nmos w=0.74u l=0.13u
XNB_n307 m_n307 sn6 gn1 gn1 sg13_lv_nmos w=0.74u l=0.13u
CL_n307 n307 gn1 2f
XPA_n308 n308 sn2 ph1 ph1 sg13_lv_pmos w=1.12u l=0.13u
XPB_n308 n308 s6 ph1 ph1 sg13_lv_pmos w=1.12u l=0.13u
XNA_n308 n308 sn2 m_n308 gn1 sg13_lv_nmos w=0.74u l=0.13u
XNB_n308 m_n308 s6 gn1 gn1 sg13_lv_nmos w=0.74u l=0.13u
CL_n308 n308 gn1 2f
XPA_n31 n31 s29 ph1 ph1 sg13_lv_pmos w=1.12u l=0.13u
XPB_n31 n31 sn30 ph1 ph1 sg13_lv_pmos w=1.12u l=0.13u
XNA_n31 n31 s29 m_n31 gn1 sg13_lv_nmos w=0.74u l=0.13u
XNB_n31 m_n31 sn30 gn1 gn1 sg13_lv_nmos w=0.74u l=0.13u
CL_n31 n31 gn1 2f
XPA_n310 n310 s2 ph1 ph1 sg13_lv_pmos w=1.12u l=0.13u
XPB_n310 n310 s6 ph1 ph1 sg13_lv_pmos w=1.12u l=0.13u
XNA_n310 n310 s2 m_n310 gn1 sg13_lv_nmos w=0.74u l=0.13u
XNB_n310 m_n310 s6 gn1 gn1 sg13_lv_nmos w=0.74u l=0.13u
CL_n310 n310 gn1 2f
XPA_n311 n311 sn2 ph1 ph1 sg13_lv_pmos w=1.12u l=0.13u
XPB_n311 n311 sn6 ph1 ph1 sg13_lv_pmos w=1.12u l=0.13u
XNA_n311 n311 sn2 m_n311 gn1 sg13_lv_nmos w=0.74u l=0.13u
XNB_n311 m_n311 sn6 gn1 gn1 sg13_lv_nmos w=0.74u l=0.13u
CL_n311 n311 gn1 2f
XPA_n313 n313 s7 ph1 ph1 sg13_lv_pmos w=1.12u l=0.13u
XPB_n313 n313 sn8 ph1 ph1 sg13_lv_pmos w=1.12u l=0.13u
XNA_n313 n313 s7 m_n313 gn1 sg13_lv_nmos w=0.74u l=0.13u
XNB_n313 m_n313 sn8 gn1 gn1 sg13_lv_nmos w=0.74u l=0.13u
CL_n313 n313 gn1 2f
XPA_n314 n314 sn7 ph1 ph1 sg13_lv_pmos w=1.12u l=0.13u
XPB_n314 n314 s8 ph1 ph1 sg13_lv_pmos w=1.12u l=0.13u
XNA_n314 n314 sn7 m_n314 gn1 sg13_lv_nmos w=0.74u l=0.13u
XNB_n314 m_n314 s8 gn1 gn1 sg13_lv_nmos w=0.74u l=0.13u
CL_n314 n314 gn1 2f
XPA_n316 n316 s7 ph1 ph1 sg13_lv_pmos w=1.12u l=0.13u
XPB_n316 n316 s8 ph1 ph1 sg13_lv_pmos w=1.12u l=0.13u
XNA_n316 n316 s7 m_n316 gn1 sg13_lv_nmos w=0.74u l=0.13u
XNB_n316 m_n316 s8 gn1 gn1 sg13_lv_nmos w=0.74u l=0.13u
CL_n316 n316 gn1 2f
XPA_n317 n317 sn7 ph1 ph1 sg13_lv_pmos w=1.12u l=0.13u
XPB_n317 n317 sn8 ph1 ph1 sg13_lv_pmos w=1.12u l=0.13u
XNA_n317 n317 sn7 m_n317 gn1 sg13_lv_nmos w=0.74u l=0.13u
XNB_n317 m_n317 sn8 gn1 gn1 sg13_lv_nmos w=0.74u l=0.13u
CL_n317 n317 gn1 2f
XPA_n319 n319 s9 ph1 ph1 sg13_lv_pmos w=1.12u l=0.13u
XPB_n319 n319 sn13 ph1 ph1 sg13_lv_pmos w=1.12u l=0.13u
XNA_n319 n319 s9 m_n319 gn1 sg13_lv_nmos w=0.74u l=0.13u
XNB_n319 m_n319 sn13 gn1 gn1 sg13_lv_nmos w=0.74u l=0.13u
CL_n319 n319 gn1 2f
XPA_n32 n32 sn29 ph1 ph1 sg13_lv_pmos w=1.12u l=0.13u
XPB_n32 n32 s30 ph1 ph1 sg13_lv_pmos w=1.12u l=0.13u
XNA_n32 n32 sn29 m_n32 gn1 sg13_lv_nmos w=0.74u l=0.13u
XNB_n32 m_n32 s30 gn1 gn1 sg13_lv_nmos w=0.74u l=0.13u
CL_n32 n32 gn1 2f
XPA_n320 n320 sn9 ph1 ph1 sg13_lv_pmos w=1.12u l=0.13u
XPB_n320 n320 s13 ph1 ph1 sg13_lv_pmos w=1.12u l=0.13u
XNA_n320 n320 sn9 m_n320 gn1 sg13_lv_nmos w=0.74u l=0.13u
XNB_n320 m_n320 s13 gn1 gn1 sg13_lv_nmos w=0.74u l=0.13u
CL_n320 n320 gn1 2f
XPA_n322 n322 s9 ph1 ph1 sg13_lv_pmos w=1.12u l=0.13u
XPB_n322 n322 s13 ph1 ph1 sg13_lv_pmos w=1.12u l=0.13u
XNA_n322 n322 s9 m_n322 gn1 sg13_lv_nmos w=0.74u l=0.13u
XNB_n322 m_n322 s13 gn1 gn1 sg13_lv_nmos w=0.74u l=0.13u
CL_n322 n322 gn1 2f
XPA_n323 n323 sn9 ph1 ph1 sg13_lv_pmos w=1.12u l=0.13u
XPB_n323 n323 sn13 ph1 ph1 sg13_lv_pmos w=1.12u l=0.13u
XNA_n323 n323 sn9 m_n323 gn1 sg13_lv_nmos w=0.74u l=0.13u
XNB_n323 m_n323 sn13 gn1 gn1 sg13_lv_nmos w=0.74u l=0.13u
CL_n323 n323 gn1 2f
XPA_n325 n325 s14 ph1 ph1 sg13_lv_pmos w=1.12u l=0.13u
XPB_n325 n325 sn16 ph1 ph1 sg13_lv_pmos w=1.12u l=0.13u
XNA_n325 n325 s14 m_n325 gn1 sg13_lv_nmos w=0.74u l=0.13u
XNB_n325 m_n325 sn16 gn1 gn1 sg13_lv_nmos w=0.74u l=0.13u
CL_n325 n325 gn1 2f
XPA_n326 n326 sn14 ph1 ph1 sg13_lv_pmos w=1.12u l=0.13u
XPB_n326 n326 s16 ph1 ph1 sg13_lv_pmos w=1.12u l=0.13u
XNA_n326 n326 sn14 m_n326 gn1 sg13_lv_nmos w=0.74u l=0.13u
XNB_n326 m_n326 s16 gn1 gn1 sg13_lv_nmos w=0.74u l=0.13u
CL_n326 n326 gn1 2f
XPA_n328 n328 s14 ph1 ph1 sg13_lv_pmos w=1.12u l=0.13u
XPB_n328 n328 s16 ph1 ph1 sg13_lv_pmos w=1.12u l=0.13u
XNA_n328 n328 s14 m_n328 gn1 sg13_lv_nmos w=0.74u l=0.13u
XNB_n328 m_n328 s16 gn1 gn1 sg13_lv_nmos w=0.74u l=0.13u
CL_n328 n328 gn1 2f
XPA_n329 n329 sn14 ph1 ph1 sg13_lv_pmos w=1.12u l=0.13u
XPB_n329 n329 sn16 ph1 ph1 sg13_lv_pmos w=1.12u l=0.13u
XNA_n329 n329 sn14 m_n329 gn1 sg13_lv_nmos w=0.74u l=0.13u
XNB_n329 m_n329 sn16 gn1 gn1 sg13_lv_nmos w=0.74u l=0.13u
CL_n329 n329 gn1 2f
XPA_n331 n331 s17 ph1 ph1 sg13_lv_pmos w=1.12u l=0.13u
XPB_n331 n331 sn18 ph1 ph1 sg13_lv_pmos w=1.12u l=0.13u
XNA_n331 n331 s17 m_n331 gn1 sg13_lv_nmos w=0.74u l=0.13u
XNB_n331 m_n331 sn18 gn1 gn1 sg13_lv_nmos w=0.74u l=0.13u
CL_n331 n331 gn1 2f
XPA_n332 n332 sn17 ph1 ph1 sg13_lv_pmos w=1.12u l=0.13u
XPB_n332 n332 s18 ph1 ph1 sg13_lv_pmos w=1.12u l=0.13u
XNA_n332 n332 sn17 m_n332 gn1 sg13_lv_nmos w=0.74u l=0.13u
XNB_n332 m_n332 s18 gn1 gn1 sg13_lv_nmos w=0.74u l=0.13u
CL_n332 n332 gn1 2f
XPA_n334 n334 s17 ph1 ph1 sg13_lv_pmos w=1.12u l=0.13u
XPB_n334 n334 s18 ph1 ph1 sg13_lv_pmos w=1.12u l=0.13u
XNA_n334 n334 s17 m_n334 gn1 sg13_lv_nmos w=0.74u l=0.13u
XNB_n334 m_n334 s18 gn1 gn1 sg13_lv_nmos w=0.74u l=0.13u
CL_n334 n334 gn1 2f
XPA_n335 n335 sn17 ph1 ph1 sg13_lv_pmos w=1.12u l=0.13u
XPB_n335 n335 sn18 ph1 ph1 sg13_lv_pmos w=1.12u l=0.13u
XNA_n335 n335 sn17 m_n335 gn1 sg13_lv_nmos w=0.74u l=0.13u
XNB_n335 m_n335 sn18 gn1 gn1 sg13_lv_nmos w=0.74u l=0.13u
CL_n335 n335 gn1 2f
XPA_n337 n337 s24 ph1 ph1 sg13_lv_pmos w=1.12u l=0.13u
XPB_n337 n337 sn26 ph1 ph1 sg13_lv_pmos w=1.12u l=0.13u
XNA_n337 n337 s24 m_n337 gn1 sg13_lv_nmos w=0.74u l=0.13u
XNB_n337 m_n337 sn26 gn1 gn1 sg13_lv_nmos w=0.74u l=0.13u
CL_n337 n337 gn1 2f
XPA_n338 n338 sn24 ph1 ph1 sg13_lv_pmos w=1.12u l=0.13u
XPB_n338 n338 s26 ph1 ph1 sg13_lv_pmos w=1.12u l=0.13u
XNA_n338 n338 sn24 m_n338 gn1 sg13_lv_nmos w=0.74u l=0.13u
XNB_n338 m_n338 s26 gn1 gn1 sg13_lv_nmos w=0.74u l=0.13u
CL_n338 n338 gn1 2f
XPA_n34 n34 s29 ph1 ph1 sg13_lv_pmos w=1.12u l=0.13u
XPB_n34 n34 s30 ph1 ph1 sg13_lv_pmos w=1.12u l=0.13u
XNA_n34 n34 s29 m_n34 gn1 sg13_lv_nmos w=0.74u l=0.13u
XNB_n34 m_n34 s30 gn1 gn1 sg13_lv_nmos w=0.74u l=0.13u
CL_n34 n34 gn1 2f
XPA_n340 n340 s24 ph1 ph1 sg13_lv_pmos w=1.12u l=0.13u
XPB_n340 n340 s26 ph1 ph1 sg13_lv_pmos w=1.12u l=0.13u
XNA_n340 n340 s24 m_n340 gn1 sg13_lv_nmos w=0.74u l=0.13u
XNB_n340 m_n340 s26 gn1 gn1 sg13_lv_nmos w=0.74u l=0.13u
CL_n340 n340 gn1 2f
XPA_n341 n341 sn24 ph1 ph1 sg13_lv_pmos w=1.12u l=0.13u
XPB_n341 n341 sn26 ph1 ph1 sg13_lv_pmos w=1.12u l=0.13u
XNA_n341 n341 sn24 m_n341 gn1 sg13_lv_nmos w=0.74u l=0.13u
XNB_n341 m_n341 sn26 gn1 gn1 sg13_lv_nmos w=0.74u l=0.13u
CL_n341 n341 gn1 2f
XPA_n343 n343 s30 ph1 ph1 sg13_lv_pmos w=1.12u l=0.13u
XPB_n343 n343 sn31 ph1 ph1 sg13_lv_pmos w=1.12u l=0.13u
XNA_n343 n343 s30 m_n343 gn1 sg13_lv_nmos w=0.74u l=0.13u
XNB_n343 m_n343 sn31 gn1 gn1 sg13_lv_nmos w=0.74u l=0.13u
CL_n343 n343 gn1 2f
XPA_n344 n344 sn30 ph1 ph1 sg13_lv_pmos w=1.12u l=0.13u
XPB_n344 n344 s31 ph1 ph1 sg13_lv_pmos w=1.12u l=0.13u
XNA_n344 n344 sn30 m_n344 gn1 sg13_lv_nmos w=0.74u l=0.13u
XNB_n344 m_n344 s31 gn1 gn1 sg13_lv_nmos w=0.74u l=0.13u
CL_n344 n344 gn1 2f
XPA_n346 n346 s30 ph1 ph1 sg13_lv_pmos w=1.12u l=0.13u
XPB_n346 n346 s31 ph1 ph1 sg13_lv_pmos w=1.12u l=0.13u
XNA_n346 n346 s30 m_n346 gn1 sg13_lv_nmos w=0.74u l=0.13u
XNB_n346 m_n346 s31 gn1 gn1 sg13_lv_nmos w=0.74u l=0.13u
CL_n346 n346 gn1 2f
XPA_n347 n347 sn30 ph1 ph1 sg13_lv_pmos w=1.12u l=0.13u
XPB_n347 n347 sn31 ph1 ph1 sg13_lv_pmos w=1.12u l=0.13u
XNA_n347 n347 sn30 m_n347 gn1 sg13_lv_nmos w=0.74u l=0.13u
XNB_n347 m_n347 sn31 gn1 gn1 sg13_lv_nmos w=0.74u l=0.13u
CL_n347 n347 gn1 2f
XPA_n349 n349 d0 ph1 ph1 sg13_lv_pmos w=1.12u l=0.13u
XPB_n349 n349 dn1 ph1 ph1 sg13_lv_pmos w=1.12u l=0.13u
XNA_n349 n349 d0 m_n349 gn1 sg13_lv_nmos w=0.74u l=0.13u
XNB_n349 m_n349 dn1 gn1 gn1 sg13_lv_nmos w=0.74u l=0.13u
CL_n349 n349 gn1 2f
XPA_n35 n35 sn29 ph1 ph1 sg13_lv_pmos w=1.12u l=0.13u
XPB_n35 n35 sn30 ph1 ph1 sg13_lv_pmos w=1.12u l=0.13u
XNA_n35 n35 sn29 m_n35 gn1 sg13_lv_nmos w=0.74u l=0.13u
XNB_n35 m_n35 sn30 gn1 gn1 sg13_lv_nmos w=0.74u l=0.13u
CL_n35 n35 gn1 2f
XPA_n350 n350 dn0 ph1 ph1 sg13_lv_pmos w=1.12u l=0.13u
XPB_n350 n350 d1 ph1 ph1 sg13_lv_pmos w=1.12u l=0.13u
XNA_n350 n350 dn0 m_n350 gn1 sg13_lv_nmos w=0.74u l=0.13u
XNB_n350 m_n350 d1 gn1 gn1 sg13_lv_nmos w=0.74u l=0.13u
CL_n350 n350 gn1 2f
XPA_n352 n352 d0 ph1 ph1 sg13_lv_pmos w=1.12u l=0.13u
XPB_n352 n352 d1 ph1 ph1 sg13_lv_pmos w=1.12u l=0.13u
XNA_n352 n352 d0 m_n352 gn1 sg13_lv_nmos w=0.74u l=0.13u
XNB_n352 m_n352 d1 gn1 gn1 sg13_lv_nmos w=0.74u l=0.13u
CL_n352 n352 gn1 2f
XPA_n353 n353 dn0 ph1 ph1 sg13_lv_pmos w=1.12u l=0.13u
XPB_n353 n353 dn1 ph1 ph1 sg13_lv_pmos w=1.12u l=0.13u
XNA_n353 n353 dn0 m_n353 gn1 sg13_lv_nmos w=0.74u l=0.13u
XNB_n353 m_n353 dn1 gn1 gn1 sg13_lv_nmos w=0.74u l=0.13u
CL_n353 n353 gn1 2f
XPA_n355 n355 d5 ph1 ph1 sg13_lv_pmos w=1.12u l=0.13u
XPB_n355 n355 dn7 ph1 ph1 sg13_lv_pmos w=1.12u l=0.13u
XNA_n355 n355 d5 m_n355 gn1 sg13_lv_nmos w=0.74u l=0.13u
XNB_n355 m_n355 dn7 gn1 gn1 sg13_lv_nmos w=0.74u l=0.13u
CL_n355 n355 gn1 2f
XPA_n356 n356 dn5 ph1 ph1 sg13_lv_pmos w=1.12u l=0.13u
XPB_n356 n356 d7 ph1 ph1 sg13_lv_pmos w=1.12u l=0.13u
XNA_n356 n356 dn5 m_n356 gn1 sg13_lv_nmos w=0.74u l=0.13u
XNB_n356 m_n356 d7 gn1 gn1 sg13_lv_nmos w=0.74u l=0.13u
CL_n356 n356 gn1 2f
XPA_n358 n358 d5 ph1 ph1 sg13_lv_pmos w=1.12u l=0.13u
XPB_n358 n358 d7 ph1 ph1 sg13_lv_pmos w=1.12u l=0.13u
XNA_n358 n358 d5 m_n358 gn1 sg13_lv_nmos w=0.74u l=0.13u
XNB_n358 m_n358 d7 gn1 gn1 sg13_lv_nmos w=0.74u l=0.13u
CL_n358 n358 gn1 2f
XPA_n359 n359 dn5 ph1 ph1 sg13_lv_pmos w=1.12u l=0.13u
XPB_n359 n359 dn7 ph1 ph1 sg13_lv_pmos w=1.12u l=0.13u
XNA_n359 n359 dn5 m_n359 gn1 sg13_lv_nmos w=0.74u l=0.13u
XNB_n359 m_n359 dn7 gn1 gn1 sg13_lv_nmos w=0.74u l=0.13u
CL_n359 n359 gn1 2f
XPA_n361 n361 d13 ph1 ph1 sg13_lv_pmos w=1.12u l=0.13u
XPB_n361 n361 dn14 ph1 ph1 sg13_lv_pmos w=1.12u l=0.13u
XNA_n361 n361 d13 m_n361 gn1 sg13_lv_nmos w=0.74u l=0.13u
XNB_n361 m_n361 dn14 gn1 gn1 sg13_lv_nmos w=0.74u l=0.13u
CL_n361 n361 gn1 2f
XPA_n362 n362 dn13 ph1 ph1 sg13_lv_pmos w=1.12u l=0.13u
XPB_n362 n362 d14 ph1 ph1 sg13_lv_pmos w=1.12u l=0.13u
XNA_n362 n362 dn13 m_n362 gn1 sg13_lv_nmos w=0.74u l=0.13u
XNB_n362 m_n362 d14 gn1 gn1 sg13_lv_nmos w=0.74u l=0.13u
CL_n362 n362 gn1 2f
XPA_n364 n364 d13 ph1 ph1 sg13_lv_pmos w=1.12u l=0.13u
XPB_n364 n364 d14 ph1 ph1 sg13_lv_pmos w=1.12u l=0.13u
XNA_n364 n364 d13 m_n364 gn1 sg13_lv_nmos w=0.74u l=0.13u
XNB_n364 m_n364 d14 gn1 gn1 sg13_lv_nmos w=0.74u l=0.13u
CL_n364 n364 gn1 2f
XPA_n365 n365 dn13 ph1 ph1 sg13_lv_pmos w=1.12u l=0.13u
XPB_n365 n365 dn14 ph1 ph1 sg13_lv_pmos w=1.12u l=0.13u
XNA_n365 n365 dn13 m_n365 gn1 sg13_lv_nmos w=0.74u l=0.13u
XNB_n365 m_n365 dn14 gn1 gn1 sg13_lv_nmos w=0.74u l=0.13u
CL_n365 n365 gn1 2f
XPA_n367 n367 d15 ph1 ph1 sg13_lv_pmos w=1.12u l=0.13u
XPB_n367 n367 dn17 ph1 ph1 sg13_lv_pmos w=1.12u l=0.13u
XNA_n367 n367 d15 m_n367 gn1 sg13_lv_nmos w=0.74u l=0.13u
XNB_n367 m_n367 dn17 gn1 gn1 sg13_lv_nmos w=0.74u l=0.13u
CL_n367 n367 gn1 2f
XPA_n368 n368 dn15 ph1 ph1 sg13_lv_pmos w=1.12u l=0.13u
XPB_n368 n368 d17 ph1 ph1 sg13_lv_pmos w=1.12u l=0.13u
XNA_n368 n368 dn15 m_n368 gn1 sg13_lv_nmos w=0.74u l=0.13u
XNB_n368 m_n368 d17 gn1 gn1 sg13_lv_nmos w=0.74u l=0.13u
CL_n368 n368 gn1 2f
XPA_n37 n37 s31 ph1 ph1 sg13_lv_pmos w=1.12u l=0.13u
XPB_n37 n37 dn0 ph1 ph1 sg13_lv_pmos w=1.12u l=0.13u
XNA_n37 n37 s31 m_n37 gn1 sg13_lv_nmos w=0.74u l=0.13u
XNB_n37 m_n37 dn0 gn1 gn1 sg13_lv_nmos w=0.74u l=0.13u
CL_n37 n37 gn1 2f
XPA_n370 n370 d15 ph1 ph1 sg13_lv_pmos w=1.12u l=0.13u
XPB_n370 n370 d17 ph1 ph1 sg13_lv_pmos w=1.12u l=0.13u
XNA_n370 n370 d15 m_n370 gn1 sg13_lv_nmos w=0.74u l=0.13u
XNB_n370 m_n370 d17 gn1 gn1 sg13_lv_nmos w=0.74u l=0.13u
CL_n370 n370 gn1 2f
XPA_n371 n371 dn15 ph1 ph1 sg13_lv_pmos w=1.12u l=0.13u
XPB_n371 n371 dn17 ph1 ph1 sg13_lv_pmos w=1.12u l=0.13u
XNA_n371 n371 dn15 m_n371 gn1 sg13_lv_nmos w=0.74u l=0.13u
XNB_n371 m_n371 dn17 gn1 gn1 sg13_lv_nmos w=0.74u l=0.13u
CL_n371 n371 gn1 2f
XPA_n373 n373 d18 ph1 ph1 sg13_lv_pmos w=1.12u l=0.13u
XPB_n373 n373 dn22 ph1 ph1 sg13_lv_pmos w=1.12u l=0.13u
XNA_n373 n373 d18 m_n373 gn1 sg13_lv_nmos w=0.74u l=0.13u
XNB_n373 m_n373 dn22 gn1 gn1 sg13_lv_nmos w=0.74u l=0.13u
CL_n373 n373 gn1 2f
XPA_n374 n374 dn18 ph1 ph1 sg13_lv_pmos w=1.12u l=0.13u
XPB_n374 n374 d22 ph1 ph1 sg13_lv_pmos w=1.12u l=0.13u
XNA_n374 n374 dn18 m_n374 gn1 sg13_lv_nmos w=0.74u l=0.13u
XNB_n374 m_n374 d22 gn1 gn1 sg13_lv_nmos w=0.74u l=0.13u
CL_n374 n374 gn1 2f
XPA_n376 n376 d18 ph1 ph1 sg13_lv_pmos w=1.12u l=0.13u
XPB_n376 n376 d22 ph1 ph1 sg13_lv_pmos w=1.12u l=0.13u
XNA_n376 n376 d18 m_n376 gn1 sg13_lv_nmos w=0.74u l=0.13u
XNB_n376 m_n376 d22 gn1 gn1 sg13_lv_nmos w=0.74u l=0.13u
CL_n376 n376 gn1 2f
XPA_n377 n377 dn18 ph1 ph1 sg13_lv_pmos w=1.12u l=0.13u
XPB_n377 n377 dn22 ph1 ph1 sg13_lv_pmos w=1.12u l=0.13u
XNA_n377 n377 dn18 m_n377 gn1 sg13_lv_nmos w=0.74u l=0.13u
XNB_n377 m_n377 dn22 gn1 gn1 sg13_lv_nmos w=0.74u l=0.13u
CL_n377 n377 gn1 2f
XPA_n379 n379 d23 ph1 ph1 sg13_lv_pmos w=1.12u l=0.13u
XPB_n379 n379 dn24 ph1 ph1 sg13_lv_pmos w=1.12u l=0.13u
XNA_n379 n379 d23 m_n379 gn1 sg13_lv_nmos w=0.74u l=0.13u
XNB_n379 m_n379 dn24 gn1 gn1 sg13_lv_nmos w=0.74u l=0.13u
CL_n379 n379 gn1 2f
XPA_n38 n38 sn31 ph1 ph1 sg13_lv_pmos w=1.12u l=0.13u
XPB_n38 n38 d0 ph1 ph1 sg13_lv_pmos w=1.12u l=0.13u
XNA_n38 n38 sn31 m_n38 gn1 sg13_lv_nmos w=0.74u l=0.13u
XNB_n38 m_n38 d0 gn1 gn1 sg13_lv_nmos w=0.74u l=0.13u
CL_n38 n38 gn1 2f
XPA_n380 n380 dn23 ph1 ph1 sg13_lv_pmos w=1.12u l=0.13u
XPB_n380 n380 d24 ph1 ph1 sg13_lv_pmos w=1.12u l=0.13u
XNA_n380 n380 dn23 m_n380 gn1 sg13_lv_nmos w=0.74u l=0.13u
XNB_n380 m_n380 d24 gn1 gn1 sg13_lv_nmos w=0.74u l=0.13u
CL_n380 n380 gn1 2f
XPA_n382 n382 d23 ph1 ph1 sg13_lv_pmos w=1.12u l=0.13u
XPB_n382 n382 d24 ph1 ph1 sg13_lv_pmos w=1.12u l=0.13u
XNA_n382 n382 d23 m_n382 gn1 sg13_lv_nmos w=0.74u l=0.13u
XNB_n382 m_n382 d24 gn1 gn1 sg13_lv_nmos w=0.74u l=0.13u
CL_n382 n382 gn1 2f
XPA_n383 n383 dn23 ph1 ph1 sg13_lv_pmos w=1.12u l=0.13u
XPB_n383 n383 dn24 ph1 ph1 sg13_lv_pmos w=1.12u l=0.13u
XNA_n383 n383 dn23 m_n383 gn1 sg13_lv_nmos w=0.74u l=0.13u
XNB_n383 m_n383 dn24 gn1 gn1 sg13_lv_nmos w=0.74u l=0.13u
CL_n383 n383 gn1 2f
XPA_n385 n385 d25 ph1 ph1 sg13_lv_pmos w=1.12u l=0.13u
XPB_n385 n385 dn29 ph1 ph1 sg13_lv_pmos w=1.12u l=0.13u
XNA_n385 n385 d25 m_n385 gn1 sg13_lv_nmos w=0.74u l=0.13u
XNB_n385 m_n385 dn29 gn1 gn1 sg13_lv_nmos w=0.74u l=0.13u
CL_n385 n385 gn1 2f
XPA_n386 n386 dn25 ph1 ph1 sg13_lv_pmos w=1.12u l=0.13u
XPB_n386 n386 d29 ph1 ph1 sg13_lv_pmos w=1.12u l=0.13u
XNA_n386 n386 dn25 m_n386 gn1 sg13_lv_nmos w=0.74u l=0.13u
XNB_n386 m_n386 d29 gn1 gn1 sg13_lv_nmos w=0.74u l=0.13u
CL_n386 n386 gn1 2f
XPA_n388 n388 d25 ph1 ph1 sg13_lv_pmos w=1.12u l=0.13u
XPB_n388 n388 d29 ph1 ph1 sg13_lv_pmos w=1.12u l=0.13u
XNA_n388 n388 d25 m_n388 gn1 sg13_lv_nmos w=0.74u l=0.13u
XNB_n388 m_n388 d29 gn1 gn1 sg13_lv_nmos w=0.74u l=0.13u
CL_n388 n388 gn1 2f
XPA_n389 n389 dn25 ph1 ph1 sg13_lv_pmos w=1.12u l=0.13u
XPB_n389 n389 dn29 ph1 ph1 sg13_lv_pmos w=1.12u l=0.13u
XNA_n389 n389 dn25 m_n389 gn1 sg13_lv_nmos w=0.74u l=0.13u
XNB_n389 m_n389 dn29 gn1 gn1 sg13_lv_nmos w=0.74u l=0.13u
CL_n389 n389 gn1 2f
XPA_n391 n391 d30 ph1 ph1 sg13_lv_pmos w=1.12u l=0.13u
XPB_n391 n391 dn31 ph1 ph1 sg13_lv_pmos w=1.12u l=0.13u
XNA_n391 n391 d30 m_n391 gn1 sg13_lv_nmos w=0.74u l=0.13u
XNB_n391 m_n391 dn31 gn1 gn1 sg13_lv_nmos w=0.74u l=0.13u
CL_n391 n391 gn1 2f
XPA_n392 n392 dn30 ph1 ph1 sg13_lv_pmos w=1.12u l=0.13u
XPB_n392 n392 d31 ph1 ph1 sg13_lv_pmos w=1.12u l=0.13u
XNA_n392 n392 dn30 m_n392 gn1 sg13_lv_nmos w=0.74u l=0.13u
XNB_n392 m_n392 d31 gn1 gn1 sg13_lv_nmos w=0.74u l=0.13u
CL_n392 n392 gn1 2f
XPA_n394 n394 d30 ph1 ph1 sg13_lv_pmos w=1.12u l=0.13u
XPB_n394 n394 d31 ph1 ph1 sg13_lv_pmos w=1.12u l=0.13u
XNA_n394 n394 d30 m_n394 gn1 sg13_lv_nmos w=0.74u l=0.13u
XNB_n394 m_n394 d31 gn1 gn1 sg13_lv_nmos w=0.74u l=0.13u
CL_n394 n394 gn1 2f
XPA_n395 n395 dn30 ph1 ph1 sg13_lv_pmos w=1.12u l=0.13u
XPB_n395 n395 dn31 ph1 ph1 sg13_lv_pmos w=1.12u l=0.13u
XNA_n395 n395 dn30 m_n395 gn1 sg13_lv_nmos w=0.74u l=0.13u
XNB_n395 m_n395 dn31 gn1 gn1 sg13_lv_nmos w=0.74u l=0.13u
CL_n395 n395 gn1 2f
XPA_n4 n4 s0 ph1 ph1 sg13_lv_pmos w=1.12u l=0.13u
XPB_n4 n4 s6 ph1 ph1 sg13_lv_pmos w=1.12u l=0.13u
XNA_n4 n4 s0 m_n4 gn1 sg13_lv_nmos w=0.74u l=0.13u
XNB_n4 m_n4 s6 gn1 gn1 sg13_lv_nmos w=0.74u l=0.13u
CL_n4 n4 gn1 2f
XPA_n40 n40 s31 ph1 ph1 sg13_lv_pmos w=1.12u l=0.13u
XPB_n40 n40 d0 ph1 ph1 sg13_lv_pmos w=1.12u l=0.13u
XNA_n40 n40 s31 m_n40 gn1 sg13_lv_nmos w=0.74u l=0.13u
XNB_n40 m_n40 d0 gn1 gn1 sg13_lv_nmos w=0.74u l=0.13u
CL_n40 n40 gn1 2f
XPA_n41 n41 sn31 ph1 ph1 sg13_lv_pmos w=1.12u l=0.13u
XPB_n41 n41 dn0 ph1 ph1 sg13_lv_pmos w=1.12u l=0.13u
XNA_n41 n41 sn31 m_n41 gn1 sg13_lv_nmos w=0.74u l=0.13u
XNB_n41 m_n41 dn0 gn1 gn1 sg13_lv_nmos w=0.74u l=0.13u
CL_n41 n41 gn1 2f
XPA_n43 n43 d1 ph1 ph1 sg13_lv_pmos w=1.12u l=0.13u
XPB_n43 n43 dn2 ph1 ph1 sg13_lv_pmos w=1.12u l=0.13u
XNA_n43 n43 d1 m_n43 gn1 sg13_lv_nmos w=0.74u l=0.13u
XNB_n43 m_n43 dn2 gn1 gn1 sg13_lv_nmos w=0.74u l=0.13u
CL_n43 n43 gn1 2f
XPA_n44 n44 dn1 ph1 ph1 sg13_lv_pmos w=1.12u l=0.13u
XPB_n44 n44 d2 ph1 ph1 sg13_lv_pmos w=1.12u l=0.13u
XNA_n44 n44 dn1 m_n44 gn1 sg13_lv_nmos w=0.74u l=0.13u
XNB_n44 m_n44 d2 gn1 gn1 sg13_lv_nmos w=0.74u l=0.13u
CL_n44 n44 gn1 2f
XPA_n46 n46 d1 ph1 ph1 sg13_lv_pmos w=1.12u l=0.13u
XPB_n46 n46 d2 ph1 ph1 sg13_lv_pmos w=1.12u l=0.13u
XNA_n46 n46 d1 m_n46 gn1 sg13_lv_nmos w=0.74u l=0.13u
XNB_n46 m_n46 d2 gn1 gn1 sg13_lv_nmos w=0.74u l=0.13u
CL_n46 n46 gn1 2f
XPA_n47 n47 dn1 ph1 ph1 sg13_lv_pmos w=1.12u l=0.13u
XPB_n47 n47 dn2 ph1 ph1 sg13_lv_pmos w=1.12u l=0.13u
XNA_n47 n47 dn1 m_n47 gn1 sg13_lv_nmos w=0.74u l=0.13u
XNB_n47 m_n47 dn2 gn1 gn1 sg13_lv_nmos w=0.74u l=0.13u
CL_n47 n47 gn1 2f
XPA_n487 n487 s1 ph1 ph1 sg13_lv_pmos w=1.12u l=0.13u
XPB_n487 n487 sn2 ph1 ph1 sg13_lv_pmos w=1.12u l=0.13u
XNA_n487 n487 s1 m_n487 gn1 sg13_lv_nmos w=0.74u l=0.13u
XNB_n487 m_n487 sn2 gn1 gn1 sg13_lv_nmos w=0.74u l=0.13u
CL_n487 n487 gn1 2f
XPA_n488 n488 sn1 ph1 ph1 sg13_lv_pmos w=1.12u l=0.13u
XPB_n488 n488 s2 ph1 ph1 sg13_lv_pmos w=1.12u l=0.13u
XNA_n488 n488 sn1 m_n488 gn1 sg13_lv_nmos w=0.74u l=0.13u
XNB_n488 m_n488 s2 gn1 gn1 sg13_lv_nmos w=0.74u l=0.13u
CL_n488 n488 gn1 2f
XPA_n49 n49 d3 ph1 ph1 sg13_lv_pmos w=1.12u l=0.13u
XPB_n49 n49 dn5 ph1 ph1 sg13_lv_pmos w=1.12u l=0.13u
XNA_n49 n49 d3 m_n49 gn1 sg13_lv_nmos w=0.74u l=0.13u
XNB_n49 m_n49 dn5 gn1 gn1 sg13_lv_nmos w=0.74u l=0.13u
CL_n49 n49 gn1 2f
XPA_n490 n490 s1 ph1 ph1 sg13_lv_pmos w=1.12u l=0.13u
XPB_n490 n490 s2 ph1 ph1 sg13_lv_pmos w=1.12u l=0.13u
XNA_n490 n490 s1 m_n490 gn1 sg13_lv_nmos w=0.74u l=0.13u
XNB_n490 m_n490 s2 gn1 gn1 sg13_lv_nmos w=0.74u l=0.13u
CL_n490 n490 gn1 2f
XPA_n491 n491 sn1 ph1 ph1 sg13_lv_pmos w=1.12u l=0.13u
XPB_n491 n491 sn2 ph1 ph1 sg13_lv_pmos w=1.12u l=0.13u
XNA_n491 n491 sn1 m_n491 gn1 sg13_lv_nmos w=0.74u l=0.13u
XNB_n491 m_n491 sn2 gn1 gn1 sg13_lv_nmos w=0.74u l=0.13u
CL_n491 n491 gn1 2f
XPA_n493 n493 s3 ph1 ph1 sg13_lv_pmos w=1.12u l=0.13u
XPB_n493 n493 sn7 ph1 ph1 sg13_lv_pmos w=1.12u l=0.13u
XNA_n493 n493 s3 m_n493 gn1 sg13_lv_nmos w=0.74u l=0.13u
XNB_n493 m_n493 sn7 gn1 gn1 sg13_lv_nmos w=0.74u l=0.13u
CL_n493 n493 gn1 2f
XPA_n494 n494 sn3 ph1 ph1 sg13_lv_pmos w=1.12u l=0.13u
XPB_n494 n494 s7 ph1 ph1 sg13_lv_pmos w=1.12u l=0.13u
XNA_n494 n494 sn3 m_n494 gn1 sg13_lv_nmos w=0.74u l=0.13u
XNB_n494 m_n494 s7 gn1 gn1 sg13_lv_nmos w=0.74u l=0.13u
CL_n494 n494 gn1 2f
XPA_n496 n496 s3 ph1 ph1 sg13_lv_pmos w=1.12u l=0.13u
XPB_n496 n496 s7 ph1 ph1 sg13_lv_pmos w=1.12u l=0.13u
XNA_n496 n496 s3 m_n496 gn1 sg13_lv_nmos w=0.74u l=0.13u
XNB_n496 m_n496 s7 gn1 gn1 sg13_lv_nmos w=0.74u l=0.13u
CL_n496 n496 gn1 2f
XPA_n497 n497 sn3 ph1 ph1 sg13_lv_pmos w=1.12u l=0.13u
XPB_n497 n497 sn7 ph1 ph1 sg13_lv_pmos w=1.12u l=0.13u
XNA_n497 n497 sn3 m_n497 gn1 sg13_lv_nmos w=0.74u l=0.13u
XNB_n497 m_n497 sn7 gn1 gn1 sg13_lv_nmos w=0.74u l=0.13u
CL_n497 n497 gn1 2f
XPA_n499 n499 s8 ph1 ph1 sg13_lv_pmos w=1.12u l=0.13u
XPB_n499 n499 sn9 ph1 ph1 sg13_lv_pmos w=1.12u l=0.13u
XNA_n499 n499 s8 m_n499 gn1 sg13_lv_nmos w=0.74u l=0.13u
XNB_n499 m_n499 sn9 gn1 gn1 sg13_lv_nmos w=0.74u l=0.13u
CL_n499 n499 gn1 2f
XPA_n5 n5 sn0 ph1 ph1 sg13_lv_pmos w=1.12u l=0.13u
XPB_n5 n5 sn6 ph1 ph1 sg13_lv_pmos w=1.12u l=0.13u
XNA_n5 n5 sn0 m_n5 gn1 sg13_lv_nmos w=0.74u l=0.13u
XNB_n5 m_n5 sn6 gn1 gn1 sg13_lv_nmos w=0.74u l=0.13u
CL_n5 n5 gn1 2f
XPA_n50 n50 dn3 ph1 ph1 sg13_lv_pmos w=1.12u l=0.13u
XPB_n50 n50 d5 ph1 ph1 sg13_lv_pmos w=1.12u l=0.13u
XNA_n50 n50 dn3 m_n50 gn1 sg13_lv_nmos w=0.74u l=0.13u
XNB_n50 m_n50 d5 gn1 gn1 sg13_lv_nmos w=0.74u l=0.13u
CL_n50 n50 gn1 2f
XPA_n500 n500 sn8 ph1 ph1 sg13_lv_pmos w=1.12u l=0.13u
XPB_n500 n500 s9 ph1 ph1 sg13_lv_pmos w=1.12u l=0.13u
XNA_n500 n500 sn8 m_n500 gn1 sg13_lv_nmos w=0.74u l=0.13u
XNB_n500 m_n500 s9 gn1 gn1 sg13_lv_nmos w=0.74u l=0.13u
CL_n500 n500 gn1 2f
XPA_n502 n502 s8 ph1 ph1 sg13_lv_pmos w=1.12u l=0.13u
XPB_n502 n502 s9 ph1 ph1 sg13_lv_pmos w=1.12u l=0.13u
XNA_n502 n502 s8 m_n502 gn1 sg13_lv_nmos w=0.74u l=0.13u
XNB_n502 m_n502 s9 gn1 gn1 sg13_lv_nmos w=0.74u l=0.13u
CL_n502 n502 gn1 2f
XPA_n503 n503 sn8 ph1 ph1 sg13_lv_pmos w=1.12u l=0.13u
XPB_n503 n503 sn9 ph1 ph1 sg13_lv_pmos w=1.12u l=0.13u
XNA_n503 n503 sn8 m_n503 gn1 sg13_lv_nmos w=0.74u l=0.13u
XNB_n503 m_n503 sn9 gn1 gn1 sg13_lv_nmos w=0.74u l=0.13u
CL_n503 n503 gn1 2f
XPA_n505 n505 s10 ph1 ph1 sg13_lv_pmos w=1.12u l=0.13u
XPB_n505 n505 sn14 ph1 ph1 sg13_lv_pmos w=1.12u l=0.13u
XNA_n505 n505 s10 m_n505 gn1 sg13_lv_nmos w=0.74u l=0.13u
XNB_n505 m_n505 sn14 gn1 gn1 sg13_lv_nmos w=0.74u l=0.13u
CL_n505 n505 gn1 2f
XPA_n506 n506 sn10 ph1 ph1 sg13_lv_pmos w=1.12u l=0.13u
XPB_n506 n506 s14 ph1 ph1 sg13_lv_pmos w=1.12u l=0.13u
XNA_n506 n506 sn10 m_n506 gn1 sg13_lv_nmos w=0.74u l=0.13u
XNB_n506 m_n506 s14 gn1 gn1 sg13_lv_nmos w=0.74u l=0.13u
CL_n506 n506 gn1 2f
XPA_n508 n508 s10 ph1 ph1 sg13_lv_pmos w=1.12u l=0.13u
XPB_n508 n508 s14 ph1 ph1 sg13_lv_pmos w=1.12u l=0.13u
XNA_n508 n508 s10 m_n508 gn1 sg13_lv_nmos w=0.74u l=0.13u
XNB_n508 m_n508 s14 gn1 gn1 sg13_lv_nmos w=0.74u l=0.13u
CL_n508 n508 gn1 2f
XPA_n509 n509 sn10 ph1 ph1 sg13_lv_pmos w=1.12u l=0.13u
XPB_n509 n509 sn14 ph1 ph1 sg13_lv_pmos w=1.12u l=0.13u
XNA_n509 n509 sn10 m_n509 gn1 sg13_lv_nmos w=0.74u l=0.13u
XNB_n509 m_n509 sn14 gn1 gn1 sg13_lv_nmos w=0.74u l=0.13u
CL_n509 n509 gn1 2f
XPA_n511 n511 s15 ph1 ph1 sg13_lv_pmos w=1.12u l=0.13u
XPB_n511 n511 sn17 ph1 ph1 sg13_lv_pmos w=1.12u l=0.13u
XNA_n511 n511 s15 m_n511 gn1 sg13_lv_nmos w=0.74u l=0.13u
XNB_n511 m_n511 sn17 gn1 gn1 sg13_lv_nmos w=0.74u l=0.13u
CL_n511 n511 gn1 2f
XPA_n512 n512 sn15 ph1 ph1 sg13_lv_pmos w=1.12u l=0.13u
XPB_n512 n512 s17 ph1 ph1 sg13_lv_pmos w=1.12u l=0.13u
XNA_n512 n512 sn15 m_n512 gn1 sg13_lv_nmos w=0.74u l=0.13u
XNB_n512 m_n512 s17 gn1 gn1 sg13_lv_nmos w=0.74u l=0.13u
CL_n512 n512 gn1 2f
XPA_n514 n514 s15 ph1 ph1 sg13_lv_pmos w=1.12u l=0.13u
XPB_n514 n514 s17 ph1 ph1 sg13_lv_pmos w=1.12u l=0.13u
XNA_n514 n514 s15 m_n514 gn1 sg13_lv_nmos w=0.74u l=0.13u
XNB_n514 m_n514 s17 gn1 gn1 sg13_lv_nmos w=0.74u l=0.13u
CL_n514 n514 gn1 2f
XPA_n515 n515 sn15 ph1 ph1 sg13_lv_pmos w=1.12u l=0.13u
XPB_n515 n515 sn17 ph1 ph1 sg13_lv_pmos w=1.12u l=0.13u
XNA_n515 n515 sn15 m_n515 gn1 sg13_lv_nmos w=0.74u l=0.13u
XNB_n515 m_n515 sn17 gn1 gn1 sg13_lv_nmos w=0.74u l=0.13u
CL_n515 n515 gn1 2f
XPA_n517 n517 s18 ph1 ph1 sg13_lv_pmos w=1.12u l=0.13u
XPB_n517 n517 sn19 ph1 ph1 sg13_lv_pmos w=1.12u l=0.13u
XNA_n517 n517 s18 m_n517 gn1 sg13_lv_nmos w=0.74u l=0.13u
XNB_n517 m_n517 sn19 gn1 gn1 sg13_lv_nmos w=0.74u l=0.13u
CL_n517 n517 gn1 2f
XPA_n518 n518 sn18 ph1 ph1 sg13_lv_pmos w=1.12u l=0.13u
XPB_n518 n518 s19 ph1 ph1 sg13_lv_pmos w=1.12u l=0.13u
XNA_n518 n518 sn18 m_n518 gn1 sg13_lv_nmos w=0.74u l=0.13u
XNB_n518 m_n518 s19 gn1 gn1 sg13_lv_nmos w=0.74u l=0.13u
CL_n518 n518 gn1 2f
XPA_n52 n52 d3 ph1 ph1 sg13_lv_pmos w=1.12u l=0.13u
XPB_n52 n52 d5 ph1 ph1 sg13_lv_pmos w=1.12u l=0.13u
XNA_n52 n52 d3 m_n52 gn1 sg13_lv_nmos w=0.74u l=0.13u
XNB_n52 m_n52 d5 gn1 gn1 sg13_lv_nmos w=0.74u l=0.13u
CL_n52 n52 gn1 2f
XPA_n520 n520 s18 ph1 ph1 sg13_lv_pmos w=1.12u l=0.13u
XPB_n520 n520 s19 ph1 ph1 sg13_lv_pmos w=1.12u l=0.13u
XNA_n520 n520 s18 m_n520 gn1 sg13_lv_nmos w=0.74u l=0.13u
XNB_n520 m_n520 s19 gn1 gn1 sg13_lv_nmos w=0.74u l=0.13u
CL_n520 n520 gn1 2f
XPA_n521 n521 sn18 ph1 ph1 sg13_lv_pmos w=1.12u l=0.13u
XPB_n521 n521 sn19 ph1 ph1 sg13_lv_pmos w=1.12u l=0.13u
XNA_n521 n521 sn18 m_n521 gn1 sg13_lv_nmos w=0.74u l=0.13u
XNB_n521 m_n521 sn19 gn1 gn1 sg13_lv_nmos w=0.74u l=0.13u
CL_n521 n521 gn1 2f
XPA_n523 n523 s25 ph1 ph1 sg13_lv_pmos w=1.12u l=0.13u
XPB_n523 n523 sn27 ph1 ph1 sg13_lv_pmos w=1.12u l=0.13u
XNA_n523 n523 s25 m_n523 gn1 sg13_lv_nmos w=0.74u l=0.13u
XNB_n523 m_n523 sn27 gn1 gn1 sg13_lv_nmos w=0.74u l=0.13u
CL_n523 n523 gn1 2f
XPA_n524 n524 sn25 ph1 ph1 sg13_lv_pmos w=1.12u l=0.13u
XPB_n524 n524 s27 ph1 ph1 sg13_lv_pmos w=1.12u l=0.13u
XNA_n524 n524 sn25 m_n524 gn1 sg13_lv_nmos w=0.74u l=0.13u
XNB_n524 m_n524 s27 gn1 gn1 sg13_lv_nmos w=0.74u l=0.13u
CL_n524 n524 gn1 2f
XPA_n526 n526 s25 ph1 ph1 sg13_lv_pmos w=1.12u l=0.13u
XPB_n526 n526 s27 ph1 ph1 sg13_lv_pmos w=1.12u l=0.13u
XNA_n526 n526 s25 m_n526 gn1 sg13_lv_nmos w=0.74u l=0.13u
XNB_n526 m_n526 s27 gn1 gn1 sg13_lv_nmos w=0.74u l=0.13u
CL_n526 n526 gn1 2f
XPA_n527 n527 sn25 ph1 ph1 sg13_lv_pmos w=1.12u l=0.13u
XPB_n527 n527 sn27 ph1 ph1 sg13_lv_pmos w=1.12u l=0.13u
XNA_n527 n527 sn25 m_n527 gn1 sg13_lv_nmos w=0.74u l=0.13u
XNB_n527 m_n527 sn27 gn1 gn1 sg13_lv_nmos w=0.74u l=0.13u
CL_n527 n527 gn1 2f
XPA_n529 n529 s31 ph1 ph1 sg13_lv_pmos w=1.12u l=0.13u
XPB_n529 n529 dn0 ph1 ph1 sg13_lv_pmos w=1.12u l=0.13u
XNA_n529 n529 s31 m_n529 gn1 sg13_lv_nmos w=0.74u l=0.13u
XNB_n529 m_n529 dn0 gn1 gn1 sg13_lv_nmos w=0.74u l=0.13u
CL_n529 n529 gn1 2f
XPA_n53 n53 dn3 ph1 ph1 sg13_lv_pmos w=1.12u l=0.13u
XPB_n53 n53 dn5 ph1 ph1 sg13_lv_pmos w=1.12u l=0.13u
XNA_n53 n53 dn3 m_n53 gn1 sg13_lv_nmos w=0.74u l=0.13u
XNB_n53 m_n53 dn5 gn1 gn1 sg13_lv_nmos w=0.74u l=0.13u
CL_n53 n53 gn1 2f
XPA_n530 n530 sn31 ph1 ph1 sg13_lv_pmos w=1.12u l=0.13u
XPB_n530 n530 d0 ph1 ph1 sg13_lv_pmos w=1.12u l=0.13u
XNA_n530 n530 sn31 m_n530 gn1 sg13_lv_nmos w=0.74u l=0.13u
XNB_n530 m_n530 d0 gn1 gn1 sg13_lv_nmos w=0.74u l=0.13u
CL_n530 n530 gn1 2f
XPA_n532 n532 s31 ph1 ph1 sg13_lv_pmos w=1.12u l=0.13u
XPB_n532 n532 d0 ph1 ph1 sg13_lv_pmos w=1.12u l=0.13u
XNA_n532 n532 s31 m_n532 gn1 sg13_lv_nmos w=0.74u l=0.13u
XNB_n532 m_n532 d0 gn1 gn1 sg13_lv_nmos w=0.74u l=0.13u
CL_n532 n532 gn1 2f
XPA_n533 n533 sn31 ph1 ph1 sg13_lv_pmos w=1.12u l=0.13u
XPB_n533 n533 dn0 ph1 ph1 sg13_lv_pmos w=1.12u l=0.13u
XNA_n533 n533 sn31 m_n533 gn1 sg13_lv_nmos w=0.74u l=0.13u
XNB_n533 m_n533 dn0 gn1 gn1 sg13_lv_nmos w=0.74u l=0.13u
CL_n533 n533 gn1 2f
XPA_n535 n535 d4 ph1 ph1 sg13_lv_pmos w=1.12u l=0.13u
XPB_n535 n535 dn6 ph1 ph1 sg13_lv_pmos w=1.12u l=0.13u
XNA_n535 n535 d4 m_n535 gn1 sg13_lv_nmos w=0.74u l=0.13u
XNB_n535 m_n535 dn6 gn1 gn1 sg13_lv_nmos w=0.74u l=0.13u
CL_n535 n535 gn1 2f
XPA_n536 n536 dn4 ph1 ph1 sg13_lv_pmos w=1.12u l=0.13u
XPB_n536 n536 d6 ph1 ph1 sg13_lv_pmos w=1.12u l=0.13u
XNA_n536 n536 dn4 m_n536 gn1 sg13_lv_nmos w=0.74u l=0.13u
XNB_n536 m_n536 d6 gn1 gn1 sg13_lv_nmos w=0.74u l=0.13u
CL_n536 n536 gn1 2f
XPA_n538 n538 d4 ph1 ph1 sg13_lv_pmos w=1.12u l=0.13u
XPB_n538 n538 d6 ph1 ph1 sg13_lv_pmos w=1.12u l=0.13u
XNA_n538 n538 d4 m_n538 gn1 sg13_lv_nmos w=0.74u l=0.13u
XNB_n538 m_n538 d6 gn1 gn1 sg13_lv_nmos w=0.74u l=0.13u
CL_n538 n538 gn1 2f
XPA_n539 n539 dn4 ph1 ph1 sg13_lv_pmos w=1.12u l=0.13u
XPB_n539 n539 dn6 ph1 ph1 sg13_lv_pmos w=1.12u l=0.13u
XNA_n539 n539 dn4 m_n539 gn1 sg13_lv_nmos w=0.74u l=0.13u
XNB_n539 m_n539 dn6 gn1 gn1 sg13_lv_nmos w=0.74u l=0.13u
CL_n539 n539 gn1 2f
XPA_n541 n541 d12 ph1 ph1 sg13_lv_pmos w=1.12u l=0.13u
XPB_n541 n541 dn13 ph1 ph1 sg13_lv_pmos w=1.12u l=0.13u
XNA_n541 n541 d12 m_n541 gn1 sg13_lv_nmos w=0.74u l=0.13u
XNB_n541 m_n541 dn13 gn1 gn1 sg13_lv_nmos w=0.74u l=0.13u
CL_n541 n541 gn1 2f
XPA_n542 n542 dn12 ph1 ph1 sg13_lv_pmos w=1.12u l=0.13u
XPB_n542 n542 d13 ph1 ph1 sg13_lv_pmos w=1.12u l=0.13u
XNA_n542 n542 dn12 m_n542 gn1 sg13_lv_nmos w=0.74u l=0.13u
XNB_n542 m_n542 d13 gn1 gn1 sg13_lv_nmos w=0.74u l=0.13u
CL_n542 n542 gn1 2f
XPA_n544 n544 d12 ph1 ph1 sg13_lv_pmos w=1.12u l=0.13u
XPB_n544 n544 d13 ph1 ph1 sg13_lv_pmos w=1.12u l=0.13u
XNA_n544 n544 d12 m_n544 gn1 sg13_lv_nmos w=0.74u l=0.13u
XNB_n544 m_n544 d13 gn1 gn1 sg13_lv_nmos w=0.74u l=0.13u
CL_n544 n544 gn1 2f
XPA_n545 n545 dn12 ph1 ph1 sg13_lv_pmos w=1.12u l=0.13u
XPB_n545 n545 dn13 ph1 ph1 sg13_lv_pmos w=1.12u l=0.13u
XNA_n545 n545 dn12 m_n545 gn1 sg13_lv_nmos w=0.74u l=0.13u
XNB_n545 m_n545 dn13 gn1 gn1 sg13_lv_nmos w=0.74u l=0.13u
CL_n545 n545 gn1 2f
XPA_n547 n547 d14 ph1 ph1 sg13_lv_pmos w=1.12u l=0.13u
XPB_n547 n547 dn16 ph1 ph1 sg13_lv_pmos w=1.12u l=0.13u
XNA_n547 n547 d14 m_n547 gn1 sg13_lv_nmos w=0.74u l=0.13u
XNB_n547 m_n547 dn16 gn1 gn1 sg13_lv_nmos w=0.74u l=0.13u
CL_n547 n547 gn1 2f
XPA_n548 n548 dn14 ph1 ph1 sg13_lv_pmos w=1.12u l=0.13u
XPB_n548 n548 d16 ph1 ph1 sg13_lv_pmos w=1.12u l=0.13u
XNA_n548 n548 dn14 m_n548 gn1 sg13_lv_nmos w=0.74u l=0.13u
XNB_n548 m_n548 d16 gn1 gn1 sg13_lv_nmos w=0.74u l=0.13u
CL_n548 n548 gn1 2f
XPA_n55 n55 d6 ph1 ph1 sg13_lv_pmos w=1.12u l=0.13u
XPB_n55 n55 dn7 ph1 ph1 sg13_lv_pmos w=1.12u l=0.13u
XNA_n55 n55 d6 m_n55 gn1 sg13_lv_nmos w=0.74u l=0.13u
XNB_n55 m_n55 dn7 gn1 gn1 sg13_lv_nmos w=0.74u l=0.13u
CL_n55 n55 gn1 2f
XPA_n550 n550 d14 ph1 ph1 sg13_lv_pmos w=1.12u l=0.13u
XPB_n550 n550 d16 ph1 ph1 sg13_lv_pmos w=1.12u l=0.13u
XNA_n550 n550 d14 m_n550 gn1 sg13_lv_nmos w=0.74u l=0.13u
XNB_n550 m_n550 d16 gn1 gn1 sg13_lv_nmos w=0.74u l=0.13u
CL_n550 n550 gn1 2f
XPA_n551 n551 dn14 ph1 ph1 sg13_lv_pmos w=1.12u l=0.13u
XPB_n551 n551 dn16 ph1 ph1 sg13_lv_pmos w=1.12u l=0.13u
XNA_n551 n551 dn14 m_n551 gn1 sg13_lv_nmos w=0.74u l=0.13u
XNB_n551 m_n551 dn16 gn1 gn1 sg13_lv_nmos w=0.74u l=0.13u
CL_n551 n551 gn1 2f
XPA_n553 n553 d17 ph1 ph1 sg13_lv_pmos w=1.12u l=0.13u
XPB_n553 n553 dn21 ph1 ph1 sg13_lv_pmos w=1.12u l=0.13u
XNA_n553 n553 d17 m_n553 gn1 sg13_lv_nmos w=0.74u l=0.13u
XNB_n553 m_n553 dn21 gn1 gn1 sg13_lv_nmos w=0.74u l=0.13u
CL_n553 n553 gn1 2f
XPA_n554 n554 dn17 ph1 ph1 sg13_lv_pmos w=1.12u l=0.13u
XPB_n554 n554 d21 ph1 ph1 sg13_lv_pmos w=1.12u l=0.13u
XNA_n554 n554 dn17 m_n554 gn1 sg13_lv_nmos w=0.74u l=0.13u
XNB_n554 m_n554 d21 gn1 gn1 sg13_lv_nmos w=0.74u l=0.13u
CL_n554 n554 gn1 2f
XPA_n556 n556 d17 ph1 ph1 sg13_lv_pmos w=1.12u l=0.13u
XPB_n556 n556 d21 ph1 ph1 sg13_lv_pmos w=1.12u l=0.13u
XNA_n556 n556 d17 m_n556 gn1 sg13_lv_nmos w=0.74u l=0.13u
XNB_n556 m_n556 d21 gn1 gn1 sg13_lv_nmos w=0.74u l=0.13u
CL_n556 n556 gn1 2f
XPA_n557 n557 dn17 ph1 ph1 sg13_lv_pmos w=1.12u l=0.13u
XPB_n557 n557 dn21 ph1 ph1 sg13_lv_pmos w=1.12u l=0.13u
XNA_n557 n557 dn17 m_n557 gn1 sg13_lv_nmos w=0.74u l=0.13u
XNB_n557 m_n557 dn21 gn1 gn1 sg13_lv_nmos w=0.74u l=0.13u
CL_n557 n557 gn1 2f
XPA_n559 n559 d22 ph1 ph1 sg13_lv_pmos w=1.12u l=0.13u
XPB_n559 n559 dn23 ph1 ph1 sg13_lv_pmos w=1.12u l=0.13u
XNA_n559 n559 d22 m_n559 gn1 sg13_lv_nmos w=0.74u l=0.13u
XNB_n559 m_n559 dn23 gn1 gn1 sg13_lv_nmos w=0.74u l=0.13u
CL_n559 n559 gn1 2f
XPA_n56 n56 dn6 ph1 ph1 sg13_lv_pmos w=1.12u l=0.13u
XPB_n56 n56 d7 ph1 ph1 sg13_lv_pmos w=1.12u l=0.13u
XNA_n56 n56 dn6 m_n56 gn1 sg13_lv_nmos w=0.74u l=0.13u
XNB_n56 m_n56 d7 gn1 gn1 sg13_lv_nmos w=0.74u l=0.13u
CL_n56 n56 gn1 2f
XPA_n560 n560 dn22 ph1 ph1 sg13_lv_pmos w=1.12u l=0.13u
XPB_n560 n560 d23 ph1 ph1 sg13_lv_pmos w=1.12u l=0.13u
XNA_n560 n560 dn22 m_n560 gn1 sg13_lv_nmos w=0.74u l=0.13u
XNB_n560 m_n560 d23 gn1 gn1 sg13_lv_nmos w=0.74u l=0.13u
CL_n560 n560 gn1 2f
XPA_n562 n562 d22 ph1 ph1 sg13_lv_pmos w=1.12u l=0.13u
XPB_n562 n562 d23 ph1 ph1 sg13_lv_pmos w=1.12u l=0.13u
XNA_n562 n562 d22 m_n562 gn1 sg13_lv_nmos w=0.74u l=0.13u
XNB_n562 m_n562 d23 gn1 gn1 sg13_lv_nmos w=0.74u l=0.13u
CL_n562 n562 gn1 2f
XPA_n563 n563 dn22 ph1 ph1 sg13_lv_pmos w=1.12u l=0.13u
XPB_n563 n563 dn23 ph1 ph1 sg13_lv_pmos w=1.12u l=0.13u
XNA_n563 n563 dn22 m_n563 gn1 sg13_lv_nmos w=0.74u l=0.13u
XNB_n563 m_n563 dn23 gn1 gn1 sg13_lv_nmos w=0.74u l=0.13u
CL_n563 n563 gn1 2f
XPA_n565 n565 d24 ph1 ph1 sg13_lv_pmos w=1.12u l=0.13u
XPB_n565 n565 dn28 ph1 ph1 sg13_lv_pmos w=1.12u l=0.13u
XNA_n565 n565 d24 m_n565 gn1 sg13_lv_nmos w=0.74u l=0.13u
XNB_n565 m_n565 dn28 gn1 gn1 sg13_lv_nmos w=0.74u l=0.13u
CL_n565 n565 gn1 2f
XPA_n566 n566 dn24 ph1 ph1 sg13_lv_pmos w=1.12u l=0.13u
XPB_n566 n566 d28 ph1 ph1 sg13_lv_pmos w=1.12u l=0.13u
XNA_n566 n566 dn24 m_n566 gn1 sg13_lv_nmos w=0.74u l=0.13u
XNB_n566 m_n566 d28 gn1 gn1 sg13_lv_nmos w=0.74u l=0.13u
CL_n566 n566 gn1 2f
XPA_n568 n568 d24 ph1 ph1 sg13_lv_pmos w=1.12u l=0.13u
XPB_n568 n568 d28 ph1 ph1 sg13_lv_pmos w=1.12u l=0.13u
XNA_n568 n568 d24 m_n568 gn1 sg13_lv_nmos w=0.74u l=0.13u
XNB_n568 m_n568 d28 gn1 gn1 sg13_lv_nmos w=0.74u l=0.13u
CL_n568 n568 gn1 2f
XPA_n569 n569 dn24 ph1 ph1 sg13_lv_pmos w=1.12u l=0.13u
XPB_n569 n569 dn28 ph1 ph1 sg13_lv_pmos w=1.12u l=0.13u
XNA_n569 n569 dn24 m_n569 gn1 sg13_lv_nmos w=0.74u l=0.13u
XNB_n569 m_n569 dn28 gn1 gn1 sg13_lv_nmos w=0.74u l=0.13u
CL_n569 n569 gn1 2f
XPA_n58 n58 d6 ph1 ph1 sg13_lv_pmos w=1.12u l=0.13u
XPB_n58 n58 d7 ph1 ph1 sg13_lv_pmos w=1.12u l=0.13u
XNA_n58 n58 d6 m_n58 gn1 sg13_lv_nmos w=0.74u l=0.13u
XNB_n58 m_n58 d7 gn1 gn1 sg13_lv_nmos w=0.74u l=0.13u
CL_n58 n58 gn1 2f
XPA_n59 n59 dn6 ph1 ph1 sg13_lv_pmos w=1.12u l=0.13u
XPB_n59 n59 dn7 ph1 ph1 sg13_lv_pmos w=1.12u l=0.13u
XNA_n59 n59 dn6 m_n59 gn1 sg13_lv_nmos w=0.74u l=0.13u
XNB_n59 m_n59 dn7 gn1 gn1 sg13_lv_nmos w=0.74u l=0.13u
CL_n59 n59 gn1 2f
XPA_n613 n613 d29 ph1 ph1 sg13_lv_pmos w=1.12u l=0.13u
XPB_n613 n613 dn30 ph1 ph1 sg13_lv_pmos w=1.12u l=0.13u
XNA_n613 n613 d29 m_n613 gn1 sg13_lv_nmos w=0.74u l=0.13u
XNB_n613 m_n613 dn30 gn1 gn1 sg13_lv_nmos w=0.74u l=0.13u
CL_n613 n613 gn1 2f
XPA_n614 n614 dn29 ph1 ph1 sg13_lv_pmos w=1.12u l=0.13u
XPB_n614 n614 d30 ph1 ph1 sg13_lv_pmos w=1.12u l=0.13u
XNA_n614 n614 dn29 m_n614 gn1 sg13_lv_nmos w=0.74u l=0.13u
XNB_n614 m_n614 d30 gn1 gn1 sg13_lv_nmos w=0.74u l=0.13u
CL_n614 n614 gn1 2f
XPA_n616 n616 d29 ph1 ph1 sg13_lv_pmos w=1.12u l=0.13u
XPB_n616 n616 d30 ph1 ph1 sg13_lv_pmos w=1.12u l=0.13u
XNA_n616 n616 d29 m_n616 gn1 sg13_lv_nmos w=0.74u l=0.13u
XNB_n616 m_n616 d30 gn1 gn1 sg13_lv_nmos w=0.74u l=0.13u
CL_n616 n616 gn1 2f
XPA_n617 n617 dn29 ph1 ph1 sg13_lv_pmos w=1.12u l=0.13u
XPB_n617 n617 dn30 ph1 ph1 sg13_lv_pmos w=1.12u l=0.13u
XNA_n617 n617 dn29 m_n617 gn1 sg13_lv_nmos w=0.74u l=0.13u
XNB_n617 m_n617 dn30 gn1 gn1 sg13_lv_nmos w=0.74u l=0.13u
CL_n617 n617 gn1 2f
XPA_n661 n661 s0 ph1 ph1 sg13_lv_pmos w=1.12u l=0.13u
XPB_n661 n661 sn2 ph1 ph1 sg13_lv_pmos w=1.12u l=0.13u
XNA_n661 n661 s0 m_n661 gn1 sg13_lv_nmos w=0.74u l=0.13u
XNB_n661 m_n661 sn2 gn1 gn1 sg13_lv_nmos w=0.74u l=0.13u
CL_n661 n661 gn1 2f
XPA_n662 n662 sn0 ph1 ph1 sg13_lv_pmos w=1.12u l=0.13u
XPB_n662 n662 s2 ph1 ph1 sg13_lv_pmos w=1.12u l=0.13u
XNA_n662 n662 sn0 m_n662 gn1 sg13_lv_nmos w=0.74u l=0.13u
XNB_n662 m_n662 s2 gn1 gn1 sg13_lv_nmos w=0.74u l=0.13u
CL_n662 n662 gn1 2f
XPA_n664 n664 s0 ph1 ph1 sg13_lv_pmos w=1.12u l=0.13u
XPB_n664 n664 s2 ph1 ph1 sg13_lv_pmos w=1.12u l=0.13u
XNA_n664 n664 s0 m_n664 gn1 sg13_lv_nmos w=0.74u l=0.13u
XNB_n664 m_n664 s2 gn1 gn1 sg13_lv_nmos w=0.74u l=0.13u
CL_n664 n664 gn1 2f
XPA_n665 n665 sn0 ph1 ph1 sg13_lv_pmos w=1.12u l=0.13u
XPB_n665 n665 sn2 ph1 ph1 sg13_lv_pmos w=1.12u l=0.13u
XNA_n665 n665 sn0 m_n665 gn1 sg13_lv_nmos w=0.74u l=0.13u
XNB_n665 m_n665 sn2 gn1 gn1 sg13_lv_nmos w=0.74u l=0.13u
CL_n665 n665 gn1 2f
XPA_n667 n667 s3 ph1 ph1 sg13_lv_pmos w=1.12u l=0.13u
XPB_n667 n667 sn4 ph1 ph1 sg13_lv_pmos w=1.12u l=0.13u
XNA_n667 n667 s3 m_n667 gn1 sg13_lv_nmos w=0.74u l=0.13u
XNB_n667 m_n667 sn4 gn1 gn1 sg13_lv_nmos w=0.74u l=0.13u
CL_n667 n667 gn1 2f
XPA_n668 n668 sn3 ph1 ph1 sg13_lv_pmos w=1.12u l=0.13u
XPB_n668 n668 s4 ph1 ph1 sg13_lv_pmos w=1.12u l=0.13u
XNA_n668 n668 sn3 m_n668 gn1 sg13_lv_nmos w=0.74u l=0.13u
XNB_n668 m_n668 s4 gn1 gn1 sg13_lv_nmos w=0.74u l=0.13u
CL_n668 n668 gn1 2f
XPA_n670 n670 s3 ph1 ph1 sg13_lv_pmos w=1.12u l=0.13u
XPB_n670 n670 s4 ph1 ph1 sg13_lv_pmos w=1.12u l=0.13u
XNA_n670 n670 s3 m_n670 gn1 sg13_lv_nmos w=0.74u l=0.13u
XNB_n670 m_n670 s4 gn1 gn1 sg13_lv_nmos w=0.74u l=0.13u
CL_n670 n670 gn1 2f
XPA_n671 n671 sn3 ph1 ph1 sg13_lv_pmos w=1.12u l=0.13u
XPB_n671 n671 sn4 ph1 ph1 sg13_lv_pmos w=1.12u l=0.13u
XNA_n671 n671 sn3 m_n671 gn1 sg13_lv_nmos w=0.74u l=0.13u
XNB_n671 m_n671 sn4 gn1 gn1 sg13_lv_nmos w=0.74u l=0.13u
CL_n671 n671 gn1 2f
XPA_n679 n679 s6 ph1 ph1 sg13_lv_pmos w=1.12u l=0.13u
XPB_n679 n679 sn8 ph1 ph1 sg13_lv_pmos w=1.12u l=0.13u
XNA_n679 n679 s6 m_n679 gn1 sg13_lv_nmos w=0.74u l=0.13u
XNB_n679 m_n679 sn8 gn1 gn1 sg13_lv_nmos w=0.74u l=0.13u
CL_n679 n679 gn1 2f
XPA_n680 n680 sn6 ph1 ph1 sg13_lv_pmos w=1.12u l=0.13u
XPB_n680 n680 s8 ph1 ph1 sg13_lv_pmos w=1.12u l=0.13u
XNA_n680 n680 sn6 m_n680 gn1 sg13_lv_nmos w=0.74u l=0.13u
XNB_n680 m_n680 s8 gn1 gn1 sg13_lv_nmos w=0.74u l=0.13u
CL_n680 n680 gn1 2f
XPA_n682 n682 s6 ph1 ph1 sg13_lv_pmos w=1.12u l=0.13u
XPB_n682 n682 s8 ph1 ph1 sg13_lv_pmos w=1.12u l=0.13u
XNA_n682 n682 s6 m_n682 gn1 sg13_lv_nmos w=0.74u l=0.13u
XNB_n682 m_n682 s8 gn1 gn1 sg13_lv_nmos w=0.74u l=0.13u
CL_n682 n682 gn1 2f
XPA_n683 n683 sn6 ph1 ph1 sg13_lv_pmos w=1.12u l=0.13u
XPB_n683 n683 sn8 ph1 ph1 sg13_lv_pmos w=1.12u l=0.13u
XNA_n683 n683 sn6 m_n683 gn1 sg13_lv_nmos w=0.74u l=0.13u
XNB_n683 m_n683 sn8 gn1 gn1 sg13_lv_nmos w=0.74u l=0.13u
CL_n683 n683 gn1 2f
XPA_n685 n685 s11 ph1 ph1 sg13_lv_pmos w=1.12u l=0.13u
XPB_n685 n685 sn12 ph1 ph1 sg13_lv_pmos w=1.12u l=0.13u
XNA_n685 n685 s11 m_n685 gn1 sg13_lv_nmos w=0.74u l=0.13u
XNB_n685 m_n685 sn12 gn1 gn1 sg13_lv_nmos w=0.74u l=0.13u
CL_n685 n685 gn1 2f
XPA_n686 n686 sn11 ph1 ph1 sg13_lv_pmos w=1.12u l=0.13u
XPB_n686 n686 s12 ph1 ph1 sg13_lv_pmos w=1.12u l=0.13u
XNA_n686 n686 sn11 m_n686 gn1 sg13_lv_nmos w=0.74u l=0.13u
XNB_n686 m_n686 s12 gn1 gn1 sg13_lv_nmos w=0.74u l=0.13u
CL_n686 n686 gn1 2f
XPA_n688 n688 s11 ph1 ph1 sg13_lv_pmos w=1.12u l=0.13u
XPB_n688 n688 s12 ph1 ph1 sg13_lv_pmos w=1.12u l=0.13u
XNA_n688 n688 s11 m_n688 gn1 sg13_lv_nmos w=0.74u l=0.13u
XNB_n688 m_n688 s12 gn1 gn1 sg13_lv_nmos w=0.74u l=0.13u
CL_n688 n688 gn1 2f
XPA_n689 n689 sn11 ph1 ph1 sg13_lv_pmos w=1.12u l=0.13u
XPB_n689 n689 sn12 ph1 ph1 sg13_lv_pmos w=1.12u l=0.13u
XNA_n689 n689 sn11 m_n689 gn1 sg13_lv_nmos w=0.74u l=0.13u
XNB_n689 m_n689 sn12 gn1 gn1 sg13_lv_nmos w=0.74u l=0.13u
CL_n689 n689 gn1 2f
XPA_n691 n691 s15 ph1 ph1 sg13_lv_pmos w=1.12u l=0.13u
XPB_n691 n691 sn18 ph1 ph1 sg13_lv_pmos w=1.12u l=0.13u
XNA_n691 n691 s15 m_n691 gn1 sg13_lv_nmos w=0.74u l=0.13u
XNB_n691 m_n691 sn18 gn1 gn1 sg13_lv_nmos w=0.74u l=0.13u
CL_n691 n691 gn1 2f
XPA_n692 n692 sn15 ph1 ph1 sg13_lv_pmos w=1.12u l=0.13u
XPB_n692 n692 s18 ph1 ph1 sg13_lv_pmos w=1.12u l=0.13u
XNA_n692 n692 sn15 m_n692 gn1 sg13_lv_nmos w=0.74u l=0.13u
XNB_n692 m_n692 s18 gn1 gn1 sg13_lv_nmos w=0.74u l=0.13u
CL_n692 n692 gn1 2f
XPA_n694 n694 s15 ph1 ph1 sg13_lv_pmos w=1.12u l=0.13u
XPB_n694 n694 s18 ph1 ph1 sg13_lv_pmos w=1.12u l=0.13u
XNA_n694 n694 s15 m_n694 gn1 sg13_lv_nmos w=0.74u l=0.13u
XNB_n694 m_n694 s18 gn1 gn1 sg13_lv_nmos w=0.74u l=0.13u
CL_n694 n694 gn1 2f
XPA_n695 n695 sn15 ph1 ph1 sg13_lv_pmos w=1.12u l=0.13u
XPB_n695 n695 sn18 ph1 ph1 sg13_lv_pmos w=1.12u l=0.13u
XNA_n695 n695 sn15 m_n695 gn1 sg13_lv_nmos w=0.74u l=0.13u
XNB_n695 m_n695 sn18 gn1 gn1 sg13_lv_nmos w=0.74u l=0.13u
CL_n695 n695 gn1 2f
XPA_n697 n697 s19 ph1 ph1 sg13_lv_pmos w=1.12u l=0.13u
XPB_n697 n697 sn20 ph1 ph1 sg13_lv_pmos w=1.12u l=0.13u
XNA_n697 n697 s19 m_n697 gn1 sg13_lv_nmos w=0.74u l=0.13u
XNB_n697 m_n697 sn20 gn1 gn1 sg13_lv_nmos w=0.74u l=0.13u
CL_n697 n697 gn1 2f
XPA_n698 n698 sn19 ph1 ph1 sg13_lv_pmos w=1.12u l=0.13u
XPB_n698 n698 s20 ph1 ph1 sg13_lv_pmos w=1.12u l=0.13u
XNA_n698 n698 sn19 m_n698 gn1 sg13_lv_nmos w=0.74u l=0.13u
XNB_n698 m_n698 s20 gn1 gn1 sg13_lv_nmos w=0.74u l=0.13u
CL_n698 n698 gn1 2f
XPA_n7 n7 s9 ph1 ph1 sg13_lv_pmos w=1.12u l=0.13u
XPB_n7 n7 sn10 ph1 ph1 sg13_lv_pmos w=1.12u l=0.13u
XNA_n7 n7 s9 m_n7 gn1 sg13_lv_nmos w=0.74u l=0.13u
XNB_n7 m_n7 sn10 gn1 gn1 sg13_lv_nmos w=0.74u l=0.13u
CL_n7 n7 gn1 2f
XPA_n700 n700 s19 ph1 ph1 sg13_lv_pmos w=1.12u l=0.13u
XPB_n700 n700 s20 ph1 ph1 sg13_lv_pmos w=1.12u l=0.13u
XNA_n700 n700 s19 m_n700 gn1 sg13_lv_nmos w=0.74u l=0.13u
XNB_n700 m_n700 s20 gn1 gn1 sg13_lv_nmos w=0.74u l=0.13u
CL_n700 n700 gn1 2f
XPA_n701 n701 sn19 ph1 ph1 sg13_lv_pmos w=1.12u l=0.13u
XPB_n701 n701 sn20 ph1 ph1 sg13_lv_pmos w=1.12u l=0.13u
XNA_n701 n701 sn19 m_n701 gn1 sg13_lv_nmos w=0.74u l=0.13u
XNB_n701 m_n701 sn20 gn1 gn1 sg13_lv_nmos w=0.74u l=0.13u
CL_n701 n701 gn1 2f
XPA_n703 n703 s24 ph1 ph1 sg13_lv_pmos w=1.12u l=0.13u
XPB_n703 n703 sn25 ph1 ph1 sg13_lv_pmos w=1.12u l=0.13u
XNA_n703 n703 s24 m_n703 gn1 sg13_lv_nmos w=0.74u l=0.13u
XNB_n703 m_n703 sn25 gn1 gn1 sg13_lv_nmos w=0.74u l=0.13u
CL_n703 n703 gn1 2f
XPA_n704 n704 sn24 ph1 ph1 sg13_lv_pmos w=1.12u l=0.13u
XPB_n704 n704 s25 ph1 ph1 sg13_lv_pmos w=1.12u l=0.13u
XNA_n704 n704 sn24 m_n704 gn1 sg13_lv_nmos w=0.74u l=0.13u
XNB_n704 m_n704 s25 gn1 gn1 sg13_lv_nmos w=0.74u l=0.13u
CL_n704 n704 gn1 2f
XPA_n706 n706 s24 ph1 ph1 sg13_lv_pmos w=1.12u l=0.13u
XPB_n706 n706 s25 ph1 ph1 sg13_lv_pmos w=1.12u l=0.13u
XNA_n706 n706 s24 m_n706 gn1 sg13_lv_nmos w=0.74u l=0.13u
XNB_n706 m_n706 s25 gn1 gn1 sg13_lv_nmos w=0.74u l=0.13u
CL_n706 n706 gn1 2f
XPA_n707 n707 sn24 ph1 ph1 sg13_lv_pmos w=1.12u l=0.13u
XPB_n707 n707 sn25 ph1 ph1 sg13_lv_pmos w=1.12u l=0.13u
XNA_n707 n707 sn24 m_n707 gn1 sg13_lv_nmos w=0.74u l=0.13u
XNB_n707 m_n707 sn25 gn1 gn1 sg13_lv_nmos w=0.74u l=0.13u
CL_n707 n707 gn1 2f
XPA_n709 n709 s29 ph1 ph1 sg13_lv_pmos w=1.12u l=0.13u
XPB_n709 n709 sn30 ph1 ph1 sg13_lv_pmos w=1.12u l=0.13u
XNA_n709 n709 s29 m_n709 gn1 sg13_lv_nmos w=0.74u l=0.13u
XNB_n709 m_n709 sn30 gn1 gn1 sg13_lv_nmos w=0.74u l=0.13u
CL_n709 n709 gn1 2f
XPA_n710 n710 sn29 ph1 ph1 sg13_lv_pmos w=1.12u l=0.13u
XPB_n710 n710 s30 ph1 ph1 sg13_lv_pmos w=1.12u l=0.13u
XNA_n710 n710 sn29 m_n710 gn1 sg13_lv_nmos w=0.74u l=0.13u
XNB_n710 m_n710 s30 gn1 gn1 sg13_lv_nmos w=0.74u l=0.13u
CL_n710 n710 gn1 2f
XPA_n712 n712 s29 ph1 ph1 sg13_lv_pmos w=1.12u l=0.13u
XPB_n712 n712 s30 ph1 ph1 sg13_lv_pmos w=1.12u l=0.13u
XNA_n712 n712 s29 m_n712 gn1 sg13_lv_nmos w=0.74u l=0.13u
XNB_n712 m_n712 s30 gn1 gn1 sg13_lv_nmos w=0.74u l=0.13u
CL_n712 n712 gn1 2f
XPA_n713 n713 sn29 ph1 ph1 sg13_lv_pmos w=1.12u l=0.13u
XPB_n713 n713 sn30 ph1 ph1 sg13_lv_pmos w=1.12u l=0.13u
XNA_n713 n713 sn29 m_n713 gn1 sg13_lv_nmos w=0.74u l=0.13u
XNB_n713 m_n713 sn30 gn1 gn1 sg13_lv_nmos w=0.74u l=0.13u
CL_n713 n713 gn1 2f
XPA_n715 n715 s31 ph1 ph1 sg13_lv_pmos w=1.12u l=0.13u
XPB_n715 n715 dn0 ph1 ph1 sg13_lv_pmos w=1.12u l=0.13u
XNA_n715 n715 s31 m_n715 gn1 sg13_lv_nmos w=0.74u l=0.13u
XNB_n715 m_n715 dn0 gn1 gn1 sg13_lv_nmos w=0.74u l=0.13u
CL_n715 n715 gn1 2f
XPA_n716 n716 sn31 ph1 ph1 sg13_lv_pmos w=1.12u l=0.13u
XPB_n716 n716 d0 ph1 ph1 sg13_lv_pmos w=1.12u l=0.13u
XNA_n716 n716 sn31 m_n716 gn1 sg13_lv_nmos w=0.74u l=0.13u
XNB_n716 m_n716 d0 gn1 gn1 sg13_lv_nmos w=0.74u l=0.13u
CL_n716 n716 gn1 2f
XPA_n718 n718 s31 ph1 ph1 sg13_lv_pmos w=1.12u l=0.13u
XPB_n718 n718 d0 ph1 ph1 sg13_lv_pmos w=1.12u l=0.13u
XNA_n718 n718 s31 m_n718 gn1 sg13_lv_nmos w=0.74u l=0.13u
XNB_n718 m_n718 d0 gn1 gn1 sg13_lv_nmos w=0.74u l=0.13u
CL_n718 n718 gn1 2f
XPA_n719 n719 sn31 ph1 ph1 sg13_lv_pmos w=1.12u l=0.13u
XPB_n719 n719 dn0 ph1 ph1 sg13_lv_pmos w=1.12u l=0.13u
XNA_n719 n719 sn31 m_n719 gn1 sg13_lv_nmos w=0.74u l=0.13u
XNB_n719 m_n719 dn0 gn1 gn1 sg13_lv_nmos w=0.74u l=0.13u
CL_n719 n719 gn1 2f
XPA_n721 n721 d1 ph1 ph1 sg13_lv_pmos w=1.12u l=0.13u
XPB_n721 n721 dn2 ph1 ph1 sg13_lv_pmos w=1.12u l=0.13u
XNA_n721 n721 d1 m_n721 gn1 sg13_lv_nmos w=0.74u l=0.13u
XNB_n721 m_n721 dn2 gn1 gn1 sg13_lv_nmos w=0.74u l=0.13u
CL_n721 n721 gn1 2f
XPA_n722 n722 dn1 ph1 ph1 sg13_lv_pmos w=1.12u l=0.13u
XPB_n722 n722 d2 ph1 ph1 sg13_lv_pmos w=1.12u l=0.13u
XNA_n722 n722 dn1 m_n722 gn1 sg13_lv_nmos w=0.74u l=0.13u
XNB_n722 m_n722 d2 gn1 gn1 sg13_lv_nmos w=0.74u l=0.13u
CL_n722 n722 gn1 2f
XPA_n724 n724 d1 ph1 ph1 sg13_lv_pmos w=1.12u l=0.13u
XPB_n724 n724 d2 ph1 ph1 sg13_lv_pmos w=1.12u l=0.13u
XNA_n724 n724 d1 m_n724 gn1 sg13_lv_nmos w=0.74u l=0.13u
XNB_n724 m_n724 d2 gn1 gn1 sg13_lv_nmos w=0.74u l=0.13u
CL_n724 n724 gn1 2f
XPA_n725 n725 dn1 ph1 ph1 sg13_lv_pmos w=1.12u l=0.13u
XPB_n725 n725 dn2 ph1 ph1 sg13_lv_pmos w=1.12u l=0.13u
XNA_n725 n725 dn1 m_n725 gn1 sg13_lv_nmos w=0.74u l=0.13u
XNB_n725 m_n725 dn2 gn1 gn1 sg13_lv_nmos w=0.74u l=0.13u
CL_n725 n725 gn1 2f
XPA_n727 n727 d6 ph1 ph1 sg13_lv_pmos w=1.12u l=0.13u
XPB_n727 n727 dn7 ph1 ph1 sg13_lv_pmos w=1.12u l=0.13u
XNA_n727 n727 d6 m_n727 gn1 sg13_lv_nmos w=0.74u l=0.13u
XNB_n727 m_n727 dn7 gn1 gn1 sg13_lv_nmos w=0.74u l=0.13u
CL_n727 n727 gn1 2f
XPA_n728 n728 dn6 ph1 ph1 sg13_lv_pmos w=1.12u l=0.13u
XPB_n728 n728 d7 ph1 ph1 sg13_lv_pmos w=1.12u l=0.13u
XNA_n728 n728 dn6 m_n728 gn1 sg13_lv_nmos w=0.74u l=0.13u
XNB_n728 m_n728 d7 gn1 gn1 sg13_lv_nmos w=0.74u l=0.13u
CL_n728 n728 gn1 2f
XPA_n730 n730 d6 ph1 ph1 sg13_lv_pmos w=1.12u l=0.13u
XPB_n730 n730 d7 ph1 ph1 sg13_lv_pmos w=1.12u l=0.13u
XNA_n730 n730 d6 m_n730 gn1 sg13_lv_nmos w=0.74u l=0.13u
XNB_n730 m_n730 d7 gn1 gn1 sg13_lv_nmos w=0.74u l=0.13u
CL_n730 n730 gn1 2f
XPA_n731 n731 dn6 ph1 ph1 sg13_lv_pmos w=1.12u l=0.13u
XPB_n731 n731 dn7 ph1 ph1 sg13_lv_pmos w=1.12u l=0.13u
XNA_n731 n731 dn6 m_n731 gn1 sg13_lv_nmos w=0.74u l=0.13u
XNB_n731 m_n731 dn7 gn1 gn1 sg13_lv_nmos w=0.74u l=0.13u
CL_n731 n731 gn1 2f
XPA_n733 n733 d11 ph1 ph1 sg13_lv_pmos w=1.12u l=0.13u
XPB_n733 n733 dn12 ph1 ph1 sg13_lv_pmos w=1.12u l=0.13u
XNA_n733 n733 d11 m_n733 gn1 sg13_lv_nmos w=0.74u l=0.13u
XNB_n733 m_n733 dn12 gn1 gn1 sg13_lv_nmos w=0.74u l=0.13u
CL_n733 n733 gn1 2f
XPA_n734 n734 dn11 ph1 ph1 sg13_lv_pmos w=1.12u l=0.13u
XPB_n734 n734 d12 ph1 ph1 sg13_lv_pmos w=1.12u l=0.13u
XNA_n734 n734 dn11 m_n734 gn1 sg13_lv_nmos w=0.74u l=0.13u
XNB_n734 m_n734 d12 gn1 gn1 sg13_lv_nmos w=0.74u l=0.13u
CL_n734 n734 gn1 2f
XPA_n736 n736 d11 ph1 ph1 sg13_lv_pmos w=1.12u l=0.13u
XPB_n736 n736 d12 ph1 ph1 sg13_lv_pmos w=1.12u l=0.13u
XNA_n736 n736 d11 m_n736 gn1 sg13_lv_nmos w=0.74u l=0.13u
XNB_n736 m_n736 d12 gn1 gn1 sg13_lv_nmos w=0.74u l=0.13u
CL_n736 n736 gn1 2f
XPA_n737 n737 dn11 ph1 ph1 sg13_lv_pmos w=1.12u l=0.13u
XPB_n737 n737 dn12 ph1 ph1 sg13_lv_pmos w=1.12u l=0.13u
XNA_n737 n737 dn11 m_n737 gn1 sg13_lv_nmos w=0.74u l=0.13u
XNB_n737 m_n737 dn12 gn1 gn1 sg13_lv_nmos w=0.74u l=0.13u
CL_n737 n737 gn1 2f
XPA_n739 n739 d13 ph1 ph1 sg13_lv_pmos w=1.12u l=0.13u
XPB_n739 n739 dn16 ph1 ph1 sg13_lv_pmos w=1.12u l=0.13u
XNA_n739 n739 d13 m_n739 gn1 sg13_lv_nmos w=0.74u l=0.13u
XNB_n739 m_n739 dn16 gn1 gn1 sg13_lv_nmos w=0.74u l=0.13u
CL_n739 n739 gn1 2f
XPA_n740 n740 dn13 ph1 ph1 sg13_lv_pmos w=1.12u l=0.13u
XPB_n740 n740 d16 ph1 ph1 sg13_lv_pmos w=1.12u l=0.13u
XNA_n740 n740 dn13 m_n740 gn1 sg13_lv_nmos w=0.74u l=0.13u
XNB_n740 m_n740 d16 gn1 gn1 sg13_lv_nmos w=0.74u l=0.13u
CL_n740 n740 gn1 2f
XPA_n742 n742 d13 ph1 ph1 sg13_lv_pmos w=1.12u l=0.13u
XPB_n742 n742 d16 ph1 ph1 sg13_lv_pmos w=1.12u l=0.13u
XNA_n742 n742 d13 m_n742 gn1 sg13_lv_nmos w=0.74u l=0.13u
XNB_n742 m_n742 d16 gn1 gn1 sg13_lv_nmos w=0.74u l=0.13u
CL_n742 n742 gn1 2f
XPA_n743 n743 dn13 ph1 ph1 sg13_lv_pmos w=1.12u l=0.13u
XPB_n743 n743 dn16 ph1 ph1 sg13_lv_pmos w=1.12u l=0.13u
XNA_n743 n743 dn13 m_n743 gn1 sg13_lv_nmos w=0.74u l=0.13u
XNB_n743 m_n743 dn16 gn1 gn1 sg13_lv_nmos w=0.74u l=0.13u
CL_n743 n743 gn1 2f
XPA_n745 n745 d19 ph1 ph1 sg13_lv_pmos w=1.12u l=0.13u
XPB_n745 n745 dn20 ph1 ph1 sg13_lv_pmos w=1.12u l=0.13u
XNA_n745 n745 d19 m_n745 gn1 sg13_lv_nmos w=0.74u l=0.13u
XNB_n745 m_n745 dn20 gn1 gn1 sg13_lv_nmos w=0.74u l=0.13u
CL_n745 n745 gn1 2f
XPA_n746 n746 dn19 ph1 ph1 sg13_lv_pmos w=1.12u l=0.13u
XPB_n746 n746 d20 ph1 ph1 sg13_lv_pmos w=1.12u l=0.13u
XNA_n746 n746 dn19 m_n746 gn1 sg13_lv_nmos w=0.74u l=0.13u
XNB_n746 m_n746 d20 gn1 gn1 sg13_lv_nmos w=0.74u l=0.13u
CL_n746 n746 gn1 2f
XPA_n748 n748 d19 ph1 ph1 sg13_lv_pmos w=1.12u l=0.13u
XPB_n748 n748 d20 ph1 ph1 sg13_lv_pmos w=1.12u l=0.13u
XNA_n748 n748 d19 m_n748 gn1 sg13_lv_nmos w=0.74u l=0.13u
XNB_n748 m_n748 d20 gn1 gn1 sg13_lv_nmos w=0.74u l=0.13u
CL_n748 n748 gn1 2f
XPA_n749 n749 dn19 ph1 ph1 sg13_lv_pmos w=1.12u l=0.13u
XPB_n749 n749 dn20 ph1 ph1 sg13_lv_pmos w=1.12u l=0.13u
XNA_n749 n749 dn19 m_n749 gn1 sg13_lv_nmos w=0.74u l=0.13u
XNB_n749 m_n749 dn20 gn1 gn1 sg13_lv_nmos w=0.74u l=0.13u
CL_n749 n749 gn1 2f
XPA_n751 n751 d23 ph1 ph1 sg13_lv_pmos w=1.12u l=0.13u
XPB_n751 n751 dn25 ph1 ph1 sg13_lv_pmos w=1.12u l=0.13u
XNA_n751 n751 d23 m_n751 gn1 sg13_lv_nmos w=0.74u l=0.13u
XNB_n751 m_n751 dn25 gn1 gn1 sg13_lv_nmos w=0.74u l=0.13u
CL_n751 n751 gn1 2f
XPA_n752 n752 dn23 ph1 ph1 sg13_lv_pmos w=1.12u l=0.13u
XPB_n752 n752 d25 ph1 ph1 sg13_lv_pmos w=1.12u l=0.13u
XNA_n752 n752 dn23 m_n752 gn1 sg13_lv_nmos w=0.74u l=0.13u
XNB_n752 m_n752 d25 gn1 gn1 sg13_lv_nmos w=0.74u l=0.13u
CL_n752 n752 gn1 2f
XPA_n754 n754 d23 ph1 ph1 sg13_lv_pmos w=1.12u l=0.13u
XPB_n754 n754 d25 ph1 ph1 sg13_lv_pmos w=1.12u l=0.13u
XNA_n754 n754 d23 m_n754 gn1 sg13_lv_nmos w=0.74u l=0.13u
XNB_n754 m_n754 d25 gn1 gn1 sg13_lv_nmos w=0.74u l=0.13u
CL_n754 n754 gn1 2f
XPA_n755 n755 dn23 ph1 ph1 sg13_lv_pmos w=1.12u l=0.13u
XPB_n755 n755 dn25 ph1 ph1 sg13_lv_pmos w=1.12u l=0.13u
XNA_n755 n755 dn23 m_n755 gn1 sg13_lv_nmos w=0.74u l=0.13u
XNB_n755 m_n755 dn25 gn1 gn1 sg13_lv_nmos w=0.74u l=0.13u
CL_n755 n755 gn1 2f
XPA_n757 n757 d27 ph1 ph1 sg13_lv_pmos w=1.12u l=0.13u
XPB_n757 n757 dn28 ph1 ph1 sg13_lv_pmos w=1.12u l=0.13u
XNA_n757 n757 d27 m_n757 gn1 sg13_lv_nmos w=0.74u l=0.13u
XNB_n757 m_n757 dn28 gn1 gn1 sg13_lv_nmos w=0.74u l=0.13u
CL_n757 n757 gn1 2f
XPA_n758 n758 dn27 ph1 ph1 sg13_lv_pmos w=1.12u l=0.13u
XPB_n758 n758 d28 ph1 ph1 sg13_lv_pmos w=1.12u l=0.13u
XNA_n758 n758 dn27 m_n758 gn1 sg13_lv_nmos w=0.74u l=0.13u
XNB_n758 m_n758 d28 gn1 gn1 sg13_lv_nmos w=0.74u l=0.13u
CL_n758 n758 gn1 2f
XPA_n760 n760 d27 ph1 ph1 sg13_lv_pmos w=1.12u l=0.13u
XPB_n760 n760 d28 ph1 ph1 sg13_lv_pmos w=1.12u l=0.13u
XNA_n760 n760 d27 m_n760 gn1 sg13_lv_nmos w=0.74u l=0.13u
XNB_n760 m_n760 d28 gn1 gn1 sg13_lv_nmos w=0.74u l=0.13u
CL_n760 n760 gn1 2f
XPA_n761 n761 dn27 ph1 ph1 sg13_lv_pmos w=1.12u l=0.13u
XPB_n761 n761 dn28 ph1 ph1 sg13_lv_pmos w=1.12u l=0.13u
XNA_n761 n761 dn27 m_n761 gn1 sg13_lv_nmos w=0.74u l=0.13u
XNB_n761 m_n761 dn28 gn1 gn1 sg13_lv_nmos w=0.74u l=0.13u
CL_n761 n761 gn1 2f
XPA_n763 n763 d29 ph1 ph1 sg13_lv_pmos w=1.12u l=0.13u
XPB_n763 n763 dn31 ph1 ph1 sg13_lv_pmos w=1.12u l=0.13u
XNA_n763 n763 d29 m_n763 gn1 sg13_lv_nmos w=0.74u l=0.13u
XNB_n763 m_n763 dn31 gn1 gn1 sg13_lv_nmos w=0.74u l=0.13u
CL_n763 n763 gn1 2f
XPA_n764 n764 dn29 ph1 ph1 sg13_lv_pmos w=1.12u l=0.13u
XPB_n764 n764 d31 ph1 ph1 sg13_lv_pmos w=1.12u l=0.13u
XNA_n764 n764 dn29 m_n764 gn1 sg13_lv_nmos w=0.74u l=0.13u
XNB_n764 m_n764 d31 gn1 gn1 sg13_lv_nmos w=0.74u l=0.13u
CL_n764 n764 gn1 2f
XPA_n766 n766 d29 ph1 ph1 sg13_lv_pmos w=1.12u l=0.13u
XPB_n766 n766 d31 ph1 ph1 sg13_lv_pmos w=1.12u l=0.13u
XNA_n766 n766 d29 m_n766 gn1 sg13_lv_nmos w=0.74u l=0.13u
XNB_n766 m_n766 d31 gn1 gn1 sg13_lv_nmos w=0.74u l=0.13u
CL_n766 n766 gn1 2f
XPA_n767 n767 dn29 ph1 ph1 sg13_lv_pmos w=1.12u l=0.13u
XPB_n767 n767 dn31 ph1 ph1 sg13_lv_pmos w=1.12u l=0.13u
XNA_n767 n767 dn29 m_n767 gn1 sg13_lv_nmos w=0.74u l=0.13u
XNB_n767 m_n767 dn31 gn1 gn1 sg13_lv_nmos w=0.74u l=0.13u
CL_n767 n767 gn1 2f
XPA_n8 n8 sn9 ph1 ph1 sg13_lv_pmos w=1.12u l=0.13u
XPB_n8 n8 s10 ph1 ph1 sg13_lv_pmos w=1.12u l=0.13u
XNA_n8 n8 sn9 m_n8 gn1 sg13_lv_nmos w=0.74u l=0.13u
XNB_n8 m_n8 s10 gn1 gn1 sg13_lv_nmos w=0.74u l=0.13u
CL_n8 n8 gn1 2f
XPA_n859 n859 s0 ph1 ph1 sg13_lv_pmos w=1.12u l=0.13u
XPB_n859 n859 sn1 ph1 ph1 sg13_lv_pmos w=1.12u l=0.13u
XNA_n859 n859 s0 m_n859 gn1 sg13_lv_nmos w=0.74u l=0.13u
XNB_n859 m_n859 sn1 gn1 gn1 sg13_lv_nmos w=0.74u l=0.13u
CL_n859 n859 gn1 2f
XPA_n860 n860 sn0 ph1 ph1 sg13_lv_pmos w=1.12u l=0.13u
XPB_n860 n860 s1 ph1 ph1 sg13_lv_pmos w=1.12u l=0.13u
XNA_n860 n860 sn0 m_n860 gn1 sg13_lv_nmos w=0.74u l=0.13u
XNB_n860 m_n860 s1 gn1 gn1 sg13_lv_nmos w=0.74u l=0.13u
CL_n860 n860 gn1 2f
XPA_n862 n862 s0 ph1 ph1 sg13_lv_pmos w=1.12u l=0.13u
XPB_n862 n862 s1 ph1 ph1 sg13_lv_pmos w=1.12u l=0.13u
XNA_n862 n862 s0 m_n862 gn1 sg13_lv_nmos w=0.74u l=0.13u
XNB_n862 m_n862 s1 gn1 gn1 sg13_lv_nmos w=0.74u l=0.13u
CL_n862 n862 gn1 2f
XPA_n863 n863 sn0 ph1 ph1 sg13_lv_pmos w=1.12u l=0.13u
XPB_n863 n863 sn1 ph1 ph1 sg13_lv_pmos w=1.12u l=0.13u
XNA_n863 n863 sn0 m_n863 gn1 sg13_lv_nmos w=0.74u l=0.13u
XNB_n863 m_n863 sn1 gn1 gn1 sg13_lv_nmos w=0.74u l=0.13u
CL_n863 n863 gn1 2f
XPA_n865 n865 s3 ph1 ph1 sg13_lv_pmos w=1.12u l=0.13u
XPB_n865 n865 sn4 ph1 ph1 sg13_lv_pmos w=1.12u l=0.13u
XNA_n865 n865 s3 m_n865 gn1 sg13_lv_nmos w=0.74u l=0.13u
XNB_n865 m_n865 sn4 gn1 gn1 sg13_lv_nmos w=0.74u l=0.13u
CL_n865 n865 gn1 2f
XPA_n866 n866 sn3 ph1 ph1 sg13_lv_pmos w=1.12u l=0.13u
XPB_n866 n866 s4 ph1 ph1 sg13_lv_pmos w=1.12u l=0.13u
XNA_n866 n866 sn3 m_n866 gn1 sg13_lv_nmos w=0.74u l=0.13u
XNB_n866 m_n866 s4 gn1 gn1 sg13_lv_nmos w=0.74u l=0.13u
CL_n866 n866 gn1 2f
XPA_n868 n868 s3 ph1 ph1 sg13_lv_pmos w=1.12u l=0.13u
XPB_n868 n868 s4 ph1 ph1 sg13_lv_pmos w=1.12u l=0.13u
XNA_n868 n868 s3 m_n868 gn1 sg13_lv_nmos w=0.74u l=0.13u
XNB_n868 m_n868 s4 gn1 gn1 sg13_lv_nmos w=0.74u l=0.13u
CL_n868 n868 gn1 2f
XPA_n869 n869 sn3 ph1 ph1 sg13_lv_pmos w=1.12u l=0.13u
XPB_n869 n869 sn4 ph1 ph1 sg13_lv_pmos w=1.12u l=0.13u
XNA_n869 n869 sn3 m_n869 gn1 sg13_lv_nmos w=0.74u l=0.13u
XNB_n869 m_n869 sn4 gn1 gn1 sg13_lv_nmos w=0.74u l=0.13u
CL_n869 n869 gn1 2f
XPA_n871 n871 s5 ph1 ph1 sg13_lv_pmos w=1.12u l=0.13u
XPB_n871 n871 sn6 ph1 ph1 sg13_lv_pmos w=1.12u l=0.13u
XNA_n871 n871 s5 m_n871 gn1 sg13_lv_nmos w=0.74u l=0.13u
XNB_n871 m_n871 sn6 gn1 gn1 sg13_lv_nmos w=0.74u l=0.13u
CL_n871 n871 gn1 2f
XPA_n872 n872 sn5 ph1 ph1 sg13_lv_pmos w=1.12u l=0.13u
XPB_n872 n872 s6 ph1 ph1 sg13_lv_pmos w=1.12u l=0.13u
XNA_n872 n872 sn5 m_n872 gn1 sg13_lv_nmos w=0.74u l=0.13u
XNB_n872 m_n872 s6 gn1 gn1 sg13_lv_nmos w=0.74u l=0.13u
CL_n872 n872 gn1 2f
XPA_n874 n874 s5 ph1 ph1 sg13_lv_pmos w=1.12u l=0.13u
XPB_n874 n874 s6 ph1 ph1 sg13_lv_pmos w=1.12u l=0.13u
XNA_n874 n874 s5 m_n874 gn1 sg13_lv_nmos w=0.74u l=0.13u
XNB_n874 m_n874 s6 gn1 gn1 sg13_lv_nmos w=0.74u l=0.13u
CL_n874 n874 gn1 2f
XPA_n875 n875 sn5 ph1 ph1 sg13_lv_pmos w=1.12u l=0.13u
XPB_n875 n875 sn6 ph1 ph1 sg13_lv_pmos w=1.12u l=0.13u
XNA_n875 n875 sn5 m_n875 gn1 sg13_lv_nmos w=0.74u l=0.13u
XNB_n875 m_n875 sn6 gn1 gn1 sg13_lv_nmos w=0.74u l=0.13u
CL_n875 n875 gn1 2f
XPA_n877 n877 s7 ph1 ph1 sg13_lv_pmos w=1.12u l=0.13u
XPB_n877 n877 sn10 ph1 ph1 sg13_lv_pmos w=1.12u l=0.13u
XNA_n877 n877 s7 m_n877 gn1 sg13_lv_nmos w=0.74u l=0.13u
XNB_n877 m_n877 sn10 gn1 gn1 sg13_lv_nmos w=0.74u l=0.13u
CL_n877 n877 gn1 2f
XPA_n878 n878 sn7 ph1 ph1 sg13_lv_pmos w=1.12u l=0.13u
XPB_n878 n878 s10 ph1 ph1 sg13_lv_pmos w=1.12u l=0.13u
XNA_n878 n878 sn7 m_n878 gn1 sg13_lv_nmos w=0.74u l=0.13u
XNB_n878 m_n878 s10 gn1 gn1 sg13_lv_nmos w=0.74u l=0.13u
CL_n878 n878 gn1 2f
XPA_n880 n880 s7 ph1 ph1 sg13_lv_pmos w=1.12u l=0.13u
XPB_n880 n880 s10 ph1 ph1 sg13_lv_pmos w=1.12u l=0.13u
XNA_n880 n880 s7 m_n880 gn1 sg13_lv_nmos w=0.74u l=0.13u
XNB_n880 m_n880 s10 gn1 gn1 sg13_lv_nmos w=0.74u l=0.13u
CL_n880 n880 gn1 2f
XPA_n881 n881 sn7 ph1 ph1 sg13_lv_pmos w=1.12u l=0.13u
XPB_n881 n881 sn10 ph1 ph1 sg13_lv_pmos w=1.12u l=0.13u
XNA_n881 n881 sn7 m_n881 gn1 sg13_lv_nmos w=0.74u l=0.13u
XNB_n881 m_n881 sn10 gn1 gn1 sg13_lv_nmos w=0.74u l=0.13u
CL_n881 n881 gn1 2f
XPA_n883 n883 s13 ph1 ph1 sg13_lv_pmos w=1.12u l=0.13u
XPB_n883 n883 sn19 ph1 ph1 sg13_lv_pmos w=1.12u l=0.13u
XNA_n883 n883 s13 m_n883 gn1 sg13_lv_nmos w=0.74u l=0.13u
XNB_n883 m_n883 sn19 gn1 gn1 sg13_lv_nmos w=0.74u l=0.13u
CL_n883 n883 gn1 2f
XPA_n884 n884 sn13 ph1 ph1 sg13_lv_pmos w=1.12u l=0.13u
XPB_n884 n884 s19 ph1 ph1 sg13_lv_pmos w=1.12u l=0.13u
XNA_n884 n884 sn13 m_n884 gn1 sg13_lv_nmos w=0.74u l=0.13u
XNB_n884 m_n884 s19 gn1 gn1 sg13_lv_nmos w=0.74u l=0.13u
CL_n884 n884 gn1 2f
XPA_n886 n886 s13 ph1 ph1 sg13_lv_pmos w=1.12u l=0.13u
XPB_n886 n886 s19 ph1 ph1 sg13_lv_pmos w=1.12u l=0.13u
XNA_n886 n886 s13 m_n886 gn1 sg13_lv_nmos w=0.74u l=0.13u
XNB_n886 m_n886 s19 gn1 gn1 sg13_lv_nmos w=0.74u l=0.13u
CL_n886 n886 gn1 2f
XPA_n887 n887 sn13 ph1 ph1 sg13_lv_pmos w=1.12u l=0.13u
XPB_n887 n887 sn19 ph1 ph1 sg13_lv_pmos w=1.12u l=0.13u
XNA_n887 n887 sn13 m_n887 gn1 sg13_lv_nmos w=0.74u l=0.13u
XNB_n887 m_n887 sn19 gn1 gn1 sg13_lv_nmos w=0.74u l=0.13u
CL_n887 n887 gn1 2f
XPA_n889 n889 s20 ph1 ph1 sg13_lv_pmos w=1.12u l=0.13u
XPB_n889 n889 sn21 ph1 ph1 sg13_lv_pmos w=1.12u l=0.13u
XNA_n889 n889 s20 m_n889 gn1 sg13_lv_nmos w=0.74u l=0.13u
XNB_n889 m_n889 sn21 gn1 gn1 sg13_lv_nmos w=0.74u l=0.13u
CL_n889 n889 gn1 2f
XPA_n890 n890 sn20 ph1 ph1 sg13_lv_pmos w=1.12u l=0.13u
XPB_n890 n890 s21 ph1 ph1 sg13_lv_pmos w=1.12u l=0.13u
XNA_n890 n890 sn20 m_n890 gn1 sg13_lv_nmos w=0.74u l=0.13u
XNB_n890 m_n890 s21 gn1 gn1 sg13_lv_nmos w=0.74u l=0.13u
CL_n890 n890 gn1 2f
XPA_n892 n892 s20 ph1 ph1 sg13_lv_pmos w=1.12u l=0.13u
XPB_n892 n892 s21 ph1 ph1 sg13_lv_pmos w=1.12u l=0.13u
XNA_n892 n892 s20 m_n892 gn1 sg13_lv_nmos w=0.74u l=0.13u
XNB_n892 m_n892 s21 gn1 gn1 sg13_lv_nmos w=0.74u l=0.13u
CL_n892 n892 gn1 2f
XPA_n893 n893 sn20 ph1 ph1 sg13_lv_pmos w=1.12u l=0.13u
XPB_n893 n893 sn21 ph1 ph1 sg13_lv_pmos w=1.12u l=0.13u
XNA_n893 n893 sn20 m_n893 gn1 sg13_lv_nmos w=0.74u l=0.13u
XNB_n893 m_n893 sn21 gn1 gn1 sg13_lv_nmos w=0.74u l=0.13u
CL_n893 n893 gn1 2f
XPA_n895 n895 s24 ph1 ph1 sg13_lv_pmos w=1.12u l=0.13u
XPB_n895 n895 sn28 ph1 ph1 sg13_lv_pmos w=1.12u l=0.13u
XNA_n895 n895 s24 m_n895 gn1 sg13_lv_nmos w=0.74u l=0.13u
XNB_n895 m_n895 sn28 gn1 gn1 sg13_lv_nmos w=0.74u l=0.13u
CL_n895 n895 gn1 2f
XPA_n896 n896 sn24 ph1 ph1 sg13_lv_pmos w=1.12u l=0.13u
XPB_n896 n896 s28 ph1 ph1 sg13_lv_pmos w=1.12u l=0.13u
XNA_n896 n896 sn24 m_n896 gn1 sg13_lv_nmos w=0.74u l=0.13u
XNB_n896 m_n896 s28 gn1 gn1 sg13_lv_nmos w=0.74u l=0.13u
CL_n896 n896 gn1 2f
XPA_n898 n898 s24 ph1 ph1 sg13_lv_pmos w=1.12u l=0.13u
XPB_n898 n898 s28 ph1 ph1 sg13_lv_pmos w=1.12u l=0.13u
XNA_n898 n898 s24 m_n898 gn1 sg13_lv_nmos w=0.74u l=0.13u
XNB_n898 m_n898 s28 gn1 gn1 sg13_lv_nmos w=0.74u l=0.13u
CL_n898 n898 gn1 2f
XPA_n899 n899 sn24 ph1 ph1 sg13_lv_pmos w=1.12u l=0.13u
XPB_n899 n899 sn28 ph1 ph1 sg13_lv_pmos w=1.12u l=0.13u
XNA_n899 n899 sn24 m_n899 gn1 sg13_lv_nmos w=0.74u l=0.13u
XNB_n899 m_n899 sn28 gn1 gn1 sg13_lv_nmos w=0.74u l=0.13u
CL_n899 n899 gn1 2f
XPA_n901 n901 s29 ph1 ph1 sg13_lv_pmos w=1.12u l=0.13u
XPB_n901 n901 dn2 ph1 ph1 sg13_lv_pmos w=1.12u l=0.13u
XNA_n901 n901 s29 m_n901 gn1 sg13_lv_nmos w=0.74u l=0.13u
XNB_n901 m_n901 dn2 gn1 gn1 sg13_lv_nmos w=0.74u l=0.13u
CL_n901 n901 gn1 2f
XPA_n902 n902 sn29 ph1 ph1 sg13_lv_pmos w=1.12u l=0.13u
XPB_n902 n902 d2 ph1 ph1 sg13_lv_pmos w=1.12u l=0.13u
XNA_n902 n902 sn29 m_n902 gn1 sg13_lv_nmos w=0.74u l=0.13u
XNB_n902 m_n902 d2 gn1 gn1 sg13_lv_nmos w=0.74u l=0.13u
CL_n902 n902 gn1 2f
XPA_n904 n904 s29 ph1 ph1 sg13_lv_pmos w=1.12u l=0.13u
XPB_n904 n904 d2 ph1 ph1 sg13_lv_pmos w=1.12u l=0.13u
XNA_n904 n904 s29 m_n904 gn1 sg13_lv_nmos w=0.74u l=0.13u
XNB_n904 m_n904 d2 gn1 gn1 sg13_lv_nmos w=0.74u l=0.13u
CL_n904 n904 gn1 2f
XPA_n905 n905 sn29 ph1 ph1 sg13_lv_pmos w=1.12u l=0.13u
XPB_n905 n905 dn2 ph1 ph1 sg13_lv_pmos w=1.12u l=0.13u
XNA_n905 n905 sn29 m_n905 gn1 sg13_lv_nmos w=0.74u l=0.13u
XNB_n905 m_n905 dn2 gn1 gn1 sg13_lv_nmos w=0.74u l=0.13u
CL_n905 n905 gn1 2f
XPA_n907 n907 d3 ph1 ph1 sg13_lv_pmos w=1.12u l=0.13u
XPB_n907 n907 dn7 ph1 ph1 sg13_lv_pmos w=1.12u l=0.13u
XNA_n907 n907 d3 m_n907 gn1 sg13_lv_nmos w=0.74u l=0.13u
XNB_n907 m_n907 dn7 gn1 gn1 sg13_lv_nmos w=0.74u l=0.13u
CL_n907 n907 gn1 2f
XPA_n908 n908 dn3 ph1 ph1 sg13_lv_pmos w=1.12u l=0.13u
XPB_n908 n908 d7 ph1 ph1 sg13_lv_pmos w=1.12u l=0.13u
XNA_n908 n908 dn3 m_n908 gn1 sg13_lv_nmos w=0.74u l=0.13u
XNB_n908 m_n908 d7 gn1 gn1 sg13_lv_nmos w=0.74u l=0.13u
CL_n908 n908 gn1 2f
XPA_n91 n91 d15 ph1 ph1 sg13_lv_pmos w=1.12u l=0.13u
XPB_n91 n91 dn19 ph1 ph1 sg13_lv_pmos w=1.12u l=0.13u
XNA_n91 n91 d15 m_n91 gn1 sg13_lv_nmos w=0.74u l=0.13u
XNB_n91 m_n91 dn19 gn1 gn1 sg13_lv_nmos w=0.74u l=0.13u
CL_n91 n91 gn1 2f
XPA_n910 n910 d3 ph1 ph1 sg13_lv_pmos w=1.12u l=0.13u
XPB_n910 n910 d7 ph1 ph1 sg13_lv_pmos w=1.12u l=0.13u
XNA_n910 n910 d3 m_n910 gn1 sg13_lv_nmos w=0.74u l=0.13u
XNB_n910 m_n910 d7 gn1 gn1 sg13_lv_nmos w=0.74u l=0.13u
CL_n910 n910 gn1 2f
XPA_n911 n911 dn3 ph1 ph1 sg13_lv_pmos w=1.12u l=0.13u
XPB_n911 n911 dn7 ph1 ph1 sg13_lv_pmos w=1.12u l=0.13u
XNA_n911 n911 dn3 m_n911 gn1 sg13_lv_nmos w=0.74u l=0.13u
XNB_n911 m_n911 dn7 gn1 gn1 sg13_lv_nmos w=0.74u l=0.13u
CL_n911 n911 gn1 2f
XPA_n913 n913 d10 ph1 ph1 sg13_lv_pmos w=1.12u l=0.13u
XPB_n913 n913 dn11 ph1 ph1 sg13_lv_pmos w=1.12u l=0.13u
XNA_n913 n913 d10 m_n913 gn1 sg13_lv_nmos w=0.74u l=0.13u
XNB_n913 m_n913 dn11 gn1 gn1 sg13_lv_nmos w=0.74u l=0.13u
CL_n913 n913 gn1 2f
XPA_n914 n914 dn10 ph1 ph1 sg13_lv_pmos w=1.12u l=0.13u
XPB_n914 n914 d11 ph1 ph1 sg13_lv_pmos w=1.12u l=0.13u
XNA_n914 n914 dn10 m_n914 gn1 sg13_lv_nmos w=0.74u l=0.13u
XNB_n914 m_n914 d11 gn1 gn1 sg13_lv_nmos w=0.74u l=0.13u
CL_n914 n914 gn1 2f
XPA_n916 n916 d10 ph1 ph1 sg13_lv_pmos w=1.12u l=0.13u
XPB_n916 n916 d11 ph1 ph1 sg13_lv_pmos w=1.12u l=0.13u
XNA_n916 n916 d10 m_n916 gn1 sg13_lv_nmos w=0.74u l=0.13u
XNB_n916 m_n916 d11 gn1 gn1 sg13_lv_nmos w=0.74u l=0.13u
CL_n916 n916 gn1 2f
XPA_n917 n917 dn10 ph1 ph1 sg13_lv_pmos w=1.12u l=0.13u
XPB_n917 n917 dn11 ph1 ph1 sg13_lv_pmos w=1.12u l=0.13u
XNA_n917 n917 dn10 m_n917 gn1 sg13_lv_nmos w=0.74u l=0.13u
XNB_n917 m_n917 dn11 gn1 gn1 sg13_lv_nmos w=0.74u l=0.13u
CL_n917 n917 gn1 2f
XPA_n919 n919 d12 ph1 ph1 sg13_lv_pmos w=1.12u l=0.13u
XPB_n919 n919 dn18 ph1 ph1 sg13_lv_pmos w=1.12u l=0.13u
XNA_n919 n919 d12 m_n919 gn1 sg13_lv_nmos w=0.74u l=0.13u
XNB_n919 m_n919 dn18 gn1 gn1 sg13_lv_nmos w=0.74u l=0.13u
CL_n919 n919 gn1 2f
XPA_n92 n92 dn15 ph1 ph1 sg13_lv_pmos w=1.12u l=0.13u
XPB_n92 n92 d19 ph1 ph1 sg13_lv_pmos w=1.12u l=0.13u
XNA_n92 n92 dn15 m_n92 gn1 sg13_lv_nmos w=0.74u l=0.13u
XNB_n92 m_n92 d19 gn1 gn1 sg13_lv_nmos w=0.74u l=0.13u
CL_n92 n92 gn1 2f
XPA_n920 n920 dn12 ph1 ph1 sg13_lv_pmos w=1.12u l=0.13u
XPB_n920 n920 d18 ph1 ph1 sg13_lv_pmos w=1.12u l=0.13u
XNA_n920 n920 dn12 m_n920 gn1 sg13_lv_nmos w=0.74u l=0.13u
XNB_n920 m_n920 d18 gn1 gn1 sg13_lv_nmos w=0.74u l=0.13u
CL_n920 n920 gn1 2f
XPA_n922 n922 d12 ph1 ph1 sg13_lv_pmos w=1.12u l=0.13u
XPB_n922 n922 d18 ph1 ph1 sg13_lv_pmos w=1.12u l=0.13u
XNA_n922 n922 d12 m_n922 gn1 sg13_lv_nmos w=0.74u l=0.13u
XNB_n922 m_n922 d18 gn1 gn1 sg13_lv_nmos w=0.74u l=0.13u
CL_n922 n922 gn1 2f
XPA_n923 n923 dn12 ph1 ph1 sg13_lv_pmos w=1.12u l=0.13u
XPB_n923 n923 dn18 ph1 ph1 sg13_lv_pmos w=1.12u l=0.13u
XNA_n923 n923 dn12 m_n923 gn1 sg13_lv_nmos w=0.74u l=0.13u
XNB_n923 m_n923 dn18 gn1 gn1 sg13_lv_nmos w=0.74u l=0.13u
CL_n923 n923 gn1 2f
XPA_n925 n925 d21 ph1 ph1 sg13_lv_pmos w=1.12u l=0.13u
XPB_n925 n925 dn24 ph1 ph1 sg13_lv_pmos w=1.12u l=0.13u
XNA_n925 n925 d21 m_n925 gn1 sg13_lv_nmos w=0.74u l=0.13u
XNB_n925 m_n925 dn24 gn1 gn1 sg13_lv_nmos w=0.74u l=0.13u
CL_n925 n925 gn1 2f
XPA_n926 n926 dn21 ph1 ph1 sg13_lv_pmos w=1.12u l=0.13u
XPB_n926 n926 d24 ph1 ph1 sg13_lv_pmos w=1.12u l=0.13u
XNA_n926 n926 dn21 m_n926 gn1 sg13_lv_nmos w=0.74u l=0.13u
XNB_n926 m_n926 d24 gn1 gn1 sg13_lv_nmos w=0.74u l=0.13u
CL_n926 n926 gn1 2f
XPA_n928 n928 d21 ph1 ph1 sg13_lv_pmos w=1.12u l=0.13u
XPB_n928 n928 d24 ph1 ph1 sg13_lv_pmos w=1.12u l=0.13u
XNA_n928 n928 d21 m_n928 gn1 sg13_lv_nmos w=0.74u l=0.13u
XNB_n928 m_n928 d24 gn1 gn1 sg13_lv_nmos w=0.74u l=0.13u
CL_n928 n928 gn1 2f
XPA_n929 n929 dn21 ph1 ph1 sg13_lv_pmos w=1.12u l=0.13u
XPB_n929 n929 dn24 ph1 ph1 sg13_lv_pmos w=1.12u l=0.13u
XNA_n929 n929 dn21 m_n929 gn1 sg13_lv_nmos w=0.74u l=0.13u
XNB_n929 m_n929 dn24 gn1 gn1 sg13_lv_nmos w=0.74u l=0.13u
CL_n929 n929 gn1 2f
XPA_n931 n931 d25 ph1 ph1 sg13_lv_pmos w=1.12u l=0.13u
XPB_n931 n931 dn26 ph1 ph1 sg13_lv_pmos w=1.12u l=0.13u
XNA_n931 n931 d25 m_n931 gn1 sg13_lv_nmos w=0.74u l=0.13u
XNB_n931 m_n931 dn26 gn1 gn1 sg13_lv_nmos w=0.74u l=0.13u
CL_n931 n931 gn1 2f
XPA_n932 n932 dn25 ph1 ph1 sg13_lv_pmos w=1.12u l=0.13u
XPB_n932 n932 d26 ph1 ph1 sg13_lv_pmos w=1.12u l=0.13u
XNA_n932 n932 dn25 m_n932 gn1 sg13_lv_nmos w=0.74u l=0.13u
XNB_n932 m_n932 d26 gn1 gn1 sg13_lv_nmos w=0.74u l=0.13u
CL_n932 n932 gn1 2f
XPA_n934 n934 d25 ph1 ph1 sg13_lv_pmos w=1.12u l=0.13u
XPB_n934 n934 d26 ph1 ph1 sg13_lv_pmos w=1.12u l=0.13u
XNA_n934 n934 d25 m_n934 gn1 sg13_lv_nmos w=0.74u l=0.13u
XNB_n934 m_n934 d26 gn1 gn1 sg13_lv_nmos w=0.74u l=0.13u
CL_n934 n934 gn1 2f
XPA_n935 n935 dn25 ph1 ph1 sg13_lv_pmos w=1.12u l=0.13u
XPB_n935 n935 dn26 ph1 ph1 sg13_lv_pmos w=1.12u l=0.13u
XNA_n935 n935 dn25 m_n935 gn1 sg13_lv_nmos w=0.74u l=0.13u
XNB_n935 m_n935 dn26 gn1 gn1 sg13_lv_nmos w=0.74u l=0.13u
CL_n935 n935 gn1 2f
XPA_n937 n937 d27 ph1 ph1 sg13_lv_pmos w=1.12u l=0.13u
XPB_n937 n937 dn28 ph1 ph1 sg13_lv_pmos w=1.12u l=0.13u
XNA_n937 n937 d27 m_n937 gn1 sg13_lv_nmos w=0.74u l=0.13u
XNB_n937 m_n937 dn28 gn1 gn1 sg13_lv_nmos w=0.74u l=0.13u
CL_n937 n937 gn1 2f
XPA_n938 n938 dn27 ph1 ph1 sg13_lv_pmos w=1.12u l=0.13u
XPB_n938 n938 d28 ph1 ph1 sg13_lv_pmos w=1.12u l=0.13u
XNA_n938 n938 dn27 m_n938 gn1 sg13_lv_nmos w=0.74u l=0.13u
XNB_n938 m_n938 d28 gn1 gn1 sg13_lv_nmos w=0.74u l=0.13u
CL_n938 n938 gn1 2f
XPA_n94 n94 d15 ph1 ph1 sg13_lv_pmos w=1.12u l=0.13u
XPB_n94 n94 d19 ph1 ph1 sg13_lv_pmos w=1.12u l=0.13u
XNA_n94 n94 d15 m_n94 gn1 sg13_lv_nmos w=0.74u l=0.13u
XNB_n94 m_n94 d19 gn1 gn1 sg13_lv_nmos w=0.74u l=0.13u
CL_n94 n94 gn1 2f
XPA_n940 n940 d27 ph1 ph1 sg13_lv_pmos w=1.12u l=0.13u
XPB_n940 n940 d28 ph1 ph1 sg13_lv_pmos w=1.12u l=0.13u
XNA_n940 n940 d27 m_n940 gn1 sg13_lv_nmos w=0.74u l=0.13u
XNB_n940 m_n940 d28 gn1 gn1 sg13_lv_nmos w=0.74u l=0.13u
CL_n940 n940 gn1 2f
XPA_n941 n941 dn27 ph1 ph1 sg13_lv_pmos w=1.12u l=0.13u
XPB_n941 n941 dn28 ph1 ph1 sg13_lv_pmos w=1.12u l=0.13u
XNA_n941 n941 dn27 m_n941 gn1 sg13_lv_nmos w=0.74u l=0.13u
XNB_n941 m_n941 dn28 gn1 gn1 sg13_lv_nmos w=0.74u l=0.13u
CL_n941 n941 gn1 2f
XPA_n95 n95 dn15 ph1 ph1 sg13_lv_pmos w=1.12u l=0.13u
XPB_n95 n95 dn19 ph1 ph1 sg13_lv_pmos w=1.12u l=0.13u
XNA_n95 n95 dn15 m_n95 gn1 sg13_lv_nmos w=0.74u l=0.13u
XNB_n95 m_n95 dn19 gn1 gn1 sg13_lv_nmos w=0.74u l=0.13u
CL_n95 n95 gn1 2f
XPA_n97 n97 d21 ph1 ph1 sg13_lv_pmos w=1.12u l=0.13u
XPB_n97 n97 dn22 ph1 ph1 sg13_lv_pmos w=1.12u l=0.13u
XNA_n97 n97 d21 m_n97 gn1 sg13_lv_nmos w=0.74u l=0.13u
XNB_n97 m_n97 dn22 gn1 gn1 sg13_lv_nmos w=0.74u l=0.13u
CL_n97 n97 gn1 2f
XPA_n98 n98 dn21 ph1 ph1 sg13_lv_pmos w=1.12u l=0.13u
XPB_n98 n98 d22 ph1 ph1 sg13_lv_pmos w=1.12u l=0.13u
XNA_n98 n98 dn21 m_n98 gn1 sg13_lv_nmos w=0.74u l=0.13u
XNB_n98 m_n98 d22 gn1 gn1 sg13_lv_nmos w=0.74u l=0.13u
CL_n98 n98 gn1 2f
XPA_n985 n985 d30 ph1 ph1 sg13_lv_pmos w=1.12u l=0.13u
XPB_n985 n985 dn31 ph1 ph1 sg13_lv_pmos w=1.12u l=0.13u
XNA_n985 n985 d30 m_n985 gn1 sg13_lv_nmos w=0.74u l=0.13u
XNB_n985 m_n985 dn31 gn1 gn1 sg13_lv_nmos w=0.74u l=0.13u
CL_n985 n985 gn1 2f
XPA_n986 n986 dn30 ph1 ph1 sg13_lv_pmos w=1.12u l=0.13u
XPB_n986 n986 d31 ph1 ph1 sg13_lv_pmos w=1.12u l=0.13u
XNA_n986 n986 dn30 m_n986 gn1 sg13_lv_nmos w=0.74u l=0.13u
XNB_n986 m_n986 d31 gn1 gn1 sg13_lv_nmos w=0.74u l=0.13u
CL_n986 n986 gn1 2f
XPA_n988 n988 d30 ph1 ph1 sg13_lv_pmos w=1.12u l=0.13u
XPB_n988 n988 d31 ph1 ph1 sg13_lv_pmos w=1.12u l=0.13u
XNA_n988 n988 d30 m_n988 gn1 sg13_lv_nmos w=0.74u l=0.13u
XNB_n988 m_n988 d31 gn1 gn1 sg13_lv_nmos w=0.74u l=0.13u
CL_n988 n988 gn1 2f
XPA_n989 n989 dn30 ph1 ph1 sg13_lv_pmos w=1.12u l=0.13u
XPB_n989 n989 dn31 ph1 ph1 sg13_lv_pmos w=1.12u l=0.13u
XNA_n989 n989 dn30 m_n989 gn1 sg13_lv_nmos w=0.74u l=0.13u
XNB_n989 m_n989 dn31 gn1 gn1 sg13_lv_nmos w=0.74u l=0.13u
CL_n989 n989 gn1 2f
XPA_n102 n102 n100 ph1 ph1 sg13_lv_pmos w=1.12u l=0.13u
XPB_n102 n102 n101 ph1 ph1 sg13_lv_pmos w=1.12u l=0.13u
XNA_n102 n102 n100 m_n102 gn1 sg13_lv_nmos w=0.74u l=0.13u
XNB_n102 m_n102 n101 gn1 gn1 sg13_lv_nmos w=0.74u l=0.13u
CL_n102 n102 gn1 2f
XPA_n1035 n1035 n1033 ph1 ph1 sg13_lv_pmos w=1.12u l=0.13u
XPB_n1035 n1035 n1034 ph1 ph1 sg13_lv_pmos w=1.12u l=0.13u
XNA_n1035 n1035 n1033 m_n1035 gn1 sg13_lv_nmos w=0.74u l=0.13u
XNB_n1035 m_n1035 n1034 gn1 gn1 sg13_lv_nmos w=0.74u l=0.13u
CL_n1035 n1035 gn1 2f
XPA_n1038 n1038 n1036 ph1 ph1 sg13_lv_pmos w=1.12u l=0.13u
XPB_n1038 n1038 n1037 ph1 ph1 sg13_lv_pmos w=1.12u l=0.13u
XNA_n1038 n1038 n1036 m_n1038 gn1 sg13_lv_nmos w=0.74u l=0.13u
XNB_n1038 m_n1038 n1037 gn1 gn1 sg13_lv_nmos w=0.74u l=0.13u
CL_n1038 n1038 gn1 2f
XPA_n1041 n1041 n1039 ph1 ph1 sg13_lv_pmos w=1.12u l=0.13u
XPB_n1041 n1041 n1040 ph1 ph1 sg13_lv_pmos w=1.12u l=0.13u
XNA_n1041 n1041 n1039 m_n1041 gn1 sg13_lv_nmos w=0.74u l=0.13u
XNB_n1041 m_n1041 n1040 gn1 gn1 sg13_lv_nmos w=0.74u l=0.13u
CL_n1041 n1041 gn1 2f
XPA_n1044 n1044 n1042 ph1 ph1 sg13_lv_pmos w=1.12u l=0.13u
XPB_n1044 n1044 n1043 ph1 ph1 sg13_lv_pmos w=1.12u l=0.13u
XNA_n1044 n1044 n1042 m_n1044 gn1 sg13_lv_nmos w=0.74u l=0.13u
XNB_n1044 m_n1044 n1043 gn1 gn1 sg13_lv_nmos w=0.74u l=0.13u
CL_n1044 n1044 gn1 2f
XPA_n1047 n1047 n1045 ph1 ph1 sg13_lv_pmos w=1.12u l=0.13u
XPB_n1047 n1047 n1046 ph1 ph1 sg13_lv_pmos w=1.12u l=0.13u
XNA_n1047 n1047 n1045 m_n1047 gn1 sg13_lv_nmos w=0.74u l=0.13u
XNB_n1047 m_n1047 n1046 gn1 gn1 sg13_lv_nmos w=0.74u l=0.13u
CL_n1047 n1047 gn1 2f
XPA_n105 n105 n103 ph1 ph1 sg13_lv_pmos w=1.12u l=0.13u
XPB_n105 n105 n104 ph1 ph1 sg13_lv_pmos w=1.12u l=0.13u
XNA_n105 n105 n103 m_n105 gn1 sg13_lv_nmos w=0.74u l=0.13u
XNB_n105 m_n105 n104 gn1 gn1 sg13_lv_nmos w=0.74u l=0.13u
CL_n105 n105 gn1 2f
XPA_n1050 n1050 n1048 ph1 ph1 sg13_lv_pmos w=1.12u l=0.13u
XPB_n1050 n1050 n1049 ph1 ph1 sg13_lv_pmos w=1.12u l=0.13u
XNA_n1050 n1050 n1048 m_n1050 gn1 sg13_lv_nmos w=0.74u l=0.13u
XNB_n1050 m_n1050 n1049 gn1 gn1 sg13_lv_nmos w=0.74u l=0.13u
CL_n1050 n1050 gn1 2f
XPA_n1053 n1053 n1051 ph1 ph1 sg13_lv_pmos w=1.12u l=0.13u
XPB_n1053 n1053 n1052 ph1 ph1 sg13_lv_pmos w=1.12u l=0.13u
XNA_n1053 n1053 n1051 m_n1053 gn1 sg13_lv_nmos w=0.74u l=0.13u
XNB_n1053 m_n1053 n1052 gn1 gn1 sg13_lv_nmos w=0.74u l=0.13u
CL_n1053 n1053 gn1 2f
XPA_n1056 n1056 n1054 ph1 ph1 sg13_lv_pmos w=1.12u l=0.13u
XPB_n1056 n1056 n1055 ph1 ph1 sg13_lv_pmos w=1.12u l=0.13u
XNA_n1056 n1056 n1054 m_n1056 gn1 sg13_lv_nmos w=0.74u l=0.13u
XNB_n1056 m_n1056 n1055 gn1 gn1 sg13_lv_nmos w=0.74u l=0.13u
CL_n1056 n1056 gn1 2f
XPA_n1059 n1059 n1057 ph1 ph1 sg13_lv_pmos w=1.12u l=0.13u
XPB_n1059 n1059 n1058 ph1 ph1 sg13_lv_pmos w=1.12u l=0.13u
XNA_n1059 n1059 n1057 m_n1059 gn1 sg13_lv_nmos w=0.74u l=0.13u
XNB_n1059 m_n1059 n1058 gn1 gn1 sg13_lv_nmos w=0.74u l=0.13u
CL_n1059 n1059 gn1 2f
XPA_n1062 n1062 n1060 ph1 ph1 sg13_lv_pmos w=1.12u l=0.13u
XPB_n1062 n1062 n1061 ph1 ph1 sg13_lv_pmos w=1.12u l=0.13u
XNA_n1062 n1062 n1060 m_n1062 gn1 sg13_lv_nmos w=0.74u l=0.13u
XNB_n1062 m_n1062 n1061 gn1 gn1 sg13_lv_nmos w=0.74u l=0.13u
CL_n1062 n1062 gn1 2f
XPA_n1065 n1065 n1063 ph1 ph1 sg13_lv_pmos w=1.12u l=0.13u
XPB_n1065 n1065 n1064 ph1 ph1 sg13_lv_pmos w=1.12u l=0.13u
XNA_n1065 n1065 n1063 m_n1065 gn1 sg13_lv_nmos w=0.74u l=0.13u
XNB_n1065 m_n1065 n1064 gn1 gn1 sg13_lv_nmos w=0.74u l=0.13u
CL_n1065 n1065 gn1 2f
XPA_n1068 n1068 n1066 ph1 ph1 sg13_lv_pmos w=1.12u l=0.13u
XPB_n1068 n1068 n1067 ph1 ph1 sg13_lv_pmos w=1.12u l=0.13u
XNA_n1068 n1068 n1066 m_n1068 gn1 sg13_lv_nmos w=0.74u l=0.13u
XNB_n1068 m_n1068 n1067 gn1 gn1 sg13_lv_nmos w=0.74u l=0.13u
CL_n1068 n1068 gn1 2f
XPA_n1071 n1071 n1069 ph1 ph1 sg13_lv_pmos w=1.12u l=0.13u
XPB_n1071 n1071 n1070 ph1 ph1 sg13_lv_pmos w=1.12u l=0.13u
XNA_n1071 n1071 n1069 m_n1071 gn1 sg13_lv_nmos w=0.74u l=0.13u
XNB_n1071 m_n1071 n1070 gn1 gn1 sg13_lv_nmos w=0.74u l=0.13u
CL_n1071 n1071 gn1 2f
XPA_n1074 n1074 n1072 ph1 ph1 sg13_lv_pmos w=1.12u l=0.13u
XPB_n1074 n1074 n1073 ph1 ph1 sg13_lv_pmos w=1.12u l=0.13u
XNA_n1074 n1074 n1072 m_n1074 gn1 sg13_lv_nmos w=0.74u l=0.13u
XNB_n1074 m_n1074 n1073 gn1 gn1 sg13_lv_nmos w=0.74u l=0.13u
CL_n1074 n1074 gn1 2f
XPA_n1077 n1077 n1075 ph1 ph1 sg13_lv_pmos w=1.12u l=0.13u
XPB_n1077 n1077 n1076 ph1 ph1 sg13_lv_pmos w=1.12u l=0.13u
XNA_n1077 n1077 n1075 m_n1077 gn1 sg13_lv_nmos w=0.74u l=0.13u
XNB_n1077 m_n1077 n1076 gn1 gn1 sg13_lv_nmos w=0.74u l=0.13u
CL_n1077 n1077 gn1 2f
XPA_n108 n108 n106 ph1 ph1 sg13_lv_pmos w=1.12u l=0.13u
XPB_n108 n108 n107 ph1 ph1 sg13_lv_pmos w=1.12u l=0.13u
XNA_n108 n108 n106 m_n108 gn1 sg13_lv_nmos w=0.74u l=0.13u
XNB_n108 m_n108 n107 gn1 gn1 sg13_lv_nmos w=0.74u l=0.13u
CL_n108 n108 gn1 2f
XPA_n1080 n1080 n1078 ph1 ph1 sg13_lv_pmos w=1.12u l=0.13u
XPB_n1080 n1080 n1079 ph1 ph1 sg13_lv_pmos w=1.12u l=0.13u
XNA_n1080 n1080 n1078 m_n1080 gn1 sg13_lv_nmos w=0.74u l=0.13u
XNB_n1080 m_n1080 n1079 gn1 gn1 sg13_lv_nmos w=0.74u l=0.13u
CL_n1080 n1080 gn1 2f
XPA_n1083 n1083 n1081 ph1 ph1 sg13_lv_pmos w=1.12u l=0.13u
XPB_n1083 n1083 n1082 ph1 ph1 sg13_lv_pmos w=1.12u l=0.13u
XNA_n1083 n1083 n1081 m_n1083 gn1 sg13_lv_nmos w=0.74u l=0.13u
XNB_n1083 m_n1083 n1082 gn1 gn1 sg13_lv_nmos w=0.74u l=0.13u
CL_n1083 n1083 gn1 2f
XPA_n1086 n1086 n1084 ph1 ph1 sg13_lv_pmos w=1.12u l=0.13u
XPB_n1086 n1086 n1085 ph1 ph1 sg13_lv_pmos w=1.12u l=0.13u
XNA_n1086 n1086 n1084 m_n1086 gn1 sg13_lv_nmos w=0.74u l=0.13u
XNB_n1086 m_n1086 n1085 gn1 gn1 sg13_lv_nmos w=0.74u l=0.13u
CL_n1086 n1086 gn1 2f
XPA_n1089 n1089 n1087 ph1 ph1 sg13_lv_pmos w=1.12u l=0.13u
XPB_n1089 n1089 n1088 ph1 ph1 sg13_lv_pmos w=1.12u l=0.13u
XNA_n1089 n1089 n1087 m_n1089 gn1 sg13_lv_nmos w=0.74u l=0.13u
XNB_n1089 m_n1089 n1088 gn1 gn1 sg13_lv_nmos w=0.74u l=0.13u
CL_n1089 n1089 gn1 2f
XPA_n1092 n1092 n1090 ph1 ph1 sg13_lv_pmos w=1.12u l=0.13u
XPB_n1092 n1092 n1091 ph1 ph1 sg13_lv_pmos w=1.12u l=0.13u
XNA_n1092 n1092 n1090 m_n1092 gn1 sg13_lv_nmos w=0.74u l=0.13u
XNB_n1092 m_n1092 n1091 gn1 gn1 sg13_lv_nmos w=0.74u l=0.13u
CL_n1092 n1092 gn1 2f
XPA_n1095 n1095 n1093 ph1 ph1 sg13_lv_pmos w=1.12u l=0.13u
XPB_n1095 n1095 n1094 ph1 ph1 sg13_lv_pmos w=1.12u l=0.13u
XNA_n1095 n1095 n1093 m_n1095 gn1 sg13_lv_nmos w=0.74u l=0.13u
XNB_n1095 m_n1095 n1094 gn1 gn1 sg13_lv_nmos w=0.74u l=0.13u
CL_n1095 n1095 gn1 2f
XPA_n1098 n1098 n1096 ph1 ph1 sg13_lv_pmos w=1.12u l=0.13u
XPB_n1098 n1098 n1097 ph1 ph1 sg13_lv_pmos w=1.12u l=0.13u
XNA_n1098 n1098 n1096 m_n1098 gn1 sg13_lv_nmos w=0.74u l=0.13u
XNB_n1098 m_n1098 n1097 gn1 gn1 sg13_lv_nmos w=0.74u l=0.13u
CL_n1098 n1098 gn1 2f
XPA_n1101 n1101 n1099 ph1 ph1 sg13_lv_pmos w=1.12u l=0.13u
XPB_n1101 n1101 n1100 ph1 ph1 sg13_lv_pmos w=1.12u l=0.13u
XNA_n1101 n1101 n1099 m_n1101 gn1 sg13_lv_nmos w=0.74u l=0.13u
XNB_n1101 m_n1101 n1100 gn1 gn1 sg13_lv_nmos w=0.74u l=0.13u
CL_n1101 n1101 gn1 2f
XPA_n1104 n1104 n1102 ph1 ph1 sg13_lv_pmos w=1.12u l=0.13u
XPB_n1104 n1104 n1103 ph1 ph1 sg13_lv_pmos w=1.12u l=0.13u
XNA_n1104 n1104 n1102 m_n1104 gn1 sg13_lv_nmos w=0.74u l=0.13u
XNB_n1104 m_n1104 n1103 gn1 gn1 sg13_lv_nmos w=0.74u l=0.13u
CL_n1104 n1104 gn1 2f
XPA_n1107 n1107 n1105 ph1 ph1 sg13_lv_pmos w=1.12u l=0.13u
XPB_n1107 n1107 n1106 ph1 ph1 sg13_lv_pmos w=1.12u l=0.13u
XNA_n1107 n1107 n1105 m_n1107 gn1 sg13_lv_nmos w=0.74u l=0.13u
XNB_n1107 m_n1107 n1106 gn1 gn1 sg13_lv_nmos w=0.74u l=0.13u
CL_n1107 n1107 gn1 2f
XPA_n1110 n1110 n1108 ph1 ph1 sg13_lv_pmos w=1.12u l=0.13u
XPB_n1110 n1110 n1109 ph1 ph1 sg13_lv_pmos w=1.12u l=0.13u
XNA_n1110 n1110 n1108 m_n1110 gn1 sg13_lv_nmos w=0.74u l=0.13u
XNB_n1110 m_n1110 n1109 gn1 gn1 sg13_lv_nmos w=0.74u l=0.13u
CL_n1110 n1110 gn1 2f
XPA_n1113 n1113 n1111 ph1 ph1 sg13_lv_pmos w=1.12u l=0.13u
XPB_n1113 n1113 n1112 ph1 ph1 sg13_lv_pmos w=1.12u l=0.13u
XNA_n1113 n1113 n1111 m_n1113 gn1 sg13_lv_nmos w=0.74u l=0.13u
XNB_n1113 m_n1113 n1112 gn1 gn1 sg13_lv_nmos w=0.74u l=0.13u
CL_n1113 n1113 gn1 2f
XPA_n1116 n1116 n1114 ph1 ph1 sg13_lv_pmos w=1.12u l=0.13u
XPB_n1116 n1116 n1115 ph1 ph1 sg13_lv_pmos w=1.12u l=0.13u
XNA_n1116 n1116 n1114 m_n1116 gn1 sg13_lv_nmos w=0.74u l=0.13u
XNB_n1116 m_n1116 n1115 gn1 gn1 sg13_lv_nmos w=0.74u l=0.13u
CL_n1116 n1116 gn1 2f
XPA_n1161 n1161 n1159 ph1 ph1 sg13_lv_pmos w=1.12u l=0.13u
XPB_n1161 n1161 n1160 ph1 ph1 sg13_lv_pmos w=1.12u l=0.13u
XNA_n1161 n1161 n1159 m_n1161 gn1 sg13_lv_nmos w=0.74u l=0.13u
XNB_n1161 m_n1161 n1160 gn1 gn1 sg13_lv_nmos w=0.74u l=0.13u
CL_n1161 n1161 gn1 2f
XPA_n1164 n1164 n1162 ph1 ph1 sg13_lv_pmos w=1.12u l=0.13u
XPB_n1164 n1164 n1163 ph1 ph1 sg13_lv_pmos w=1.12u l=0.13u
XNA_n1164 n1164 n1162 m_n1164 gn1 sg13_lv_nmos w=0.74u l=0.13u
XNB_n1164 m_n1164 n1163 gn1 gn1 sg13_lv_nmos w=0.74u l=0.13u
CL_n1164 n1164 gn1 2f
XPA_n12 n12 n10 ph1 ph1 sg13_lv_pmos w=1.12u l=0.13u
XPB_n12 n12 n11 ph1 ph1 sg13_lv_pmos w=1.12u l=0.13u
XNA_n12 n12 n10 m_n12 gn1 sg13_lv_nmos w=0.74u l=0.13u
XNB_n12 m_n12 n11 gn1 gn1 sg13_lv_nmos w=0.74u l=0.13u
CL_n12 n12 gn1 2f
XPA_n1209 n1209 n1207 ph1 ph1 sg13_lv_pmos w=1.12u l=0.13u
XPB_n1209 n1209 n1208 ph1 ph1 sg13_lv_pmos w=1.12u l=0.13u
XNA_n1209 n1209 n1207 m_n1209 gn1 sg13_lv_nmos w=0.74u l=0.13u
XNB_n1209 m_n1209 n1208 gn1 gn1 sg13_lv_nmos w=0.74u l=0.13u
CL_n1209 n1209 gn1 2f
XPA_n1212 n1212 n1210 ph1 ph1 sg13_lv_pmos w=1.12u l=0.13u
XPB_n1212 n1212 n1211 ph1 ph1 sg13_lv_pmos w=1.12u l=0.13u
XNA_n1212 n1212 n1210 m_n1212 gn1 sg13_lv_nmos w=0.74u l=0.13u
XNB_n1212 m_n1212 n1211 gn1 gn1 sg13_lv_nmos w=0.74u l=0.13u
CL_n1212 n1212 gn1 2f
XPA_n1215 n1215 n1213 ph1 ph1 sg13_lv_pmos w=1.12u l=0.13u
XPB_n1215 n1215 n1214 ph1 ph1 sg13_lv_pmos w=1.12u l=0.13u
XNA_n1215 n1215 n1213 m_n1215 gn1 sg13_lv_nmos w=0.74u l=0.13u
XNB_n1215 m_n1215 n1214 gn1 gn1 sg13_lv_nmos w=0.74u l=0.13u
CL_n1215 n1215 gn1 2f
XPA_n1218 n1218 n1216 ph1 ph1 sg13_lv_pmos w=1.12u l=0.13u
XPB_n1218 n1218 n1217 ph1 ph1 sg13_lv_pmos w=1.12u l=0.13u
XNA_n1218 n1218 n1216 m_n1218 gn1 sg13_lv_nmos w=0.74u l=0.13u
XNB_n1218 m_n1218 n1217 gn1 gn1 sg13_lv_nmos w=0.74u l=0.13u
CL_n1218 n1218 gn1 2f
XPA_n1221 n1221 n1219 ph1 ph1 sg13_lv_pmos w=1.12u l=0.13u
XPB_n1221 n1221 n1220 ph1 ph1 sg13_lv_pmos w=1.12u l=0.13u
XNA_n1221 n1221 n1219 m_n1221 gn1 sg13_lv_nmos w=0.74u l=0.13u
XNB_n1221 m_n1221 n1220 gn1 gn1 sg13_lv_nmos w=0.74u l=0.13u
CL_n1221 n1221 gn1 2f
XPA_n1224 n1224 n1222 ph1 ph1 sg13_lv_pmos w=1.12u l=0.13u
XPB_n1224 n1224 n1223 ph1 ph1 sg13_lv_pmos w=1.12u l=0.13u
XNA_n1224 n1224 n1222 m_n1224 gn1 sg13_lv_nmos w=0.74u l=0.13u
XNB_n1224 m_n1224 n1223 gn1 gn1 sg13_lv_nmos w=0.74u l=0.13u
CL_n1224 n1224 gn1 2f
XPA_n1227 n1227 n1225 ph1 ph1 sg13_lv_pmos w=1.12u l=0.13u
XPB_n1227 n1227 n1226 ph1 ph1 sg13_lv_pmos w=1.12u l=0.13u
XNA_n1227 n1227 n1225 m_n1227 gn1 sg13_lv_nmos w=0.74u l=0.13u
XNB_n1227 m_n1227 n1226 gn1 gn1 sg13_lv_nmos w=0.74u l=0.13u
CL_n1227 n1227 gn1 2f
XPA_n1230 n1230 n1228 ph1 ph1 sg13_lv_pmos w=1.12u l=0.13u
XPB_n1230 n1230 n1229 ph1 ph1 sg13_lv_pmos w=1.12u l=0.13u
XNA_n1230 n1230 n1228 m_n1230 gn1 sg13_lv_nmos w=0.74u l=0.13u
XNB_n1230 m_n1230 n1229 gn1 gn1 sg13_lv_nmos w=0.74u l=0.13u
CL_n1230 n1230 gn1 2f
XPA_n1233 n1233 n1231 ph1 ph1 sg13_lv_pmos w=1.12u l=0.13u
XPB_n1233 n1233 n1232 ph1 ph1 sg13_lv_pmos w=1.12u l=0.13u
XNA_n1233 n1233 n1231 m_n1233 gn1 sg13_lv_nmos w=0.74u l=0.13u
XNB_n1233 m_n1233 n1232 gn1 gn1 sg13_lv_nmos w=0.74u l=0.13u
CL_n1233 n1233 gn1 2f
XPA_n1236 n1236 n1234 ph1 ph1 sg13_lv_pmos w=1.12u l=0.13u
XPB_n1236 n1236 n1235 ph1 ph1 sg13_lv_pmos w=1.12u l=0.13u
XNA_n1236 n1236 n1234 m_n1236 gn1 sg13_lv_nmos w=0.74u l=0.13u
XNB_n1236 m_n1236 n1235 gn1 gn1 sg13_lv_nmos w=0.74u l=0.13u
CL_n1236 n1236 gn1 2f
XPA_n1239 n1239 n1237 ph1 ph1 sg13_lv_pmos w=1.12u l=0.13u
XPB_n1239 n1239 n1238 ph1 ph1 sg13_lv_pmos w=1.12u l=0.13u
XNA_n1239 n1239 n1237 m_n1239 gn1 sg13_lv_nmos w=0.74u l=0.13u
XNB_n1239 m_n1239 n1238 gn1 gn1 sg13_lv_nmos w=0.74u l=0.13u
CL_n1239 n1239 gn1 2f
XPA_n1242 n1242 n1240 ph1 ph1 sg13_lv_pmos w=1.12u l=0.13u
XPB_n1242 n1242 n1241 ph1 ph1 sg13_lv_pmos w=1.12u l=0.13u
XNA_n1242 n1242 n1240 m_n1242 gn1 sg13_lv_nmos w=0.74u l=0.13u
XNB_n1242 m_n1242 n1241 gn1 gn1 sg13_lv_nmos w=0.74u l=0.13u
CL_n1242 n1242 gn1 2f
XPA_n1245 n1245 n1243 ph1 ph1 sg13_lv_pmos w=1.12u l=0.13u
XPB_n1245 n1245 n1244 ph1 ph1 sg13_lv_pmos w=1.12u l=0.13u
XNA_n1245 n1245 n1243 m_n1245 gn1 sg13_lv_nmos w=0.74u l=0.13u
XNB_n1245 m_n1245 n1244 gn1 gn1 sg13_lv_nmos w=0.74u l=0.13u
CL_n1245 n1245 gn1 2f
XPA_n1248 n1248 n1246 ph1 ph1 sg13_lv_pmos w=1.12u l=0.13u
XPB_n1248 n1248 n1247 ph1 ph1 sg13_lv_pmos w=1.12u l=0.13u
XNA_n1248 n1248 n1246 m_n1248 gn1 sg13_lv_nmos w=0.74u l=0.13u
XNB_n1248 m_n1248 n1247 gn1 gn1 sg13_lv_nmos w=0.74u l=0.13u
CL_n1248 n1248 gn1 2f
XPA_n1251 n1251 n1249 ph1 ph1 sg13_lv_pmos w=1.12u l=0.13u
XPB_n1251 n1251 n1250 ph1 ph1 sg13_lv_pmos w=1.12u l=0.13u
XNA_n1251 n1251 n1249 m_n1251 gn1 sg13_lv_nmos w=0.74u l=0.13u
XNB_n1251 m_n1251 n1250 gn1 gn1 sg13_lv_nmos w=0.74u l=0.13u
CL_n1251 n1251 gn1 2f
XPA_n1254 n1254 n1252 ph1 ph1 sg13_lv_pmos w=1.12u l=0.13u
XPB_n1254 n1254 n1253 ph1 ph1 sg13_lv_pmos w=1.12u l=0.13u
XNA_n1254 n1254 n1252 m_n1254 gn1 sg13_lv_nmos w=0.74u l=0.13u
XNB_n1254 m_n1254 n1253 gn1 gn1 sg13_lv_nmos w=0.74u l=0.13u
CL_n1254 n1254 gn1 2f
XPA_n1257 n1257 n1255 ph1 ph1 sg13_lv_pmos w=1.12u l=0.13u
XPB_n1257 n1257 n1256 ph1 ph1 sg13_lv_pmos w=1.12u l=0.13u
XNA_n1257 n1257 n1255 m_n1257 gn1 sg13_lv_nmos w=0.74u l=0.13u
XNB_n1257 m_n1257 n1256 gn1 gn1 sg13_lv_nmos w=0.74u l=0.13u
CL_n1257 n1257 gn1 2f
XPA_n1260 n1260 n1258 ph1 ph1 sg13_lv_pmos w=1.12u l=0.13u
XPB_n1260 n1260 n1259 ph1 ph1 sg13_lv_pmos w=1.12u l=0.13u
XNA_n1260 n1260 n1258 m_n1260 gn1 sg13_lv_nmos w=0.74u l=0.13u
XNB_n1260 m_n1260 n1259 gn1 gn1 sg13_lv_nmos w=0.74u l=0.13u
CL_n1260 n1260 gn1 2f
XPA_n1263 n1263 n1261 ph1 ph1 sg13_lv_pmos w=1.12u l=0.13u
XPB_n1263 n1263 n1262 ph1 ph1 sg13_lv_pmos w=1.12u l=0.13u
XNA_n1263 n1263 n1261 m_n1263 gn1 sg13_lv_nmos w=0.74u l=0.13u
XNB_n1263 m_n1263 n1262 gn1 gn1 sg13_lv_nmos w=0.74u l=0.13u
CL_n1263 n1263 gn1 2f
XPA_n1266 n1266 n1264 ph1 ph1 sg13_lv_pmos w=1.12u l=0.13u
XPB_n1266 n1266 n1265 ph1 ph1 sg13_lv_pmos w=1.12u l=0.13u
XNA_n1266 n1266 n1264 m_n1266 gn1 sg13_lv_nmos w=0.74u l=0.13u
XNB_n1266 m_n1266 n1265 gn1 gn1 sg13_lv_nmos w=0.74u l=0.13u
CL_n1266 n1266 gn1 2f
XPA_n1269 n1269 n1267 ph1 ph1 sg13_lv_pmos w=1.12u l=0.13u
XPB_n1269 n1269 n1268 ph1 ph1 sg13_lv_pmos w=1.12u l=0.13u
XNA_n1269 n1269 n1267 m_n1269 gn1 sg13_lv_nmos w=0.74u l=0.13u
XNB_n1269 m_n1269 n1268 gn1 gn1 sg13_lv_nmos w=0.74u l=0.13u
CL_n1269 n1269 gn1 2f
XPA_n1272 n1272 n1270 ph1 ph1 sg13_lv_pmos w=1.12u l=0.13u
XPB_n1272 n1272 n1271 ph1 ph1 sg13_lv_pmos w=1.12u l=0.13u
XNA_n1272 n1272 n1270 m_n1272 gn1 sg13_lv_nmos w=0.74u l=0.13u
XNB_n1272 m_n1272 n1271 gn1 gn1 sg13_lv_nmos w=0.74u l=0.13u
CL_n1272 n1272 gn1 2f
XPA_n1275 n1275 n1273 ph1 ph1 sg13_lv_pmos w=1.12u l=0.13u
XPB_n1275 n1275 n1274 ph1 ph1 sg13_lv_pmos w=1.12u l=0.13u
XNA_n1275 n1275 n1273 m_n1275 gn1 sg13_lv_nmos w=0.74u l=0.13u
XNB_n1275 m_n1275 n1274 gn1 gn1 sg13_lv_nmos w=0.74u l=0.13u
CL_n1275 n1275 gn1 2f
XPA_n1278 n1278 n1276 ph1 ph1 sg13_lv_pmos w=1.12u l=0.13u
XPB_n1278 n1278 n1277 ph1 ph1 sg13_lv_pmos w=1.12u l=0.13u
XNA_n1278 n1278 n1276 m_n1278 gn1 sg13_lv_nmos w=0.74u l=0.13u
XNB_n1278 m_n1278 n1277 gn1 gn1 sg13_lv_nmos w=0.74u l=0.13u
CL_n1278 n1278 gn1 2f
XPA_n1281 n1281 n1279 ph1 ph1 sg13_lv_pmos w=1.12u l=0.13u
XPB_n1281 n1281 n1280 ph1 ph1 sg13_lv_pmos w=1.12u l=0.13u
XNA_n1281 n1281 n1279 m_n1281 gn1 sg13_lv_nmos w=0.74u l=0.13u
XNB_n1281 m_n1281 n1280 gn1 gn1 sg13_lv_nmos w=0.74u l=0.13u
CL_n1281 n1281 gn1 2f
XPA_n1284 n1284 n1282 ph1 ph1 sg13_lv_pmos w=1.12u l=0.13u
XPB_n1284 n1284 n1283 ph1 ph1 sg13_lv_pmos w=1.12u l=0.13u
XNA_n1284 n1284 n1282 m_n1284 gn1 sg13_lv_nmos w=0.74u l=0.13u
XNB_n1284 m_n1284 n1283 gn1 gn1 sg13_lv_nmos w=0.74u l=0.13u
CL_n1284 n1284 gn1 2f
XPA_n1287 n1287 n1285 ph1 ph1 sg13_lv_pmos w=1.12u l=0.13u
XPB_n1287 n1287 n1286 ph1 ph1 sg13_lv_pmos w=1.12u l=0.13u
XNA_n1287 n1287 n1285 m_n1287 gn1 sg13_lv_nmos w=0.74u l=0.13u
XNB_n1287 m_n1287 n1286 gn1 gn1 sg13_lv_nmos w=0.74u l=0.13u
CL_n1287 n1287 gn1 2f
XPA_n1290 n1290 n1288 ph1 ph1 sg13_lv_pmos w=1.12u l=0.13u
XPB_n1290 n1290 n1289 ph1 ph1 sg13_lv_pmos w=1.12u l=0.13u
XNA_n1290 n1290 n1288 m_n1290 gn1 sg13_lv_nmos w=0.74u l=0.13u
XNB_n1290 m_n1290 n1289 gn1 gn1 sg13_lv_nmos w=0.74u l=0.13u
CL_n1290 n1290 gn1 2f
XPA_n1293 n1293 n1291 ph1 ph1 sg13_lv_pmos w=1.12u l=0.13u
XPB_n1293 n1293 n1292 ph1 ph1 sg13_lv_pmos w=1.12u l=0.13u
XNA_n1293 n1293 n1291 m_n1293 gn1 sg13_lv_nmos w=0.74u l=0.13u
XNB_n1293 m_n1293 n1292 gn1 gn1 sg13_lv_nmos w=0.74u l=0.13u
CL_n1293 n1293 gn1 2f
XPA_n1296 n1296 n1294 ph1 ph1 sg13_lv_pmos w=1.12u l=0.13u
XPB_n1296 n1296 n1295 ph1 ph1 sg13_lv_pmos w=1.12u l=0.13u
XNA_n1296 n1296 n1294 m_n1296 gn1 sg13_lv_nmos w=0.74u l=0.13u
XNB_n1296 m_n1296 n1295 gn1 gn1 sg13_lv_nmos w=0.74u l=0.13u
CL_n1296 n1296 gn1 2f
XPA_n1299 n1299 n1297 ph1 ph1 sg13_lv_pmos w=1.12u l=0.13u
XPB_n1299 n1299 n1298 ph1 ph1 sg13_lv_pmos w=1.12u l=0.13u
XNA_n1299 n1299 n1297 m_n1299 gn1 sg13_lv_nmos w=0.74u l=0.13u
XNB_n1299 m_n1299 n1298 gn1 gn1 sg13_lv_nmos w=0.74u l=0.13u
CL_n1299 n1299 gn1 2f
XPA_n1302 n1302 n1300 ph1 ph1 sg13_lv_pmos w=1.12u l=0.13u
XPB_n1302 n1302 n1301 ph1 ph1 sg13_lv_pmos w=1.12u l=0.13u
XNA_n1302 n1302 n1300 m_n1302 gn1 sg13_lv_nmos w=0.74u l=0.13u
XNB_n1302 m_n1302 n1301 gn1 gn1 sg13_lv_nmos w=0.74u l=0.13u
CL_n1302 n1302 gn1 2f
XPA_n15 n15 n13 ph1 ph1 sg13_lv_pmos w=1.12u l=0.13u
XPB_n15 n15 n14 ph1 ph1 sg13_lv_pmos w=1.12u l=0.13u
XNA_n15 n15 n13 m_n15 gn1 sg13_lv_nmos w=0.74u l=0.13u
XNB_n15 m_n15 n14 gn1 gn1 sg13_lv_nmos w=0.74u l=0.13u
CL_n15 n15 gn1 2f
XPA_n153 n153 n151 ph1 ph1 sg13_lv_pmos w=1.12u l=0.13u
XPB_n153 n153 n152 ph1 ph1 sg13_lv_pmos w=1.12u l=0.13u
XNA_n153 n153 n151 m_n153 gn1 sg13_lv_nmos w=0.74u l=0.13u
XNB_n153 m_n153 n152 gn1 gn1 sg13_lv_nmos w=0.74u l=0.13u
CL_n153 n153 gn1 2f
XPA_n156 n156 n154 ph1 ph1 sg13_lv_pmos w=1.12u l=0.13u
XPB_n156 n156 n155 ph1 ph1 sg13_lv_pmos w=1.12u l=0.13u
XNA_n156 n156 n154 m_n156 gn1 sg13_lv_nmos w=0.74u l=0.13u
XNB_n156 m_n156 n155 gn1 gn1 sg13_lv_nmos w=0.74u l=0.13u
CL_n156 n156 gn1 2f
XPA_n159 n159 n157 ph1 ph1 sg13_lv_pmos w=1.12u l=0.13u
XPB_n159 n159 n158 ph1 ph1 sg13_lv_pmos w=1.12u l=0.13u
XNA_n159 n159 n157 m_n159 gn1 sg13_lv_nmos w=0.74u l=0.13u
XNB_n159 m_n159 n158 gn1 gn1 sg13_lv_nmos w=0.74u l=0.13u
CL_n159 n159 gn1 2f
XPA_n162 n162 n160 ph1 ph1 sg13_lv_pmos w=1.12u l=0.13u
XPB_n162 n162 n161 ph1 ph1 sg13_lv_pmos w=1.12u l=0.13u
XNA_n162 n162 n160 m_n162 gn1 sg13_lv_nmos w=0.74u l=0.13u
XNB_n162 m_n162 n161 gn1 gn1 sg13_lv_nmos w=0.74u l=0.13u
CL_n162 n162 gn1 2f
XPA_n165 n165 n163 ph1 ph1 sg13_lv_pmos w=1.12u l=0.13u
XPB_n165 n165 n164 ph1 ph1 sg13_lv_pmos w=1.12u l=0.13u
XNA_n165 n165 n163 m_n165 gn1 sg13_lv_nmos w=0.74u l=0.13u
XNB_n165 m_n165 n164 gn1 gn1 sg13_lv_nmos w=0.74u l=0.13u
CL_n165 n165 gn1 2f
XPA_n168 n168 n166 ph1 ph1 sg13_lv_pmos w=1.12u l=0.13u
XPB_n168 n168 n167 ph1 ph1 sg13_lv_pmos w=1.12u l=0.13u
XNA_n168 n168 n166 m_n168 gn1 sg13_lv_nmos w=0.74u l=0.13u
XNB_n168 m_n168 n167 gn1 gn1 sg13_lv_nmos w=0.74u l=0.13u
CL_n168 n168 gn1 2f
XPA_n171 n171 n169 ph1 ph1 sg13_lv_pmos w=1.12u l=0.13u
XPB_n171 n171 n170 ph1 ph1 sg13_lv_pmos w=1.12u l=0.13u
XNA_n171 n171 n169 m_n171 gn1 sg13_lv_nmos w=0.74u l=0.13u
XNB_n171 m_n171 n170 gn1 gn1 sg13_lv_nmos w=0.74u l=0.13u
CL_n171 n171 gn1 2f
XPA_n174 n174 n172 ph1 ph1 sg13_lv_pmos w=1.12u l=0.13u
XPB_n174 n174 n173 ph1 ph1 sg13_lv_pmos w=1.12u l=0.13u
XNA_n174 n174 n172 m_n174 gn1 sg13_lv_nmos w=0.74u l=0.13u
XNB_n174 m_n174 n173 gn1 gn1 sg13_lv_nmos w=0.74u l=0.13u
CL_n174 n174 gn1 2f
XPA_n177 n177 n175 ph1 ph1 sg13_lv_pmos w=1.12u l=0.13u
XPB_n177 n177 n176 ph1 ph1 sg13_lv_pmos w=1.12u l=0.13u
XNA_n177 n177 n175 m_n177 gn1 sg13_lv_nmos w=0.74u l=0.13u
XNB_n177 m_n177 n176 gn1 gn1 sg13_lv_nmos w=0.74u l=0.13u
CL_n177 n177 gn1 2f
XPA_n18 n18 n16 ph1 ph1 sg13_lv_pmos w=1.12u l=0.13u
XPB_n18 n18 n17 ph1 ph1 sg13_lv_pmos w=1.12u l=0.13u
XNA_n18 n18 n16 m_n18 gn1 sg13_lv_nmos w=0.74u l=0.13u
XNB_n18 m_n18 n17 gn1 gn1 sg13_lv_nmos w=0.74u l=0.13u
CL_n18 n18 gn1 2f
XPA_n180 n180 n178 ph1 ph1 sg13_lv_pmos w=1.12u l=0.13u
XPB_n180 n180 n179 ph1 ph1 sg13_lv_pmos w=1.12u l=0.13u
XNA_n180 n180 n178 m_n180 gn1 sg13_lv_nmos w=0.74u l=0.13u
XNB_n180 m_n180 n179 gn1 gn1 sg13_lv_nmos w=0.74u l=0.13u
CL_n180 n180 gn1 2f
XPA_n183 n183 n181 ph1 ph1 sg13_lv_pmos w=1.12u l=0.13u
XPB_n183 n183 n182 ph1 ph1 sg13_lv_pmos w=1.12u l=0.13u
XNA_n183 n183 n181 m_n183 gn1 sg13_lv_nmos w=0.74u l=0.13u
XNB_n183 m_n183 n182 gn1 gn1 sg13_lv_nmos w=0.74u l=0.13u
CL_n183 n183 gn1 2f
XPA_n186 n186 n184 ph1 ph1 sg13_lv_pmos w=1.12u l=0.13u
XPB_n186 n186 n185 ph1 ph1 sg13_lv_pmos w=1.12u l=0.13u
XNA_n186 n186 n184 m_n186 gn1 sg13_lv_nmos w=0.74u l=0.13u
XNB_n186 m_n186 n185 gn1 gn1 sg13_lv_nmos w=0.74u l=0.13u
CL_n186 n186 gn1 2f
XPA_n189 n189 n187 ph1 ph1 sg13_lv_pmos w=1.12u l=0.13u
XPB_n189 n189 n188 ph1 ph1 sg13_lv_pmos w=1.12u l=0.13u
XNA_n189 n189 n187 m_n189 gn1 sg13_lv_nmos w=0.74u l=0.13u
XNB_n189 m_n189 n188 gn1 gn1 sg13_lv_nmos w=0.74u l=0.13u
CL_n189 n189 gn1 2f
XPA_n192 n192 n190 ph1 ph1 sg13_lv_pmos w=1.12u l=0.13u
XPB_n192 n192 n191 ph1 ph1 sg13_lv_pmos w=1.12u l=0.13u
XNA_n192 n192 n190 m_n192 gn1 sg13_lv_nmos w=0.74u l=0.13u
XNB_n192 m_n192 n191 gn1 gn1 sg13_lv_nmos w=0.74u l=0.13u
CL_n192 n192 gn1 2f
XPA_n195 n195 n193 ph1 ph1 sg13_lv_pmos w=1.12u l=0.13u
XPB_n195 n195 n194 ph1 ph1 sg13_lv_pmos w=1.12u l=0.13u
XNA_n195 n195 n193 m_n195 gn1 sg13_lv_nmos w=0.74u l=0.13u
XNB_n195 m_n195 n194 gn1 gn1 sg13_lv_nmos w=0.74u l=0.13u
CL_n195 n195 gn1 2f
XPA_n198 n198 n196 ph1 ph1 sg13_lv_pmos w=1.12u l=0.13u
XPB_n198 n198 n197 ph1 ph1 sg13_lv_pmos w=1.12u l=0.13u
XNA_n198 n198 n196 m_n198 gn1 sg13_lv_nmos w=0.74u l=0.13u
XNB_n198 m_n198 n197 gn1 gn1 sg13_lv_nmos w=0.74u l=0.13u
CL_n198 n198 gn1 2f
XPA_n201 n201 n199 ph1 ph1 sg13_lv_pmos w=1.12u l=0.13u
XPB_n201 n201 n200 ph1 ph1 sg13_lv_pmos w=1.12u l=0.13u
XNA_n201 n201 n199 m_n201 gn1 sg13_lv_nmos w=0.74u l=0.13u
XNB_n201 m_n201 n200 gn1 gn1 sg13_lv_nmos w=0.74u l=0.13u
CL_n201 n201 gn1 2f
XPA_n204 n204 n202 ph1 ph1 sg13_lv_pmos w=1.12u l=0.13u
XPB_n204 n204 n203 ph1 ph1 sg13_lv_pmos w=1.12u l=0.13u
XNA_n204 n204 n202 m_n204 gn1 sg13_lv_nmos w=0.74u l=0.13u
XNB_n204 m_n204 n203 gn1 gn1 sg13_lv_nmos w=0.74u l=0.13u
CL_n204 n204 gn1 2f
XPA_n207 n207 n205 ph1 ph1 sg13_lv_pmos w=1.12u l=0.13u
XPB_n207 n207 n206 ph1 ph1 sg13_lv_pmos w=1.12u l=0.13u
XNA_n207 n207 n205 m_n207 gn1 sg13_lv_nmos w=0.74u l=0.13u
XNB_n207 m_n207 n206 gn1 gn1 sg13_lv_nmos w=0.74u l=0.13u
CL_n207 n207 gn1 2f
XPA_n21 n21 n19 ph1 ph1 sg13_lv_pmos w=1.12u l=0.13u
XPB_n21 n21 n20 ph1 ph1 sg13_lv_pmos w=1.12u l=0.13u
XNA_n21 n21 n19 m_n21 gn1 sg13_lv_nmos w=0.74u l=0.13u
XNB_n21 m_n21 n20 gn1 gn1 sg13_lv_nmos w=0.74u l=0.13u
CL_n21 n21 gn1 2f
XPA_n210 n210 n208 ph1 ph1 sg13_lv_pmos w=1.12u l=0.13u
XPB_n210 n210 n209 ph1 ph1 sg13_lv_pmos w=1.12u l=0.13u
XNA_n210 n210 n208 m_n210 gn1 sg13_lv_nmos w=0.74u l=0.13u
XNB_n210 m_n210 n209 gn1 gn1 sg13_lv_nmos w=0.74u l=0.13u
CL_n210 n210 gn1 2f
XPA_n24 n24 n22 ph1 ph1 sg13_lv_pmos w=1.12u l=0.13u
XPB_n24 n24 n23 ph1 ph1 sg13_lv_pmos w=1.12u l=0.13u
XNA_n24 n24 n22 m_n24 gn1 sg13_lv_nmos w=0.74u l=0.13u
XNB_n24 m_n24 n23 gn1 gn1 sg13_lv_nmos w=0.74u l=0.13u
CL_n24 n24 gn1 2f
XPA_n243 n243 n241 ph1 ph1 sg13_lv_pmos w=1.12u l=0.13u
XPB_n243 n243 n242 ph1 ph1 sg13_lv_pmos w=1.12u l=0.13u
XNA_n243 n243 n241 m_n243 gn1 sg13_lv_nmos w=0.74u l=0.13u
XNB_n243 m_n243 n242 gn1 gn1 sg13_lv_nmos w=0.74u l=0.13u
CL_n243 n243 gn1 2f
XPA_n246 n246 n244 ph1 ph1 sg13_lv_pmos w=1.12u l=0.13u
XPB_n246 n246 n245 ph1 ph1 sg13_lv_pmos w=1.12u l=0.13u
XNA_n246 n246 n244 m_n246 gn1 sg13_lv_nmos w=0.74u l=0.13u
XNB_n246 m_n246 n245 gn1 gn1 sg13_lv_nmos w=0.74u l=0.13u
CL_n246 n246 gn1 2f
XPA_n249 n249 n247 ph1 ph1 sg13_lv_pmos w=1.12u l=0.13u
XPB_n249 n249 n248 ph1 ph1 sg13_lv_pmos w=1.12u l=0.13u
XNA_n249 n249 n247 m_n249 gn1 sg13_lv_nmos w=0.74u l=0.13u
XNB_n249 m_n249 n248 gn1 gn1 sg13_lv_nmos w=0.74u l=0.13u
CL_n249 n249 gn1 2f
XPA_n252 n252 n250 ph1 ph1 sg13_lv_pmos w=1.12u l=0.13u
XPB_n252 n252 n251 ph1 ph1 sg13_lv_pmos w=1.12u l=0.13u
XNA_n252 n252 n250 m_n252 gn1 sg13_lv_nmos w=0.74u l=0.13u
XNB_n252 m_n252 n251 gn1 gn1 sg13_lv_nmos w=0.74u l=0.13u
CL_n252 n252 gn1 2f
XPA_n255 n255 n253 ph1 ph1 sg13_lv_pmos w=1.12u l=0.13u
XPB_n255 n255 n254 ph1 ph1 sg13_lv_pmos w=1.12u l=0.13u
XNA_n255 n255 n253 m_n255 gn1 sg13_lv_nmos w=0.74u l=0.13u
XNB_n255 m_n255 n254 gn1 gn1 sg13_lv_nmos w=0.74u l=0.13u
CL_n255 n255 gn1 2f
XPA_n258 n258 n256 ph1 ph1 sg13_lv_pmos w=1.12u l=0.13u
XPB_n258 n258 n257 ph1 ph1 sg13_lv_pmos w=1.12u l=0.13u
XNA_n258 n258 n256 m_n258 gn1 sg13_lv_nmos w=0.74u l=0.13u
XNB_n258 m_n258 n257 gn1 gn1 sg13_lv_nmos w=0.74u l=0.13u
CL_n258 n258 gn1 2f
XPA_n27 n27 n25 ph1 ph1 sg13_lv_pmos w=1.12u l=0.13u
XPB_n27 n27 n26 ph1 ph1 sg13_lv_pmos w=1.12u l=0.13u
XNA_n27 n27 n25 m_n27 gn1 sg13_lv_nmos w=0.74u l=0.13u
XNB_n27 m_n27 n26 gn1 gn1 sg13_lv_nmos w=0.74u l=0.13u
CL_n27 n27 gn1 2f
XPA_n3 n3 n1 ph1 ph1 sg13_lv_pmos w=1.12u l=0.13u
XPB_n3 n3 n2 ph1 ph1 sg13_lv_pmos w=1.12u l=0.13u
XNA_n3 n3 n1 m_n3 gn1 sg13_lv_nmos w=0.74u l=0.13u
XNB_n3 m_n3 n2 gn1 gn1 sg13_lv_nmos w=0.74u l=0.13u
CL_n3 n3 gn1 2f
XPA_n30 n30 n28 ph1 ph1 sg13_lv_pmos w=1.12u l=0.13u
XPB_n30 n30 n29 ph1 ph1 sg13_lv_pmos w=1.12u l=0.13u
XNA_n30 n30 n28 m_n30 gn1 sg13_lv_nmos w=0.74u l=0.13u
XNB_n30 m_n30 n29 gn1 gn1 sg13_lv_nmos w=0.74u l=0.13u
CL_n30 n30 gn1 2f
XPA_n303 n303 n301 ph1 ph1 sg13_lv_pmos w=1.12u l=0.13u
XPB_n303 n303 n302 ph1 ph1 sg13_lv_pmos w=1.12u l=0.13u
XNA_n303 n303 n301 m_n303 gn1 sg13_lv_nmos w=0.74u l=0.13u
XNB_n303 m_n303 n302 gn1 gn1 sg13_lv_nmos w=0.74u l=0.13u
CL_n303 n303 gn1 2f
XPA_n306 n306 n304 ph1 ph1 sg13_lv_pmos w=1.12u l=0.13u
XPB_n306 n306 n305 ph1 ph1 sg13_lv_pmos w=1.12u l=0.13u
XNA_n306 n306 n304 m_n306 gn1 sg13_lv_nmos w=0.74u l=0.13u
XNB_n306 m_n306 n305 gn1 gn1 sg13_lv_nmos w=0.74u l=0.13u
CL_n306 n306 gn1 2f
XPA_n309 n309 n307 ph1 ph1 sg13_lv_pmos w=1.12u l=0.13u
XPB_n309 n309 n308 ph1 ph1 sg13_lv_pmos w=1.12u l=0.13u
XNA_n309 n309 n307 m_n309 gn1 sg13_lv_nmos w=0.74u l=0.13u
XNB_n309 m_n309 n308 gn1 gn1 sg13_lv_nmos w=0.74u l=0.13u
CL_n309 n309 gn1 2f
XPA_n312 n312 n310 ph1 ph1 sg13_lv_pmos w=1.12u l=0.13u
XPB_n312 n312 n311 ph1 ph1 sg13_lv_pmos w=1.12u l=0.13u
XNA_n312 n312 n310 m_n312 gn1 sg13_lv_nmos w=0.74u l=0.13u
XNB_n312 m_n312 n311 gn1 gn1 sg13_lv_nmos w=0.74u l=0.13u
CL_n312 n312 gn1 2f
XPA_n315 n315 n313 ph1 ph1 sg13_lv_pmos w=1.12u l=0.13u
XPB_n315 n315 n314 ph1 ph1 sg13_lv_pmos w=1.12u l=0.13u
XNA_n315 n315 n313 m_n315 gn1 sg13_lv_nmos w=0.74u l=0.13u
XNB_n315 m_n315 n314 gn1 gn1 sg13_lv_nmos w=0.74u l=0.13u
CL_n315 n315 gn1 2f
XPA_n318 n318 n316 ph1 ph1 sg13_lv_pmos w=1.12u l=0.13u
XPB_n318 n318 n317 ph1 ph1 sg13_lv_pmos w=1.12u l=0.13u
XNA_n318 n318 n316 m_n318 gn1 sg13_lv_nmos w=0.74u l=0.13u
XNB_n318 m_n318 n317 gn1 gn1 sg13_lv_nmos w=0.74u l=0.13u
CL_n318 n318 gn1 2f
XPA_n321 n321 n319 ph1 ph1 sg13_lv_pmos w=1.12u l=0.13u
XPB_n321 n321 n320 ph1 ph1 sg13_lv_pmos w=1.12u l=0.13u
XNA_n321 n321 n319 m_n321 gn1 sg13_lv_nmos w=0.74u l=0.13u
XNB_n321 m_n321 n320 gn1 gn1 sg13_lv_nmos w=0.74u l=0.13u
CL_n321 n321 gn1 2f
XPA_n324 n324 n322 ph1 ph1 sg13_lv_pmos w=1.12u l=0.13u
XPB_n324 n324 n323 ph1 ph1 sg13_lv_pmos w=1.12u l=0.13u
XNA_n324 n324 n322 m_n324 gn1 sg13_lv_nmos w=0.74u l=0.13u
XNB_n324 m_n324 n323 gn1 gn1 sg13_lv_nmos w=0.74u l=0.13u
CL_n324 n324 gn1 2f
XPA_n327 n327 n325 ph1 ph1 sg13_lv_pmos w=1.12u l=0.13u
XPB_n327 n327 n326 ph1 ph1 sg13_lv_pmos w=1.12u l=0.13u
XNA_n327 n327 n325 m_n327 gn1 sg13_lv_nmos w=0.74u l=0.13u
XNB_n327 m_n327 n326 gn1 gn1 sg13_lv_nmos w=0.74u l=0.13u
CL_n327 n327 gn1 2f
XPA_n33 n33 n31 ph1 ph1 sg13_lv_pmos w=1.12u l=0.13u
XPB_n33 n33 n32 ph1 ph1 sg13_lv_pmos w=1.12u l=0.13u
XNA_n33 n33 n31 m_n33 gn1 sg13_lv_nmos w=0.74u l=0.13u
XNB_n33 m_n33 n32 gn1 gn1 sg13_lv_nmos w=0.74u l=0.13u
CL_n33 n33 gn1 2f
XPA_n330 n330 n328 ph1 ph1 sg13_lv_pmos w=1.12u l=0.13u
XPB_n330 n330 n329 ph1 ph1 sg13_lv_pmos w=1.12u l=0.13u
XNA_n330 n330 n328 m_n330 gn1 sg13_lv_nmos w=0.74u l=0.13u
XNB_n330 m_n330 n329 gn1 gn1 sg13_lv_nmos w=0.74u l=0.13u
CL_n330 n330 gn1 2f
XPA_n333 n333 n331 ph1 ph1 sg13_lv_pmos w=1.12u l=0.13u
XPB_n333 n333 n332 ph1 ph1 sg13_lv_pmos w=1.12u l=0.13u
XNA_n333 n333 n331 m_n333 gn1 sg13_lv_nmos w=0.74u l=0.13u
XNB_n333 m_n333 n332 gn1 gn1 sg13_lv_nmos w=0.74u l=0.13u
CL_n333 n333 gn1 2f
XPA_n336 n336 n334 ph1 ph1 sg13_lv_pmos w=1.12u l=0.13u
XPB_n336 n336 n335 ph1 ph1 sg13_lv_pmos w=1.12u l=0.13u
XNA_n336 n336 n334 m_n336 gn1 sg13_lv_nmos w=0.74u l=0.13u
XNB_n336 m_n336 n335 gn1 gn1 sg13_lv_nmos w=0.74u l=0.13u
CL_n336 n336 gn1 2f
XPA_n339 n339 n337 ph1 ph1 sg13_lv_pmos w=1.12u l=0.13u
XPB_n339 n339 n338 ph1 ph1 sg13_lv_pmos w=1.12u l=0.13u
XNA_n339 n339 n337 m_n339 gn1 sg13_lv_nmos w=0.74u l=0.13u
XNB_n339 m_n339 n338 gn1 gn1 sg13_lv_nmos w=0.74u l=0.13u
CL_n339 n339 gn1 2f
XPA_n342 n342 n340 ph1 ph1 sg13_lv_pmos w=1.12u l=0.13u
XPB_n342 n342 n341 ph1 ph1 sg13_lv_pmos w=1.12u l=0.13u
XNA_n342 n342 n340 m_n342 gn1 sg13_lv_nmos w=0.74u l=0.13u
XNB_n342 m_n342 n341 gn1 gn1 sg13_lv_nmos w=0.74u l=0.13u
CL_n342 n342 gn1 2f
XPA_n345 n345 n343 ph1 ph1 sg13_lv_pmos w=1.12u l=0.13u
XPB_n345 n345 n344 ph1 ph1 sg13_lv_pmos w=1.12u l=0.13u
XNA_n345 n345 n343 m_n345 gn1 sg13_lv_nmos w=0.74u l=0.13u
XNB_n345 m_n345 n344 gn1 gn1 sg13_lv_nmos w=0.74u l=0.13u
CL_n345 n345 gn1 2f
XPA_n348 n348 n346 ph1 ph1 sg13_lv_pmos w=1.12u l=0.13u
XPB_n348 n348 n347 ph1 ph1 sg13_lv_pmos w=1.12u l=0.13u
XNA_n348 n348 n346 m_n348 gn1 sg13_lv_nmos w=0.74u l=0.13u
XNB_n348 m_n348 n347 gn1 gn1 sg13_lv_nmos w=0.74u l=0.13u
CL_n348 n348 gn1 2f
XPA_n351 n351 n349 ph1 ph1 sg13_lv_pmos w=1.12u l=0.13u
XPB_n351 n351 n350 ph1 ph1 sg13_lv_pmos w=1.12u l=0.13u
XNA_n351 n351 n349 m_n351 gn1 sg13_lv_nmos w=0.74u l=0.13u
XNB_n351 m_n351 n350 gn1 gn1 sg13_lv_nmos w=0.74u l=0.13u
CL_n351 n351 gn1 2f
XPA_n354 n354 n352 ph1 ph1 sg13_lv_pmos w=1.12u l=0.13u
XPB_n354 n354 n353 ph1 ph1 sg13_lv_pmos w=1.12u l=0.13u
XNA_n354 n354 n352 m_n354 gn1 sg13_lv_nmos w=0.74u l=0.13u
XNB_n354 m_n354 n353 gn1 gn1 sg13_lv_nmos w=0.74u l=0.13u
CL_n354 n354 gn1 2f
XPA_n357 n357 n355 ph1 ph1 sg13_lv_pmos w=1.12u l=0.13u
XPB_n357 n357 n356 ph1 ph1 sg13_lv_pmos w=1.12u l=0.13u
XNA_n357 n357 n355 m_n357 gn1 sg13_lv_nmos w=0.74u l=0.13u
XNB_n357 m_n357 n356 gn1 gn1 sg13_lv_nmos w=0.74u l=0.13u
CL_n357 n357 gn1 2f
XPA_n36 n36 n34 ph1 ph1 sg13_lv_pmos w=1.12u l=0.13u
XPB_n36 n36 n35 ph1 ph1 sg13_lv_pmos w=1.12u l=0.13u
XNA_n36 n36 n34 m_n36 gn1 sg13_lv_nmos w=0.74u l=0.13u
XNB_n36 m_n36 n35 gn1 gn1 sg13_lv_nmos w=0.74u l=0.13u
CL_n36 n36 gn1 2f
XPA_n360 n360 n358 ph1 ph1 sg13_lv_pmos w=1.12u l=0.13u
XPB_n360 n360 n359 ph1 ph1 sg13_lv_pmos w=1.12u l=0.13u
XNA_n360 n360 n358 m_n360 gn1 sg13_lv_nmos w=0.74u l=0.13u
XNB_n360 m_n360 n359 gn1 gn1 sg13_lv_nmos w=0.74u l=0.13u
CL_n360 n360 gn1 2f
XPA_n363 n363 n361 ph1 ph1 sg13_lv_pmos w=1.12u l=0.13u
XPB_n363 n363 n362 ph1 ph1 sg13_lv_pmos w=1.12u l=0.13u
XNA_n363 n363 n361 m_n363 gn1 sg13_lv_nmos w=0.74u l=0.13u
XNB_n363 m_n363 n362 gn1 gn1 sg13_lv_nmos w=0.74u l=0.13u
CL_n363 n363 gn1 2f
XPA_n366 n366 n364 ph1 ph1 sg13_lv_pmos w=1.12u l=0.13u
XPB_n366 n366 n365 ph1 ph1 sg13_lv_pmos w=1.12u l=0.13u
XNA_n366 n366 n364 m_n366 gn1 sg13_lv_nmos w=0.74u l=0.13u
XNB_n366 m_n366 n365 gn1 gn1 sg13_lv_nmos w=0.74u l=0.13u
CL_n366 n366 gn1 2f
XPA_n369 n369 n367 ph1 ph1 sg13_lv_pmos w=1.12u l=0.13u
XPB_n369 n369 n368 ph1 ph1 sg13_lv_pmos w=1.12u l=0.13u
XNA_n369 n369 n367 m_n369 gn1 sg13_lv_nmos w=0.74u l=0.13u
XNB_n369 m_n369 n368 gn1 gn1 sg13_lv_nmos w=0.74u l=0.13u
CL_n369 n369 gn1 2f
XPA_n372 n372 n370 ph1 ph1 sg13_lv_pmos w=1.12u l=0.13u
XPB_n372 n372 n371 ph1 ph1 sg13_lv_pmos w=1.12u l=0.13u
XNA_n372 n372 n370 m_n372 gn1 sg13_lv_nmos w=0.74u l=0.13u
XNB_n372 m_n372 n371 gn1 gn1 sg13_lv_nmos w=0.74u l=0.13u
CL_n372 n372 gn1 2f
XPA_n375 n375 n373 ph1 ph1 sg13_lv_pmos w=1.12u l=0.13u
XPB_n375 n375 n374 ph1 ph1 sg13_lv_pmos w=1.12u l=0.13u
XNA_n375 n375 n373 m_n375 gn1 sg13_lv_nmos w=0.74u l=0.13u
XNB_n375 m_n375 n374 gn1 gn1 sg13_lv_nmos w=0.74u l=0.13u
CL_n375 n375 gn1 2f
XPA_n378 n378 n376 ph1 ph1 sg13_lv_pmos w=1.12u l=0.13u
XPB_n378 n378 n377 ph1 ph1 sg13_lv_pmos w=1.12u l=0.13u
XNA_n378 n378 n376 m_n378 gn1 sg13_lv_nmos w=0.74u l=0.13u
XNB_n378 m_n378 n377 gn1 gn1 sg13_lv_nmos w=0.74u l=0.13u
CL_n378 n378 gn1 2f
XPA_n381 n381 n379 ph1 ph1 sg13_lv_pmos w=1.12u l=0.13u
XPB_n381 n381 n380 ph1 ph1 sg13_lv_pmos w=1.12u l=0.13u
XNA_n381 n381 n379 m_n381 gn1 sg13_lv_nmos w=0.74u l=0.13u
XNB_n381 m_n381 n380 gn1 gn1 sg13_lv_nmos w=0.74u l=0.13u
CL_n381 n381 gn1 2f
XPA_n384 n384 n382 ph1 ph1 sg13_lv_pmos w=1.12u l=0.13u
XPB_n384 n384 n383 ph1 ph1 sg13_lv_pmos w=1.12u l=0.13u
XNA_n384 n384 n382 m_n384 gn1 sg13_lv_nmos w=0.74u l=0.13u
XNB_n384 m_n384 n383 gn1 gn1 sg13_lv_nmos w=0.74u l=0.13u
CL_n384 n384 gn1 2f
XPA_n387 n387 n385 ph1 ph1 sg13_lv_pmos w=1.12u l=0.13u
XPB_n387 n387 n386 ph1 ph1 sg13_lv_pmos w=1.12u l=0.13u
XNA_n387 n387 n385 m_n387 gn1 sg13_lv_nmos w=0.74u l=0.13u
XNB_n387 m_n387 n386 gn1 gn1 sg13_lv_nmos w=0.74u l=0.13u
CL_n387 n387 gn1 2f
XPA_n39 n39 n37 ph1 ph1 sg13_lv_pmos w=1.12u l=0.13u
XPB_n39 n39 n38 ph1 ph1 sg13_lv_pmos w=1.12u l=0.13u
XNA_n39 n39 n37 m_n39 gn1 sg13_lv_nmos w=0.74u l=0.13u
XNB_n39 m_n39 n38 gn1 gn1 sg13_lv_nmos w=0.74u l=0.13u
CL_n39 n39 gn1 2f
XPA_n390 n390 n388 ph1 ph1 sg13_lv_pmos w=1.12u l=0.13u
XPB_n390 n390 n389 ph1 ph1 sg13_lv_pmos w=1.12u l=0.13u
XNA_n390 n390 n388 m_n390 gn1 sg13_lv_nmos w=0.74u l=0.13u
XNB_n390 m_n390 n389 gn1 gn1 sg13_lv_nmos w=0.74u l=0.13u
CL_n390 n390 gn1 2f
XPA_n393 n393 n391 ph1 ph1 sg13_lv_pmos w=1.12u l=0.13u
XPB_n393 n393 n392 ph1 ph1 sg13_lv_pmos w=1.12u l=0.13u
XNA_n393 n393 n391 m_n393 gn1 sg13_lv_nmos w=0.74u l=0.13u
XNB_n393 m_n393 n392 gn1 gn1 sg13_lv_nmos w=0.74u l=0.13u
CL_n393 n393 gn1 2f
XPA_n396 n396 n394 ph1 ph1 sg13_lv_pmos w=1.12u l=0.13u
XPB_n396 n396 n395 ph1 ph1 sg13_lv_pmos w=1.12u l=0.13u
XNA_n396 n396 n394 m_n396 gn1 sg13_lv_nmos w=0.74u l=0.13u
XNB_n396 m_n396 n395 gn1 gn1 sg13_lv_nmos w=0.74u l=0.13u
CL_n396 n396 gn1 2f
XPA_n42 n42 n40 ph1 ph1 sg13_lv_pmos w=1.12u l=0.13u
XPB_n42 n42 n41 ph1 ph1 sg13_lv_pmos w=1.12u l=0.13u
XNA_n42 n42 n40 m_n42 gn1 sg13_lv_nmos w=0.74u l=0.13u
XNB_n42 m_n42 n41 gn1 gn1 sg13_lv_nmos w=0.74u l=0.13u
CL_n42 n42 gn1 2f
XPA_n45 n45 n43 ph1 ph1 sg13_lv_pmos w=1.12u l=0.13u
XPB_n45 n45 n44 ph1 ph1 sg13_lv_pmos w=1.12u l=0.13u
XNA_n45 n45 n43 m_n45 gn1 sg13_lv_nmos w=0.74u l=0.13u
XNB_n45 m_n45 n44 gn1 gn1 sg13_lv_nmos w=0.74u l=0.13u
CL_n45 n45 gn1 2f
XPA_n48 n48 n46 ph1 ph1 sg13_lv_pmos w=1.12u l=0.13u
XPB_n48 n48 n47 ph1 ph1 sg13_lv_pmos w=1.12u l=0.13u
XNA_n48 n48 n46 m_n48 gn1 sg13_lv_nmos w=0.74u l=0.13u
XNB_n48 m_n48 n47 gn1 gn1 sg13_lv_nmos w=0.74u l=0.13u
CL_n48 n48 gn1 2f
XPA_n489 n489 n487 ph1 ph1 sg13_lv_pmos w=1.12u l=0.13u
XPB_n489 n489 n488 ph1 ph1 sg13_lv_pmos w=1.12u l=0.13u
XNA_n489 n489 n487 m_n489 gn1 sg13_lv_nmos w=0.74u l=0.13u
XNB_n489 m_n489 n488 gn1 gn1 sg13_lv_nmos w=0.74u l=0.13u
CL_n489 n489 gn1 2f
XPA_n492 n492 n490 ph1 ph1 sg13_lv_pmos w=1.12u l=0.13u
XPB_n492 n492 n491 ph1 ph1 sg13_lv_pmos w=1.12u l=0.13u
XNA_n492 n492 n490 m_n492 gn1 sg13_lv_nmos w=0.74u l=0.13u
XNB_n492 m_n492 n491 gn1 gn1 sg13_lv_nmos w=0.74u l=0.13u
CL_n492 n492 gn1 2f
XPA_n495 n495 n493 ph1 ph1 sg13_lv_pmos w=1.12u l=0.13u
XPB_n495 n495 n494 ph1 ph1 sg13_lv_pmos w=1.12u l=0.13u
XNA_n495 n495 n493 m_n495 gn1 sg13_lv_nmos w=0.74u l=0.13u
XNB_n495 m_n495 n494 gn1 gn1 sg13_lv_nmos w=0.74u l=0.13u
CL_n495 n495 gn1 2f
XPA_n498 n498 n496 ph1 ph1 sg13_lv_pmos w=1.12u l=0.13u
XPB_n498 n498 n497 ph1 ph1 sg13_lv_pmos w=1.12u l=0.13u
XNA_n498 n498 n496 m_n498 gn1 sg13_lv_nmos w=0.74u l=0.13u
XNB_n498 m_n498 n497 gn1 gn1 sg13_lv_nmos w=0.74u l=0.13u
CL_n498 n498 gn1 2f
XPA_n501 n501 n499 ph1 ph1 sg13_lv_pmos w=1.12u l=0.13u
XPB_n501 n501 n500 ph1 ph1 sg13_lv_pmos w=1.12u l=0.13u
XNA_n501 n501 n499 m_n501 gn1 sg13_lv_nmos w=0.74u l=0.13u
XNB_n501 m_n501 n500 gn1 gn1 sg13_lv_nmos w=0.74u l=0.13u
CL_n501 n501 gn1 2f
XPA_n504 n504 n502 ph1 ph1 sg13_lv_pmos w=1.12u l=0.13u
XPB_n504 n504 n503 ph1 ph1 sg13_lv_pmos w=1.12u l=0.13u
XNA_n504 n504 n502 m_n504 gn1 sg13_lv_nmos w=0.74u l=0.13u
XNB_n504 m_n504 n503 gn1 gn1 sg13_lv_nmos w=0.74u l=0.13u
CL_n504 n504 gn1 2f
XPA_n507 n507 n505 ph1 ph1 sg13_lv_pmos w=1.12u l=0.13u
XPB_n507 n507 n506 ph1 ph1 sg13_lv_pmos w=1.12u l=0.13u
XNA_n507 n507 n505 m_n507 gn1 sg13_lv_nmos w=0.74u l=0.13u
XNB_n507 m_n507 n506 gn1 gn1 sg13_lv_nmos w=0.74u l=0.13u
CL_n507 n507 gn1 2f
XPA_n51 n51 n49 ph1 ph1 sg13_lv_pmos w=1.12u l=0.13u
XPB_n51 n51 n50 ph1 ph1 sg13_lv_pmos w=1.12u l=0.13u
XNA_n51 n51 n49 m_n51 gn1 sg13_lv_nmos w=0.74u l=0.13u
XNB_n51 m_n51 n50 gn1 gn1 sg13_lv_nmos w=0.74u l=0.13u
CL_n51 n51 gn1 2f
XPA_n510 n510 n508 ph1 ph1 sg13_lv_pmos w=1.12u l=0.13u
XPB_n510 n510 n509 ph1 ph1 sg13_lv_pmos w=1.12u l=0.13u
XNA_n510 n510 n508 m_n510 gn1 sg13_lv_nmos w=0.74u l=0.13u
XNB_n510 m_n510 n509 gn1 gn1 sg13_lv_nmos w=0.74u l=0.13u
CL_n510 n510 gn1 2f
XPA_n513 n513 n511 ph1 ph1 sg13_lv_pmos w=1.12u l=0.13u
XPB_n513 n513 n512 ph1 ph1 sg13_lv_pmos w=1.12u l=0.13u
XNA_n513 n513 n511 m_n513 gn1 sg13_lv_nmos w=0.74u l=0.13u
XNB_n513 m_n513 n512 gn1 gn1 sg13_lv_nmos w=0.74u l=0.13u
CL_n513 n513 gn1 2f
XPA_n516 n516 n514 ph1 ph1 sg13_lv_pmos w=1.12u l=0.13u
XPB_n516 n516 n515 ph1 ph1 sg13_lv_pmos w=1.12u l=0.13u
XNA_n516 n516 n514 m_n516 gn1 sg13_lv_nmos w=0.74u l=0.13u
XNB_n516 m_n516 n515 gn1 gn1 sg13_lv_nmos w=0.74u l=0.13u
CL_n516 n516 gn1 2f
XPA_n519 n519 n517 ph1 ph1 sg13_lv_pmos w=1.12u l=0.13u
XPB_n519 n519 n518 ph1 ph1 sg13_lv_pmos w=1.12u l=0.13u
XNA_n519 n519 n517 m_n519 gn1 sg13_lv_nmos w=0.74u l=0.13u
XNB_n519 m_n519 n518 gn1 gn1 sg13_lv_nmos w=0.74u l=0.13u
CL_n519 n519 gn1 2f
XPA_n522 n522 n520 ph1 ph1 sg13_lv_pmos w=1.12u l=0.13u
XPB_n522 n522 n521 ph1 ph1 sg13_lv_pmos w=1.12u l=0.13u
XNA_n522 n522 n520 m_n522 gn1 sg13_lv_nmos w=0.74u l=0.13u
XNB_n522 m_n522 n521 gn1 gn1 sg13_lv_nmos w=0.74u l=0.13u
CL_n522 n522 gn1 2f
XPA_n525 n525 n523 ph1 ph1 sg13_lv_pmos w=1.12u l=0.13u
XPB_n525 n525 n524 ph1 ph1 sg13_lv_pmos w=1.12u l=0.13u
XNA_n525 n525 n523 m_n525 gn1 sg13_lv_nmos w=0.74u l=0.13u
XNB_n525 m_n525 n524 gn1 gn1 sg13_lv_nmos w=0.74u l=0.13u
CL_n525 n525 gn1 2f
XPA_n528 n528 n526 ph1 ph1 sg13_lv_pmos w=1.12u l=0.13u
XPB_n528 n528 n527 ph1 ph1 sg13_lv_pmos w=1.12u l=0.13u
XNA_n528 n528 n526 m_n528 gn1 sg13_lv_nmos w=0.74u l=0.13u
XNB_n528 m_n528 n527 gn1 gn1 sg13_lv_nmos w=0.74u l=0.13u
CL_n528 n528 gn1 2f
XPA_n531 n531 n529 ph1 ph1 sg13_lv_pmos w=1.12u l=0.13u
XPB_n531 n531 n530 ph1 ph1 sg13_lv_pmos w=1.12u l=0.13u
XNA_n531 n531 n529 m_n531 gn1 sg13_lv_nmos w=0.74u l=0.13u
XNB_n531 m_n531 n530 gn1 gn1 sg13_lv_nmos w=0.74u l=0.13u
CL_n531 n531 gn1 2f
XPA_n534 n534 n532 ph1 ph1 sg13_lv_pmos w=1.12u l=0.13u
XPB_n534 n534 n533 ph1 ph1 sg13_lv_pmos w=1.12u l=0.13u
XNA_n534 n534 n532 m_n534 gn1 sg13_lv_nmos w=0.74u l=0.13u
XNB_n534 m_n534 n533 gn1 gn1 sg13_lv_nmos w=0.74u l=0.13u
CL_n534 n534 gn1 2f
XPA_n537 n537 n535 ph1 ph1 sg13_lv_pmos w=1.12u l=0.13u
XPB_n537 n537 n536 ph1 ph1 sg13_lv_pmos w=1.12u l=0.13u
XNA_n537 n537 n535 m_n537 gn1 sg13_lv_nmos w=0.74u l=0.13u
XNB_n537 m_n537 n536 gn1 gn1 sg13_lv_nmos w=0.74u l=0.13u
CL_n537 n537 gn1 2f
XPA_n54 n54 n52 ph1 ph1 sg13_lv_pmos w=1.12u l=0.13u
XPB_n54 n54 n53 ph1 ph1 sg13_lv_pmos w=1.12u l=0.13u
XNA_n54 n54 n52 m_n54 gn1 sg13_lv_nmos w=0.74u l=0.13u
XNB_n54 m_n54 n53 gn1 gn1 sg13_lv_nmos w=0.74u l=0.13u
CL_n54 n54 gn1 2f
XPA_n540 n540 n538 ph1 ph1 sg13_lv_pmos w=1.12u l=0.13u
XPB_n540 n540 n539 ph1 ph1 sg13_lv_pmos w=1.12u l=0.13u
XNA_n540 n540 n538 m_n540 gn1 sg13_lv_nmos w=0.74u l=0.13u
XNB_n540 m_n540 n539 gn1 gn1 sg13_lv_nmos w=0.74u l=0.13u
CL_n540 n540 gn1 2f
XPA_n543 n543 n541 ph1 ph1 sg13_lv_pmos w=1.12u l=0.13u
XPB_n543 n543 n542 ph1 ph1 sg13_lv_pmos w=1.12u l=0.13u
XNA_n543 n543 n541 m_n543 gn1 sg13_lv_nmos w=0.74u l=0.13u
XNB_n543 m_n543 n542 gn1 gn1 sg13_lv_nmos w=0.74u l=0.13u
CL_n543 n543 gn1 2f
XPA_n546 n546 n544 ph1 ph1 sg13_lv_pmos w=1.12u l=0.13u
XPB_n546 n546 n545 ph1 ph1 sg13_lv_pmos w=1.12u l=0.13u
XNA_n546 n546 n544 m_n546 gn1 sg13_lv_nmos w=0.74u l=0.13u
XNB_n546 m_n546 n545 gn1 gn1 sg13_lv_nmos w=0.74u l=0.13u
CL_n546 n546 gn1 2f
XPA_n549 n549 n547 ph1 ph1 sg13_lv_pmos w=1.12u l=0.13u
XPB_n549 n549 n548 ph1 ph1 sg13_lv_pmos w=1.12u l=0.13u
XNA_n549 n549 n547 m_n549 gn1 sg13_lv_nmos w=0.74u l=0.13u
XNB_n549 m_n549 n548 gn1 gn1 sg13_lv_nmos w=0.74u l=0.13u
CL_n549 n549 gn1 2f
XPA_n552 n552 n550 ph1 ph1 sg13_lv_pmos w=1.12u l=0.13u
XPB_n552 n552 n551 ph1 ph1 sg13_lv_pmos w=1.12u l=0.13u
XNA_n552 n552 n550 m_n552 gn1 sg13_lv_nmos w=0.74u l=0.13u
XNB_n552 m_n552 n551 gn1 gn1 sg13_lv_nmos w=0.74u l=0.13u
CL_n552 n552 gn1 2f
XPA_n555 n555 n553 ph1 ph1 sg13_lv_pmos w=1.12u l=0.13u
XPB_n555 n555 n554 ph1 ph1 sg13_lv_pmos w=1.12u l=0.13u
XNA_n555 n555 n553 m_n555 gn1 sg13_lv_nmos w=0.74u l=0.13u
XNB_n555 m_n555 n554 gn1 gn1 sg13_lv_nmos w=0.74u l=0.13u
CL_n555 n555 gn1 2f
XPA_n558 n558 n556 ph1 ph1 sg13_lv_pmos w=1.12u l=0.13u
XPB_n558 n558 n557 ph1 ph1 sg13_lv_pmos w=1.12u l=0.13u
XNA_n558 n558 n556 m_n558 gn1 sg13_lv_nmos w=0.74u l=0.13u
XNB_n558 m_n558 n557 gn1 gn1 sg13_lv_nmos w=0.74u l=0.13u
CL_n558 n558 gn1 2f
XPA_n561 n561 n559 ph1 ph1 sg13_lv_pmos w=1.12u l=0.13u
XPB_n561 n561 n560 ph1 ph1 sg13_lv_pmos w=1.12u l=0.13u
XNA_n561 n561 n559 m_n561 gn1 sg13_lv_nmos w=0.74u l=0.13u
XNB_n561 m_n561 n560 gn1 gn1 sg13_lv_nmos w=0.74u l=0.13u
CL_n561 n561 gn1 2f
XPA_n564 n564 n562 ph1 ph1 sg13_lv_pmos w=1.12u l=0.13u
XPB_n564 n564 n563 ph1 ph1 sg13_lv_pmos w=1.12u l=0.13u
XNA_n564 n564 n562 m_n564 gn1 sg13_lv_nmos w=0.74u l=0.13u
XNB_n564 m_n564 n563 gn1 gn1 sg13_lv_nmos w=0.74u l=0.13u
CL_n564 n564 gn1 2f
XPA_n567 n567 n565 ph1 ph1 sg13_lv_pmos w=1.12u l=0.13u
XPB_n567 n567 n566 ph1 ph1 sg13_lv_pmos w=1.12u l=0.13u
XNA_n567 n567 n565 m_n567 gn1 sg13_lv_nmos w=0.74u l=0.13u
XNB_n567 m_n567 n566 gn1 gn1 sg13_lv_nmos w=0.74u l=0.13u
CL_n567 n567 gn1 2f
XPA_n57 n57 n55 ph1 ph1 sg13_lv_pmos w=1.12u l=0.13u
XPB_n57 n57 n56 ph1 ph1 sg13_lv_pmos w=1.12u l=0.13u
XNA_n57 n57 n55 m_n57 gn1 sg13_lv_nmos w=0.74u l=0.13u
XNB_n57 m_n57 n56 gn1 gn1 sg13_lv_nmos w=0.74u l=0.13u
CL_n57 n57 gn1 2f
XPA_n570 n570 n568 ph1 ph1 sg13_lv_pmos w=1.12u l=0.13u
XPB_n570 n570 n569 ph1 ph1 sg13_lv_pmos w=1.12u l=0.13u
XNA_n570 n570 n568 m_n570 gn1 sg13_lv_nmos w=0.74u l=0.13u
XNB_n570 m_n570 n569 gn1 gn1 sg13_lv_nmos w=0.74u l=0.13u
CL_n570 n570 gn1 2f
XPA_n6 n6 n4 ph1 ph1 sg13_lv_pmos w=1.12u l=0.13u
XPB_n6 n6 n5 ph1 ph1 sg13_lv_pmos w=1.12u l=0.13u
XNA_n6 n6 n4 m_n6 gn1 sg13_lv_nmos w=0.74u l=0.13u
XNB_n6 m_n6 n5 gn1 gn1 sg13_lv_nmos w=0.74u l=0.13u
CL_n6 n6 gn1 2f
XPA_n60 n60 n58 ph1 ph1 sg13_lv_pmos w=1.12u l=0.13u
XPB_n60 n60 n59 ph1 ph1 sg13_lv_pmos w=1.12u l=0.13u
XNA_n60 n60 n58 m_n60 gn1 sg13_lv_nmos w=0.74u l=0.13u
XNB_n60 m_n60 n59 gn1 gn1 sg13_lv_nmos w=0.74u l=0.13u
CL_n60 n60 gn1 2f
XPA_n615 n615 n613 ph1 ph1 sg13_lv_pmos w=1.12u l=0.13u
XPB_n615 n615 n614 ph1 ph1 sg13_lv_pmos w=1.12u l=0.13u
XNA_n615 n615 n613 m_n615 gn1 sg13_lv_nmos w=0.74u l=0.13u
XNB_n615 m_n615 n614 gn1 gn1 sg13_lv_nmos w=0.74u l=0.13u
CL_n615 n615 gn1 2f
XPA_n618 n618 n616 ph1 ph1 sg13_lv_pmos w=1.12u l=0.13u
XPB_n618 n618 n617 ph1 ph1 sg13_lv_pmos w=1.12u l=0.13u
XNA_n618 n618 n616 m_n618 gn1 sg13_lv_nmos w=0.74u l=0.13u
XNB_n618 m_n618 n617 gn1 gn1 sg13_lv_nmos w=0.74u l=0.13u
CL_n618 n618 gn1 2f
XPA_n663 n663 n661 ph1 ph1 sg13_lv_pmos w=1.12u l=0.13u
XPB_n663 n663 n662 ph1 ph1 sg13_lv_pmos w=1.12u l=0.13u
XNA_n663 n663 n661 m_n663 gn1 sg13_lv_nmos w=0.74u l=0.13u
XNB_n663 m_n663 n662 gn1 gn1 sg13_lv_nmos w=0.74u l=0.13u
CL_n663 n663 gn1 2f
XPA_n666 n666 n664 ph1 ph1 sg13_lv_pmos w=1.12u l=0.13u
XPB_n666 n666 n665 ph1 ph1 sg13_lv_pmos w=1.12u l=0.13u
XNA_n666 n666 n664 m_n666 gn1 sg13_lv_nmos w=0.74u l=0.13u
XNB_n666 m_n666 n665 gn1 gn1 sg13_lv_nmos w=0.74u l=0.13u
CL_n666 n666 gn1 2f
XPA_n669 n669 n667 ph1 ph1 sg13_lv_pmos w=1.12u l=0.13u
XPB_n669 n669 n668 ph1 ph1 sg13_lv_pmos w=1.12u l=0.13u
XNA_n669 n669 n667 m_n669 gn1 sg13_lv_nmos w=0.74u l=0.13u
XNB_n669 m_n669 n668 gn1 gn1 sg13_lv_nmos w=0.74u l=0.13u
CL_n669 n669 gn1 2f
XPA_n672 n672 n670 ph1 ph1 sg13_lv_pmos w=1.12u l=0.13u
XPB_n672 n672 n671 ph1 ph1 sg13_lv_pmos w=1.12u l=0.13u
XNA_n672 n672 n670 m_n672 gn1 sg13_lv_nmos w=0.74u l=0.13u
XNB_n672 m_n672 n671 gn1 gn1 sg13_lv_nmos w=0.74u l=0.13u
CL_n672 n672 gn1 2f
XPA_n681 n681 n679 ph1 ph1 sg13_lv_pmos w=1.12u l=0.13u
XPB_n681 n681 n680 ph1 ph1 sg13_lv_pmos w=1.12u l=0.13u
XNA_n681 n681 n679 m_n681 gn1 sg13_lv_nmos w=0.74u l=0.13u
XNB_n681 m_n681 n680 gn1 gn1 sg13_lv_nmos w=0.74u l=0.13u
CL_n681 n681 gn1 2f
XPA_n684 n684 n682 ph1 ph1 sg13_lv_pmos w=1.12u l=0.13u
XPB_n684 n684 n683 ph1 ph1 sg13_lv_pmos w=1.12u l=0.13u
XNA_n684 n684 n682 m_n684 gn1 sg13_lv_nmos w=0.74u l=0.13u
XNB_n684 m_n684 n683 gn1 gn1 sg13_lv_nmos w=0.74u l=0.13u
CL_n684 n684 gn1 2f
XPA_n687 n687 n685 ph1 ph1 sg13_lv_pmos w=1.12u l=0.13u
XPB_n687 n687 n686 ph1 ph1 sg13_lv_pmos w=1.12u l=0.13u
XNA_n687 n687 n685 m_n687 gn1 sg13_lv_nmos w=0.74u l=0.13u
XNB_n687 m_n687 n686 gn1 gn1 sg13_lv_nmos w=0.74u l=0.13u
CL_n687 n687 gn1 2f
XPA_n690 n690 n688 ph1 ph1 sg13_lv_pmos w=1.12u l=0.13u
XPB_n690 n690 n689 ph1 ph1 sg13_lv_pmos w=1.12u l=0.13u
XNA_n690 n690 n688 m_n690 gn1 sg13_lv_nmos w=0.74u l=0.13u
XNB_n690 m_n690 n689 gn1 gn1 sg13_lv_nmos w=0.74u l=0.13u
CL_n690 n690 gn1 2f
XPA_n693 n693 n691 ph1 ph1 sg13_lv_pmos w=1.12u l=0.13u
XPB_n693 n693 n692 ph1 ph1 sg13_lv_pmos w=1.12u l=0.13u
XNA_n693 n693 n691 m_n693 gn1 sg13_lv_nmos w=0.74u l=0.13u
XNB_n693 m_n693 n692 gn1 gn1 sg13_lv_nmos w=0.74u l=0.13u
CL_n693 n693 gn1 2f
XPA_n696 n696 n694 ph1 ph1 sg13_lv_pmos w=1.12u l=0.13u
XPB_n696 n696 n695 ph1 ph1 sg13_lv_pmos w=1.12u l=0.13u
XNA_n696 n696 n694 m_n696 gn1 sg13_lv_nmos w=0.74u l=0.13u
XNB_n696 m_n696 n695 gn1 gn1 sg13_lv_nmos w=0.74u l=0.13u
CL_n696 n696 gn1 2f
XPA_n699 n699 n697 ph1 ph1 sg13_lv_pmos w=1.12u l=0.13u
XPB_n699 n699 n698 ph1 ph1 sg13_lv_pmos w=1.12u l=0.13u
XNA_n699 n699 n697 m_n699 gn1 sg13_lv_nmos w=0.74u l=0.13u
XNB_n699 m_n699 n698 gn1 gn1 sg13_lv_nmos w=0.74u l=0.13u
CL_n699 n699 gn1 2f
XPA_n702 n702 n700 ph1 ph1 sg13_lv_pmos w=1.12u l=0.13u
XPB_n702 n702 n701 ph1 ph1 sg13_lv_pmos w=1.12u l=0.13u
XNA_n702 n702 n700 m_n702 gn1 sg13_lv_nmos w=0.74u l=0.13u
XNB_n702 m_n702 n701 gn1 gn1 sg13_lv_nmos w=0.74u l=0.13u
CL_n702 n702 gn1 2f
XPA_n705 n705 n703 ph1 ph1 sg13_lv_pmos w=1.12u l=0.13u
XPB_n705 n705 n704 ph1 ph1 sg13_lv_pmos w=1.12u l=0.13u
XNA_n705 n705 n703 m_n705 gn1 sg13_lv_nmos w=0.74u l=0.13u
XNB_n705 m_n705 n704 gn1 gn1 sg13_lv_nmos w=0.74u l=0.13u
CL_n705 n705 gn1 2f
XPA_n708 n708 n706 ph1 ph1 sg13_lv_pmos w=1.12u l=0.13u
XPB_n708 n708 n707 ph1 ph1 sg13_lv_pmos w=1.12u l=0.13u
XNA_n708 n708 n706 m_n708 gn1 sg13_lv_nmos w=0.74u l=0.13u
XNB_n708 m_n708 n707 gn1 gn1 sg13_lv_nmos w=0.74u l=0.13u
CL_n708 n708 gn1 2f
XPA_n711 n711 n709 ph1 ph1 sg13_lv_pmos w=1.12u l=0.13u
XPB_n711 n711 n710 ph1 ph1 sg13_lv_pmos w=1.12u l=0.13u
XNA_n711 n711 n709 m_n711 gn1 sg13_lv_nmos w=0.74u l=0.13u
XNB_n711 m_n711 n710 gn1 gn1 sg13_lv_nmos w=0.74u l=0.13u
CL_n711 n711 gn1 2f
XPA_n714 n714 n712 ph1 ph1 sg13_lv_pmos w=1.12u l=0.13u
XPB_n714 n714 n713 ph1 ph1 sg13_lv_pmos w=1.12u l=0.13u
XNA_n714 n714 n712 m_n714 gn1 sg13_lv_nmos w=0.74u l=0.13u
XNB_n714 m_n714 n713 gn1 gn1 sg13_lv_nmos w=0.74u l=0.13u
CL_n714 n714 gn1 2f
XPA_n717 n717 n715 ph1 ph1 sg13_lv_pmos w=1.12u l=0.13u
XPB_n717 n717 n716 ph1 ph1 sg13_lv_pmos w=1.12u l=0.13u
XNA_n717 n717 n715 m_n717 gn1 sg13_lv_nmos w=0.74u l=0.13u
XNB_n717 m_n717 n716 gn1 gn1 sg13_lv_nmos w=0.74u l=0.13u
CL_n717 n717 gn1 2f
XPA_n720 n720 n718 ph1 ph1 sg13_lv_pmos w=1.12u l=0.13u
XPB_n720 n720 n719 ph1 ph1 sg13_lv_pmos w=1.12u l=0.13u
XNA_n720 n720 n718 m_n720 gn1 sg13_lv_nmos w=0.74u l=0.13u
XNB_n720 m_n720 n719 gn1 gn1 sg13_lv_nmos w=0.74u l=0.13u
CL_n720 n720 gn1 2f
XPA_n723 n723 n721 ph1 ph1 sg13_lv_pmos w=1.12u l=0.13u
XPB_n723 n723 n722 ph1 ph1 sg13_lv_pmos w=1.12u l=0.13u
XNA_n723 n723 n721 m_n723 gn1 sg13_lv_nmos w=0.74u l=0.13u
XNB_n723 m_n723 n722 gn1 gn1 sg13_lv_nmos w=0.74u l=0.13u
CL_n723 n723 gn1 2f
XPA_n726 n726 n724 ph1 ph1 sg13_lv_pmos w=1.12u l=0.13u
XPB_n726 n726 n725 ph1 ph1 sg13_lv_pmos w=1.12u l=0.13u
XNA_n726 n726 n724 m_n726 gn1 sg13_lv_nmos w=0.74u l=0.13u
XNB_n726 m_n726 n725 gn1 gn1 sg13_lv_nmos w=0.74u l=0.13u
CL_n726 n726 gn1 2f
XPA_n729 n729 n727 ph1 ph1 sg13_lv_pmos w=1.12u l=0.13u
XPB_n729 n729 n728 ph1 ph1 sg13_lv_pmos w=1.12u l=0.13u
XNA_n729 n729 n727 m_n729 gn1 sg13_lv_nmos w=0.74u l=0.13u
XNB_n729 m_n729 n728 gn1 gn1 sg13_lv_nmos w=0.74u l=0.13u
CL_n729 n729 gn1 2f
XPA_n732 n732 n730 ph1 ph1 sg13_lv_pmos w=1.12u l=0.13u
XPB_n732 n732 n731 ph1 ph1 sg13_lv_pmos w=1.12u l=0.13u
XNA_n732 n732 n730 m_n732 gn1 sg13_lv_nmos w=0.74u l=0.13u
XNB_n732 m_n732 n731 gn1 gn1 sg13_lv_nmos w=0.74u l=0.13u
CL_n732 n732 gn1 2f
XPA_n735 n735 n733 ph1 ph1 sg13_lv_pmos w=1.12u l=0.13u
XPB_n735 n735 n734 ph1 ph1 sg13_lv_pmos w=1.12u l=0.13u
XNA_n735 n735 n733 m_n735 gn1 sg13_lv_nmos w=0.74u l=0.13u
XNB_n735 m_n735 n734 gn1 gn1 sg13_lv_nmos w=0.74u l=0.13u
CL_n735 n735 gn1 2f
XPA_n738 n738 n736 ph1 ph1 sg13_lv_pmos w=1.12u l=0.13u
XPB_n738 n738 n737 ph1 ph1 sg13_lv_pmos w=1.12u l=0.13u
XNA_n738 n738 n736 m_n738 gn1 sg13_lv_nmos w=0.74u l=0.13u
XNB_n738 m_n738 n737 gn1 gn1 sg13_lv_nmos w=0.74u l=0.13u
CL_n738 n738 gn1 2f
XPA_n741 n741 n739 ph1 ph1 sg13_lv_pmos w=1.12u l=0.13u
XPB_n741 n741 n740 ph1 ph1 sg13_lv_pmos w=1.12u l=0.13u
XNA_n741 n741 n739 m_n741 gn1 sg13_lv_nmos w=0.74u l=0.13u
XNB_n741 m_n741 n740 gn1 gn1 sg13_lv_nmos w=0.74u l=0.13u
CL_n741 n741 gn1 2f
XPA_n744 n744 n742 ph1 ph1 sg13_lv_pmos w=1.12u l=0.13u
XPB_n744 n744 n743 ph1 ph1 sg13_lv_pmos w=1.12u l=0.13u
XNA_n744 n744 n742 m_n744 gn1 sg13_lv_nmos w=0.74u l=0.13u
XNB_n744 m_n744 n743 gn1 gn1 sg13_lv_nmos w=0.74u l=0.13u
CL_n744 n744 gn1 2f
XPA_n747 n747 n745 ph1 ph1 sg13_lv_pmos w=1.12u l=0.13u
XPB_n747 n747 n746 ph1 ph1 sg13_lv_pmos w=1.12u l=0.13u
XNA_n747 n747 n745 m_n747 gn1 sg13_lv_nmos w=0.74u l=0.13u
XNB_n747 m_n747 n746 gn1 gn1 sg13_lv_nmos w=0.74u l=0.13u
CL_n747 n747 gn1 2f
XPA_n750 n750 n748 ph1 ph1 sg13_lv_pmos w=1.12u l=0.13u
XPB_n750 n750 n749 ph1 ph1 sg13_lv_pmos w=1.12u l=0.13u
XNA_n750 n750 n748 m_n750 gn1 sg13_lv_nmos w=0.74u l=0.13u
XNB_n750 m_n750 n749 gn1 gn1 sg13_lv_nmos w=0.74u l=0.13u
CL_n750 n750 gn1 2f
XPA_n753 n753 n751 ph1 ph1 sg13_lv_pmos w=1.12u l=0.13u
XPB_n753 n753 n752 ph1 ph1 sg13_lv_pmos w=1.12u l=0.13u
XNA_n753 n753 n751 m_n753 gn1 sg13_lv_nmos w=0.74u l=0.13u
XNB_n753 m_n753 n752 gn1 gn1 sg13_lv_nmos w=0.74u l=0.13u
CL_n753 n753 gn1 2f
XPA_n756 n756 n754 ph1 ph1 sg13_lv_pmos w=1.12u l=0.13u
XPB_n756 n756 n755 ph1 ph1 sg13_lv_pmos w=1.12u l=0.13u
XNA_n756 n756 n754 m_n756 gn1 sg13_lv_nmos w=0.74u l=0.13u
XNB_n756 m_n756 n755 gn1 gn1 sg13_lv_nmos w=0.74u l=0.13u
CL_n756 n756 gn1 2f
XPA_n759 n759 n757 ph1 ph1 sg13_lv_pmos w=1.12u l=0.13u
XPB_n759 n759 n758 ph1 ph1 sg13_lv_pmos w=1.12u l=0.13u
XNA_n759 n759 n757 m_n759 gn1 sg13_lv_nmos w=0.74u l=0.13u
XNB_n759 m_n759 n758 gn1 gn1 sg13_lv_nmos w=0.74u l=0.13u
CL_n759 n759 gn1 2f
XPA_n762 n762 n760 ph1 ph1 sg13_lv_pmos w=1.12u l=0.13u
XPB_n762 n762 n761 ph1 ph1 sg13_lv_pmos w=1.12u l=0.13u
XNA_n762 n762 n760 m_n762 gn1 sg13_lv_nmos w=0.74u l=0.13u
XNB_n762 m_n762 n761 gn1 gn1 sg13_lv_nmos w=0.74u l=0.13u
CL_n762 n762 gn1 2f
XPA_n765 n765 n763 ph1 ph1 sg13_lv_pmos w=1.12u l=0.13u
XPB_n765 n765 n764 ph1 ph1 sg13_lv_pmos w=1.12u l=0.13u
XNA_n765 n765 n763 m_n765 gn1 sg13_lv_nmos w=0.74u l=0.13u
XNB_n765 m_n765 n764 gn1 gn1 sg13_lv_nmos w=0.74u l=0.13u
CL_n765 n765 gn1 2f
XPA_n768 n768 n766 ph1 ph1 sg13_lv_pmos w=1.12u l=0.13u
XPB_n768 n768 n767 ph1 ph1 sg13_lv_pmos w=1.12u l=0.13u
XNA_n768 n768 n766 m_n768 gn1 sg13_lv_nmos w=0.74u l=0.13u
XNB_n768 m_n768 n767 gn1 gn1 sg13_lv_nmos w=0.74u l=0.13u
CL_n768 n768 gn1 2f
XPA_n861 n861 n859 ph1 ph1 sg13_lv_pmos w=1.12u l=0.13u
XPB_n861 n861 n860 ph1 ph1 sg13_lv_pmos w=1.12u l=0.13u
XNA_n861 n861 n859 m_n861 gn1 sg13_lv_nmos w=0.74u l=0.13u
XNB_n861 m_n861 n860 gn1 gn1 sg13_lv_nmos w=0.74u l=0.13u
CL_n861 n861 gn1 2f
XPA_n864 n864 n862 ph1 ph1 sg13_lv_pmos w=1.12u l=0.13u
XPB_n864 n864 n863 ph1 ph1 sg13_lv_pmos w=1.12u l=0.13u
XNA_n864 n864 n862 m_n864 gn1 sg13_lv_nmos w=0.74u l=0.13u
XNB_n864 m_n864 n863 gn1 gn1 sg13_lv_nmos w=0.74u l=0.13u
CL_n864 n864 gn1 2f
XPA_n867 n867 n865 ph1 ph1 sg13_lv_pmos w=1.12u l=0.13u
XPB_n867 n867 n866 ph1 ph1 sg13_lv_pmos w=1.12u l=0.13u
XNA_n867 n867 n865 m_n867 gn1 sg13_lv_nmos w=0.74u l=0.13u
XNB_n867 m_n867 n866 gn1 gn1 sg13_lv_nmos w=0.74u l=0.13u
CL_n867 n867 gn1 2f
XPA_n870 n870 n868 ph1 ph1 sg13_lv_pmos w=1.12u l=0.13u
XPB_n870 n870 n869 ph1 ph1 sg13_lv_pmos w=1.12u l=0.13u
XNA_n870 n870 n868 m_n870 gn1 sg13_lv_nmos w=0.74u l=0.13u
XNB_n870 m_n870 n869 gn1 gn1 sg13_lv_nmos w=0.74u l=0.13u
CL_n870 n870 gn1 2f
XPA_n873 n873 n871 ph1 ph1 sg13_lv_pmos w=1.12u l=0.13u
XPB_n873 n873 n872 ph1 ph1 sg13_lv_pmos w=1.12u l=0.13u
XNA_n873 n873 n871 m_n873 gn1 sg13_lv_nmos w=0.74u l=0.13u
XNB_n873 m_n873 n872 gn1 gn1 sg13_lv_nmos w=0.74u l=0.13u
CL_n873 n873 gn1 2f
XPA_n876 n876 n874 ph1 ph1 sg13_lv_pmos w=1.12u l=0.13u
XPB_n876 n876 n875 ph1 ph1 sg13_lv_pmos w=1.12u l=0.13u
XNA_n876 n876 n874 m_n876 gn1 sg13_lv_nmos w=0.74u l=0.13u
XNB_n876 m_n876 n875 gn1 gn1 sg13_lv_nmos w=0.74u l=0.13u
CL_n876 n876 gn1 2f
XPA_n879 n879 n877 ph1 ph1 sg13_lv_pmos w=1.12u l=0.13u
XPB_n879 n879 n878 ph1 ph1 sg13_lv_pmos w=1.12u l=0.13u
XNA_n879 n879 n877 m_n879 gn1 sg13_lv_nmos w=0.74u l=0.13u
XNB_n879 m_n879 n878 gn1 gn1 sg13_lv_nmos w=0.74u l=0.13u
CL_n879 n879 gn1 2f
XPA_n882 n882 n880 ph1 ph1 sg13_lv_pmos w=1.12u l=0.13u
XPB_n882 n882 n881 ph1 ph1 sg13_lv_pmos w=1.12u l=0.13u
XNA_n882 n882 n880 m_n882 gn1 sg13_lv_nmos w=0.74u l=0.13u
XNB_n882 m_n882 n881 gn1 gn1 sg13_lv_nmos w=0.74u l=0.13u
CL_n882 n882 gn1 2f
XPA_n885 n885 n883 ph1 ph1 sg13_lv_pmos w=1.12u l=0.13u
XPB_n885 n885 n884 ph1 ph1 sg13_lv_pmos w=1.12u l=0.13u
XNA_n885 n885 n883 m_n885 gn1 sg13_lv_nmos w=0.74u l=0.13u
XNB_n885 m_n885 n884 gn1 gn1 sg13_lv_nmos w=0.74u l=0.13u
CL_n885 n885 gn1 2f
XPA_n888 n888 n886 ph1 ph1 sg13_lv_pmos w=1.12u l=0.13u
XPB_n888 n888 n887 ph1 ph1 sg13_lv_pmos w=1.12u l=0.13u
XNA_n888 n888 n886 m_n888 gn1 sg13_lv_nmos w=0.74u l=0.13u
XNB_n888 m_n888 n887 gn1 gn1 sg13_lv_nmos w=0.74u l=0.13u
CL_n888 n888 gn1 2f
XPA_n891 n891 n889 ph1 ph1 sg13_lv_pmos w=1.12u l=0.13u
XPB_n891 n891 n890 ph1 ph1 sg13_lv_pmos w=1.12u l=0.13u
XNA_n891 n891 n889 m_n891 gn1 sg13_lv_nmos w=0.74u l=0.13u
XNB_n891 m_n891 n890 gn1 gn1 sg13_lv_nmos w=0.74u l=0.13u
CL_n891 n891 gn1 2f
XPA_n894 n894 n892 ph1 ph1 sg13_lv_pmos w=1.12u l=0.13u
XPB_n894 n894 n893 ph1 ph1 sg13_lv_pmos w=1.12u l=0.13u
XNA_n894 n894 n892 m_n894 gn1 sg13_lv_nmos w=0.74u l=0.13u
XNB_n894 m_n894 n893 gn1 gn1 sg13_lv_nmos w=0.74u l=0.13u
CL_n894 n894 gn1 2f
XPA_n897 n897 n895 ph1 ph1 sg13_lv_pmos w=1.12u l=0.13u
XPB_n897 n897 n896 ph1 ph1 sg13_lv_pmos w=1.12u l=0.13u
XNA_n897 n897 n895 m_n897 gn1 sg13_lv_nmos w=0.74u l=0.13u
XNB_n897 m_n897 n896 gn1 gn1 sg13_lv_nmos w=0.74u l=0.13u
CL_n897 n897 gn1 2f
XPA_n9 n9 n7 ph1 ph1 sg13_lv_pmos w=1.12u l=0.13u
XPB_n9 n9 n8 ph1 ph1 sg13_lv_pmos w=1.12u l=0.13u
XNA_n9 n9 n7 m_n9 gn1 sg13_lv_nmos w=0.74u l=0.13u
XNB_n9 m_n9 n8 gn1 gn1 sg13_lv_nmos w=0.74u l=0.13u
CL_n9 n9 gn1 2f
XPA_n900 n900 n898 ph1 ph1 sg13_lv_pmos w=1.12u l=0.13u
XPB_n900 n900 n899 ph1 ph1 sg13_lv_pmos w=1.12u l=0.13u
XNA_n900 n900 n898 m_n900 gn1 sg13_lv_nmos w=0.74u l=0.13u
XNB_n900 m_n900 n899 gn1 gn1 sg13_lv_nmos w=0.74u l=0.13u
CL_n900 n900 gn1 2f
XPA_n903 n903 n901 ph1 ph1 sg13_lv_pmos w=1.12u l=0.13u
XPB_n903 n903 n902 ph1 ph1 sg13_lv_pmos w=1.12u l=0.13u
XNA_n903 n903 n901 m_n903 gn1 sg13_lv_nmos w=0.74u l=0.13u
XNB_n903 m_n903 n902 gn1 gn1 sg13_lv_nmos w=0.74u l=0.13u
CL_n903 n903 gn1 2f
XPA_n906 n906 n904 ph1 ph1 sg13_lv_pmos w=1.12u l=0.13u
XPB_n906 n906 n905 ph1 ph1 sg13_lv_pmos w=1.12u l=0.13u
XNA_n906 n906 n904 m_n906 gn1 sg13_lv_nmos w=0.74u l=0.13u
XNB_n906 m_n906 n905 gn1 gn1 sg13_lv_nmos w=0.74u l=0.13u
CL_n906 n906 gn1 2f
XPA_n909 n909 n907 ph1 ph1 sg13_lv_pmos w=1.12u l=0.13u
XPB_n909 n909 n908 ph1 ph1 sg13_lv_pmos w=1.12u l=0.13u
XNA_n909 n909 n907 m_n909 gn1 sg13_lv_nmos w=0.74u l=0.13u
XNB_n909 m_n909 n908 gn1 gn1 sg13_lv_nmos w=0.74u l=0.13u
CL_n909 n909 gn1 2f
XPA_n912 n912 n910 ph1 ph1 sg13_lv_pmos w=1.12u l=0.13u
XPB_n912 n912 n911 ph1 ph1 sg13_lv_pmos w=1.12u l=0.13u
XNA_n912 n912 n910 m_n912 gn1 sg13_lv_nmos w=0.74u l=0.13u
XNB_n912 m_n912 n911 gn1 gn1 sg13_lv_nmos w=0.74u l=0.13u
CL_n912 n912 gn1 2f
XPA_n915 n915 n913 ph1 ph1 sg13_lv_pmos w=1.12u l=0.13u
XPB_n915 n915 n914 ph1 ph1 sg13_lv_pmos w=1.12u l=0.13u
XNA_n915 n915 n913 m_n915 gn1 sg13_lv_nmos w=0.74u l=0.13u
XNB_n915 m_n915 n914 gn1 gn1 sg13_lv_nmos w=0.74u l=0.13u
CL_n915 n915 gn1 2f
XPA_n918 n918 n916 ph1 ph1 sg13_lv_pmos w=1.12u l=0.13u
XPB_n918 n918 n917 ph1 ph1 sg13_lv_pmos w=1.12u l=0.13u
XNA_n918 n918 n916 m_n918 gn1 sg13_lv_nmos w=0.74u l=0.13u
XNB_n918 m_n918 n917 gn1 gn1 sg13_lv_nmos w=0.74u l=0.13u
CL_n918 n918 gn1 2f
XPA_n921 n921 n919 ph1 ph1 sg13_lv_pmos w=1.12u l=0.13u
XPB_n921 n921 n920 ph1 ph1 sg13_lv_pmos w=1.12u l=0.13u
XNA_n921 n921 n919 m_n921 gn1 sg13_lv_nmos w=0.74u l=0.13u
XNB_n921 m_n921 n920 gn1 gn1 sg13_lv_nmos w=0.74u l=0.13u
CL_n921 n921 gn1 2f
XPA_n924 n924 n922 ph1 ph1 sg13_lv_pmos w=1.12u l=0.13u
XPB_n924 n924 n923 ph1 ph1 sg13_lv_pmos w=1.12u l=0.13u
XNA_n924 n924 n922 m_n924 gn1 sg13_lv_nmos w=0.74u l=0.13u
XNB_n924 m_n924 n923 gn1 gn1 sg13_lv_nmos w=0.74u l=0.13u
CL_n924 n924 gn1 2f
XPA_n927 n927 n925 ph1 ph1 sg13_lv_pmos w=1.12u l=0.13u
XPB_n927 n927 n926 ph1 ph1 sg13_lv_pmos w=1.12u l=0.13u
XNA_n927 n927 n925 m_n927 gn1 sg13_lv_nmos w=0.74u l=0.13u
XNB_n927 m_n927 n926 gn1 gn1 sg13_lv_nmos w=0.74u l=0.13u
CL_n927 n927 gn1 2f
XPA_n93 n93 n91 ph1 ph1 sg13_lv_pmos w=1.12u l=0.13u
XPB_n93 n93 n92 ph1 ph1 sg13_lv_pmos w=1.12u l=0.13u
XNA_n93 n93 n91 m_n93 gn1 sg13_lv_nmos w=0.74u l=0.13u
XNB_n93 m_n93 n92 gn1 gn1 sg13_lv_nmos w=0.74u l=0.13u
CL_n93 n93 gn1 2f
XPA_n930 n930 n928 ph1 ph1 sg13_lv_pmos w=1.12u l=0.13u
XPB_n930 n930 n929 ph1 ph1 sg13_lv_pmos w=1.12u l=0.13u
XNA_n930 n930 n928 m_n930 gn1 sg13_lv_nmos w=0.74u l=0.13u
XNB_n930 m_n930 n929 gn1 gn1 sg13_lv_nmos w=0.74u l=0.13u
CL_n930 n930 gn1 2f
XPA_n933 n933 n931 ph1 ph1 sg13_lv_pmos w=1.12u l=0.13u
XPB_n933 n933 n932 ph1 ph1 sg13_lv_pmos w=1.12u l=0.13u
XNA_n933 n933 n931 m_n933 gn1 sg13_lv_nmos w=0.74u l=0.13u
XNB_n933 m_n933 n932 gn1 gn1 sg13_lv_nmos w=0.74u l=0.13u
CL_n933 n933 gn1 2f
XPA_n936 n936 n934 ph1 ph1 sg13_lv_pmos w=1.12u l=0.13u
XPB_n936 n936 n935 ph1 ph1 sg13_lv_pmos w=1.12u l=0.13u
XNA_n936 n936 n934 m_n936 gn1 sg13_lv_nmos w=0.74u l=0.13u
XNB_n936 m_n936 n935 gn1 gn1 sg13_lv_nmos w=0.74u l=0.13u
CL_n936 n936 gn1 2f
XPA_n939 n939 n937 ph1 ph1 sg13_lv_pmos w=1.12u l=0.13u
XPB_n939 n939 n938 ph1 ph1 sg13_lv_pmos w=1.12u l=0.13u
XNA_n939 n939 n937 m_n939 gn1 sg13_lv_nmos w=0.74u l=0.13u
XNB_n939 m_n939 n938 gn1 gn1 sg13_lv_nmos w=0.74u l=0.13u
CL_n939 n939 gn1 2f
XPA_n942 n942 n940 ph1 ph1 sg13_lv_pmos w=1.12u l=0.13u
XPB_n942 n942 n941 ph1 ph1 sg13_lv_pmos w=1.12u l=0.13u
XNA_n942 n942 n940 m_n942 gn1 sg13_lv_nmos w=0.74u l=0.13u
XNB_n942 m_n942 n941 gn1 gn1 sg13_lv_nmos w=0.74u l=0.13u
CL_n942 n942 gn1 2f
XPA_n96 n96 n94 ph1 ph1 sg13_lv_pmos w=1.12u l=0.13u
XPB_n96 n96 n95 ph1 ph1 sg13_lv_pmos w=1.12u l=0.13u
XNA_n96 n96 n94 m_n96 gn1 sg13_lv_nmos w=0.74u l=0.13u
XNB_n96 m_n96 n95 gn1 gn1 sg13_lv_nmos w=0.74u l=0.13u
CL_n96 n96 gn1 2f
XPA_n987 n987 n985 ph1 ph1 sg13_lv_pmos w=1.12u l=0.13u
XPB_n987 n987 n986 ph1 ph1 sg13_lv_pmos w=1.12u l=0.13u
XNA_n987 n987 n985 m_n987 gn1 sg13_lv_nmos w=0.74u l=0.13u
XNB_n987 m_n987 n986 gn1 gn1 sg13_lv_nmos w=0.74u l=0.13u
CL_n987 n987 gn1 2f
XPA_n99 n99 n97 ph1 ph1 sg13_lv_pmos w=1.12u l=0.13u
XPB_n99 n99 n98 ph1 ph1 sg13_lv_pmos w=1.12u l=0.13u
XNA_n99 n99 n97 m_n99 gn1 sg13_lv_nmos w=0.74u l=0.13u
XNB_n99 m_n99 n98 gn1 gn1 sg13_lv_nmos w=0.74u l=0.13u
CL_n99 n99 gn1 2f
XPA_n990 n990 n988 ph1 ph1 sg13_lv_pmos w=1.12u l=0.13u
XPB_n990 n990 n989 ph1 ph1 sg13_lv_pmos w=1.12u l=0.13u
XNA_n990 n990 n988 m_n990 gn1 sg13_lv_nmos w=0.74u l=0.13u
XNB_n990 m_n990 n989 gn1 gn1 sg13_lv_nmos w=0.74u l=0.13u
CL_n990 n990 gn1 2f
XPA_n1117 n1117 n1035 ph1 ph1 sg13_lv_pmos w=1.12u l=0.13u
XPB_n1117 n1117 n1044 ph1 ph1 sg13_lv_pmos w=1.12u l=0.13u
XNA_n1117 n1117 n1035 m_n1117 gn1 sg13_lv_nmos w=0.74u l=0.13u
XNB_n1117 m_n1117 n1044 gn1 gn1 sg13_lv_nmos w=0.74u l=0.13u
CL_n1117 n1117 gn1 2f
XPA_n1118 n1118 n1038 ph1 ph1 sg13_lv_pmos w=1.12u l=0.13u
XPB_n1118 n1118 n1041 ph1 ph1 sg13_lv_pmos w=1.12u l=0.13u
XNA_n1118 n1118 n1038 m_n1118 gn1 sg13_lv_nmos w=0.74u l=0.13u
XNB_n1118 m_n1118 n1041 gn1 gn1 sg13_lv_nmos w=0.74u l=0.13u
CL_n1118 n1118 gn1 2f
XPA_n1120 n1120 n1035 ph1 ph1 sg13_lv_pmos w=1.12u l=0.13u
XPB_n1120 n1120 n1041 ph1 ph1 sg13_lv_pmos w=1.12u l=0.13u
XNA_n1120 n1120 n1035 m_n1120 gn1 sg13_lv_nmos w=0.74u l=0.13u
XNB_n1120 m_n1120 n1041 gn1 gn1 sg13_lv_nmos w=0.74u l=0.13u
CL_n1120 n1120 gn1 2f
XPA_n1121 n1121 n1038 ph1 ph1 sg13_lv_pmos w=1.12u l=0.13u
XPB_n1121 n1121 n1044 ph1 ph1 sg13_lv_pmos w=1.12u l=0.13u
XNA_n1121 n1121 n1038 m_n1121 gn1 sg13_lv_nmos w=0.74u l=0.13u
XNB_n1121 m_n1121 n1044 gn1 gn1 sg13_lv_nmos w=0.74u l=0.13u
CL_n1121 n1121 gn1 2f
XPA_n1123 n1123 n1047 ph1 ph1 sg13_lv_pmos w=1.12u l=0.13u
XPB_n1123 n1123 n1056 ph1 ph1 sg13_lv_pmos w=1.12u l=0.13u
XNA_n1123 n1123 n1047 m_n1123 gn1 sg13_lv_nmos w=0.74u l=0.13u
XNB_n1123 m_n1123 n1056 gn1 gn1 sg13_lv_nmos w=0.74u l=0.13u
CL_n1123 n1123 gn1 2f
XPA_n1124 n1124 n1050 ph1 ph1 sg13_lv_pmos w=1.12u l=0.13u
XPB_n1124 n1124 n1053 ph1 ph1 sg13_lv_pmos w=1.12u l=0.13u
XNA_n1124 n1124 n1050 m_n1124 gn1 sg13_lv_nmos w=0.74u l=0.13u
XNB_n1124 m_n1124 n1053 gn1 gn1 sg13_lv_nmos w=0.74u l=0.13u
CL_n1124 n1124 gn1 2f
XPA_n1126 n1126 n1047 ph1 ph1 sg13_lv_pmos w=1.12u l=0.13u
XPB_n1126 n1126 n1053 ph1 ph1 sg13_lv_pmos w=1.12u l=0.13u
XNA_n1126 n1126 n1047 m_n1126 gn1 sg13_lv_nmos w=0.74u l=0.13u
XNB_n1126 m_n1126 n1053 gn1 gn1 sg13_lv_nmos w=0.74u l=0.13u
CL_n1126 n1126 gn1 2f
XPA_n1127 n1127 n1050 ph1 ph1 sg13_lv_pmos w=1.12u l=0.13u
XPB_n1127 n1127 n1056 ph1 ph1 sg13_lv_pmos w=1.12u l=0.13u
XNA_n1127 n1127 n1050 m_n1127 gn1 sg13_lv_nmos w=0.74u l=0.13u
XNB_n1127 m_n1127 n1056 gn1 gn1 sg13_lv_nmos w=0.74u l=0.13u
CL_n1127 n1127 gn1 2f
XPA_n1129 n1129 n1059 ph1 ph1 sg13_lv_pmos w=1.12u l=0.13u
XPB_n1129 n1129 n1068 ph1 ph1 sg13_lv_pmos w=1.12u l=0.13u
XNA_n1129 n1129 n1059 m_n1129 gn1 sg13_lv_nmos w=0.74u l=0.13u
XNB_n1129 m_n1129 n1068 gn1 gn1 sg13_lv_nmos w=0.74u l=0.13u
CL_n1129 n1129 gn1 2f
XPA_n1130 n1130 n1062 ph1 ph1 sg13_lv_pmos w=1.12u l=0.13u
XPB_n1130 n1130 n1065 ph1 ph1 sg13_lv_pmos w=1.12u l=0.13u
XNA_n1130 n1130 n1062 m_n1130 gn1 sg13_lv_nmos w=0.74u l=0.13u
XNB_n1130 m_n1130 n1065 gn1 gn1 sg13_lv_nmos w=0.74u l=0.13u
CL_n1130 n1130 gn1 2f
XPA_n1132 n1132 n1059 ph1 ph1 sg13_lv_pmos w=1.12u l=0.13u
XPB_n1132 n1132 n1065 ph1 ph1 sg13_lv_pmos w=1.12u l=0.13u
XNA_n1132 n1132 n1059 m_n1132 gn1 sg13_lv_nmos w=0.74u l=0.13u
XNB_n1132 m_n1132 n1065 gn1 gn1 sg13_lv_nmos w=0.74u l=0.13u
CL_n1132 n1132 gn1 2f
XPA_n1133 n1133 n1062 ph1 ph1 sg13_lv_pmos w=1.12u l=0.13u
XPB_n1133 n1133 n1068 ph1 ph1 sg13_lv_pmos w=1.12u l=0.13u
XNA_n1133 n1133 n1062 m_n1133 gn1 sg13_lv_nmos w=0.74u l=0.13u
XNB_n1133 m_n1133 n1068 gn1 gn1 sg13_lv_nmos w=0.74u l=0.13u
CL_n1133 n1133 gn1 2f
XPA_n1135 n1135 n1071 ph1 ph1 sg13_lv_pmos w=1.12u l=0.13u
XPB_n1135 n1135 n1080 ph1 ph1 sg13_lv_pmos w=1.12u l=0.13u
XNA_n1135 n1135 n1071 m_n1135 gn1 sg13_lv_nmos w=0.74u l=0.13u
XNB_n1135 m_n1135 n1080 gn1 gn1 sg13_lv_nmos w=0.74u l=0.13u
CL_n1135 n1135 gn1 2f
XPA_n1136 n1136 n1074 ph1 ph1 sg13_lv_pmos w=1.12u l=0.13u
XPB_n1136 n1136 n1077 ph1 ph1 sg13_lv_pmos w=1.12u l=0.13u
XNA_n1136 n1136 n1074 m_n1136 gn1 sg13_lv_nmos w=0.74u l=0.13u
XNB_n1136 m_n1136 n1077 gn1 gn1 sg13_lv_nmos w=0.74u l=0.13u
CL_n1136 n1136 gn1 2f
XPA_n1138 n1138 n1071 ph1 ph1 sg13_lv_pmos w=1.12u l=0.13u
XPB_n1138 n1138 n1077 ph1 ph1 sg13_lv_pmos w=1.12u l=0.13u
XNA_n1138 n1138 n1071 m_n1138 gn1 sg13_lv_nmos w=0.74u l=0.13u
XNB_n1138 m_n1138 n1077 gn1 gn1 sg13_lv_nmos w=0.74u l=0.13u
CL_n1138 n1138 gn1 2f
XPA_n1139 n1139 n1074 ph1 ph1 sg13_lv_pmos w=1.12u l=0.13u
XPB_n1139 n1139 n1080 ph1 ph1 sg13_lv_pmos w=1.12u l=0.13u
XNA_n1139 n1139 n1074 m_n1139 gn1 sg13_lv_nmos w=0.74u l=0.13u
XNB_n1139 m_n1139 n1080 gn1 gn1 sg13_lv_nmos w=0.74u l=0.13u
CL_n1139 n1139 gn1 2f
XPA_n1141 n1141 n1083 ph1 ph1 sg13_lv_pmos w=1.12u l=0.13u
XPB_n1141 n1141 n1092 ph1 ph1 sg13_lv_pmos w=1.12u l=0.13u
XNA_n1141 n1141 n1083 m_n1141 gn1 sg13_lv_nmos w=0.74u l=0.13u
XNB_n1141 m_n1141 n1092 gn1 gn1 sg13_lv_nmos w=0.74u l=0.13u
CL_n1141 n1141 gn1 2f
XPA_n1142 n1142 n1086 ph1 ph1 sg13_lv_pmos w=1.12u l=0.13u
XPB_n1142 n1142 n1089 ph1 ph1 sg13_lv_pmos w=1.12u l=0.13u
XNA_n1142 n1142 n1086 m_n1142 gn1 sg13_lv_nmos w=0.74u l=0.13u
XNB_n1142 m_n1142 n1089 gn1 gn1 sg13_lv_nmos w=0.74u l=0.13u
CL_n1142 n1142 gn1 2f
XPA_n1144 n1144 n1083 ph1 ph1 sg13_lv_pmos w=1.12u l=0.13u
XPB_n1144 n1144 n1089 ph1 ph1 sg13_lv_pmos w=1.12u l=0.13u
XNA_n1144 n1144 n1083 m_n1144 gn1 sg13_lv_nmos w=0.74u l=0.13u
XNB_n1144 m_n1144 n1089 gn1 gn1 sg13_lv_nmos w=0.74u l=0.13u
CL_n1144 n1144 gn1 2f
XPA_n1145 n1145 n1086 ph1 ph1 sg13_lv_pmos w=1.12u l=0.13u
XPB_n1145 n1145 n1092 ph1 ph1 sg13_lv_pmos w=1.12u l=0.13u
XNA_n1145 n1145 n1086 m_n1145 gn1 sg13_lv_nmos w=0.74u l=0.13u
XNB_n1145 m_n1145 n1092 gn1 gn1 sg13_lv_nmos w=0.74u l=0.13u
CL_n1145 n1145 gn1 2f
XPA_n1147 n1147 n1095 ph1 ph1 sg13_lv_pmos w=1.12u l=0.13u
XPB_n1147 n1147 n1104 ph1 ph1 sg13_lv_pmos w=1.12u l=0.13u
XNA_n1147 n1147 n1095 m_n1147 gn1 sg13_lv_nmos w=0.74u l=0.13u
XNB_n1147 m_n1147 n1104 gn1 gn1 sg13_lv_nmos w=0.74u l=0.13u
CL_n1147 n1147 gn1 2f
XPA_n1148 n1148 n1098 ph1 ph1 sg13_lv_pmos w=1.12u l=0.13u
XPB_n1148 n1148 n1101 ph1 ph1 sg13_lv_pmos w=1.12u l=0.13u
XNA_n1148 n1148 n1098 m_n1148 gn1 sg13_lv_nmos w=0.74u l=0.13u
XNB_n1148 m_n1148 n1101 gn1 gn1 sg13_lv_nmos w=0.74u l=0.13u
CL_n1148 n1148 gn1 2f
XPA_n1150 n1150 n1095 ph1 ph1 sg13_lv_pmos w=1.12u l=0.13u
XPB_n1150 n1150 n1101 ph1 ph1 sg13_lv_pmos w=1.12u l=0.13u
XNA_n1150 n1150 n1095 m_n1150 gn1 sg13_lv_nmos w=0.74u l=0.13u
XNB_n1150 m_n1150 n1101 gn1 gn1 sg13_lv_nmos w=0.74u l=0.13u
CL_n1150 n1150 gn1 2f
XPA_n1151 n1151 n1098 ph1 ph1 sg13_lv_pmos w=1.12u l=0.13u
XPB_n1151 n1151 n1104 ph1 ph1 sg13_lv_pmos w=1.12u l=0.13u
XNA_n1151 n1151 n1098 m_n1151 gn1 sg13_lv_nmos w=0.74u l=0.13u
XNB_n1151 m_n1151 n1104 gn1 gn1 sg13_lv_nmos w=0.74u l=0.13u
CL_n1151 n1151 gn1 2f
XPA_n1153 n1153 n1107 ph1 ph1 sg13_lv_pmos w=1.12u l=0.13u
XPB_n1153 n1153 n1116 ph1 ph1 sg13_lv_pmos w=1.12u l=0.13u
XNA_n1153 n1153 n1107 m_n1153 gn1 sg13_lv_nmos w=0.74u l=0.13u
XNB_n1153 m_n1153 n1116 gn1 gn1 sg13_lv_nmos w=0.74u l=0.13u
CL_n1153 n1153 gn1 2f
XPA_n1154 n1154 n1110 ph1 ph1 sg13_lv_pmos w=1.12u l=0.13u
XPB_n1154 n1154 n1113 ph1 ph1 sg13_lv_pmos w=1.12u l=0.13u
XNA_n1154 n1154 n1110 m_n1154 gn1 sg13_lv_nmos w=0.74u l=0.13u
XNB_n1154 m_n1154 n1113 gn1 gn1 sg13_lv_nmos w=0.74u l=0.13u
CL_n1154 n1154 gn1 2f
XPA_n1156 n1156 n1107 ph1 ph1 sg13_lv_pmos w=1.12u l=0.13u
XPB_n1156 n1156 n1113 ph1 ph1 sg13_lv_pmos w=1.12u l=0.13u
XNA_n1156 n1156 n1107 m_n1156 gn1 sg13_lv_nmos w=0.74u l=0.13u
XNB_n1156 m_n1156 n1113 gn1 gn1 sg13_lv_nmos w=0.74u l=0.13u
CL_n1156 n1156 gn1 2f
XPA_n1157 n1157 n1110 ph1 ph1 sg13_lv_pmos w=1.12u l=0.13u
XPB_n1157 n1157 n1116 ph1 ph1 sg13_lv_pmos w=1.12u l=0.13u
XNA_n1157 n1157 n1110 m_n1157 gn1 sg13_lv_nmos w=0.74u l=0.13u
XNB_n1157 m_n1157 n1116 gn1 gn1 sg13_lv_nmos w=0.74u l=0.13u
CL_n1157 n1157 gn1 2f
XPA_n127 n127 n99 ph1 ph1 sg13_lv_pmos w=1.12u l=0.13u
XPB_n127 n127 n108 ph1 ph1 sg13_lv_pmos w=1.12u l=0.13u
XNA_n127 n127 n99 m_n127 gn1 sg13_lv_nmos w=0.74u l=0.13u
XNB_n127 m_n127 n108 gn1 gn1 sg13_lv_nmos w=0.74u l=0.13u
CL_n127 n127 gn1 2f
XPA_n128 n128 n102 ph1 ph1 sg13_lv_pmos w=1.12u l=0.13u
XPB_n128 n128 n105 ph1 ph1 sg13_lv_pmos w=1.12u l=0.13u
XNA_n128 n128 n102 m_n128 gn1 sg13_lv_nmos w=0.74u l=0.13u
XNB_n128 m_n128 n105 gn1 gn1 sg13_lv_nmos w=0.74u l=0.13u
CL_n128 n128 gn1 2f
XPA_n130 n130 n99 ph1 ph1 sg13_lv_pmos w=1.12u l=0.13u
XPB_n130 n130 n105 ph1 ph1 sg13_lv_pmos w=1.12u l=0.13u
XNA_n130 n130 n99 m_n130 gn1 sg13_lv_nmos w=0.74u l=0.13u
XNB_n130 m_n130 n105 gn1 gn1 sg13_lv_nmos w=0.74u l=0.13u
CL_n130 n130 gn1 2f
XPA_n1303 n1303 n1209 ph1 ph1 sg13_lv_pmos w=1.12u l=0.13u
XPB_n1303 n1303 n1218 ph1 ph1 sg13_lv_pmos w=1.12u l=0.13u
XNA_n1303 n1303 n1209 m_n1303 gn1 sg13_lv_nmos w=0.74u l=0.13u
XNB_n1303 m_n1303 n1218 gn1 gn1 sg13_lv_nmos w=0.74u l=0.13u
CL_n1303 n1303 gn1 2f
XPA_n1304 n1304 n1212 ph1 ph1 sg13_lv_pmos w=1.12u l=0.13u
XPB_n1304 n1304 n1215 ph1 ph1 sg13_lv_pmos w=1.12u l=0.13u
XNA_n1304 n1304 n1212 m_n1304 gn1 sg13_lv_nmos w=0.74u l=0.13u
XNB_n1304 m_n1304 n1215 gn1 gn1 sg13_lv_nmos w=0.74u l=0.13u
CL_n1304 n1304 gn1 2f
XPA_n1306 n1306 n1209 ph1 ph1 sg13_lv_pmos w=1.12u l=0.13u
XPB_n1306 n1306 n1215 ph1 ph1 sg13_lv_pmos w=1.12u l=0.13u
XNA_n1306 n1306 n1209 m_n1306 gn1 sg13_lv_nmos w=0.74u l=0.13u
XNB_n1306 m_n1306 n1215 gn1 gn1 sg13_lv_nmos w=0.74u l=0.13u
CL_n1306 n1306 gn1 2f
XPA_n1307 n1307 n1212 ph1 ph1 sg13_lv_pmos w=1.12u l=0.13u
XPB_n1307 n1307 n1218 ph1 ph1 sg13_lv_pmos w=1.12u l=0.13u
XNA_n1307 n1307 n1212 m_n1307 gn1 sg13_lv_nmos w=0.74u l=0.13u
XNB_n1307 m_n1307 n1218 gn1 gn1 sg13_lv_nmos w=0.74u l=0.13u
CL_n1307 n1307 gn1 2f
XPA_n1309 n1309 n1221 ph1 ph1 sg13_lv_pmos w=1.12u l=0.13u
XPB_n1309 n1309 n1230 ph1 ph1 sg13_lv_pmos w=1.12u l=0.13u
XNA_n1309 n1309 n1221 m_n1309 gn1 sg13_lv_nmos w=0.74u l=0.13u
XNB_n1309 m_n1309 n1230 gn1 gn1 sg13_lv_nmos w=0.74u l=0.13u
CL_n1309 n1309 gn1 2f
XPA_n131 n131 n102 ph1 ph1 sg13_lv_pmos w=1.12u l=0.13u
XPB_n131 n131 n108 ph1 ph1 sg13_lv_pmos w=1.12u l=0.13u
XNA_n131 n131 n102 m_n131 gn1 sg13_lv_nmos w=0.74u l=0.13u
XNB_n131 m_n131 n108 gn1 gn1 sg13_lv_nmos w=0.74u l=0.13u
CL_n131 n131 gn1 2f
XPA_n1310 n1310 n1224 ph1 ph1 sg13_lv_pmos w=1.12u l=0.13u
XPB_n1310 n1310 n1227 ph1 ph1 sg13_lv_pmos w=1.12u l=0.13u
XNA_n1310 n1310 n1224 m_n1310 gn1 sg13_lv_nmos w=0.74u l=0.13u
XNB_n1310 m_n1310 n1227 gn1 gn1 sg13_lv_nmos w=0.74u l=0.13u
CL_n1310 n1310 gn1 2f
XPA_n1312 n1312 n1221 ph1 ph1 sg13_lv_pmos w=1.12u l=0.13u
XPB_n1312 n1312 n1227 ph1 ph1 sg13_lv_pmos w=1.12u l=0.13u
XNA_n1312 n1312 n1221 m_n1312 gn1 sg13_lv_nmos w=0.74u l=0.13u
XNB_n1312 m_n1312 n1227 gn1 gn1 sg13_lv_nmos w=0.74u l=0.13u
CL_n1312 n1312 gn1 2f
XPA_n1313 n1313 n1224 ph1 ph1 sg13_lv_pmos w=1.12u l=0.13u
XPB_n1313 n1313 n1230 ph1 ph1 sg13_lv_pmos w=1.12u l=0.13u
XNA_n1313 n1313 n1224 m_n1313 gn1 sg13_lv_nmos w=0.74u l=0.13u
XNB_n1313 m_n1313 n1230 gn1 gn1 sg13_lv_nmos w=0.74u l=0.13u
CL_n1313 n1313 gn1 2f
XPA_n1315 n1315 n1233 ph1 ph1 sg13_lv_pmos w=1.12u l=0.13u
XPB_n1315 n1315 n1242 ph1 ph1 sg13_lv_pmos w=1.12u l=0.13u
XNA_n1315 n1315 n1233 m_n1315 gn1 sg13_lv_nmos w=0.74u l=0.13u
XNB_n1315 m_n1315 n1242 gn1 gn1 sg13_lv_nmos w=0.74u l=0.13u
CL_n1315 n1315 gn1 2f
XPA_n1316 n1316 n1236 ph1 ph1 sg13_lv_pmos w=1.12u l=0.13u
XPB_n1316 n1316 n1239 ph1 ph1 sg13_lv_pmos w=1.12u l=0.13u
XNA_n1316 n1316 n1236 m_n1316 gn1 sg13_lv_nmos w=0.74u l=0.13u
XNB_n1316 m_n1316 n1239 gn1 gn1 sg13_lv_nmos w=0.74u l=0.13u
CL_n1316 n1316 gn1 2f
XPA_n1318 n1318 n1233 ph1 ph1 sg13_lv_pmos w=1.12u l=0.13u
XPB_n1318 n1318 n1239 ph1 ph1 sg13_lv_pmos w=1.12u l=0.13u
XNA_n1318 n1318 n1233 m_n1318 gn1 sg13_lv_nmos w=0.74u l=0.13u
XNB_n1318 m_n1318 n1239 gn1 gn1 sg13_lv_nmos w=0.74u l=0.13u
CL_n1318 n1318 gn1 2f
XPA_n1319 n1319 n1236 ph1 ph1 sg13_lv_pmos w=1.12u l=0.13u
XPB_n1319 n1319 n1242 ph1 ph1 sg13_lv_pmos w=1.12u l=0.13u
XNA_n1319 n1319 n1236 m_n1319 gn1 sg13_lv_nmos w=0.74u l=0.13u
XNB_n1319 m_n1319 n1242 gn1 gn1 sg13_lv_nmos w=0.74u l=0.13u
CL_n1319 n1319 gn1 2f
XPA_n1321 n1321 n1245 ph1 ph1 sg13_lv_pmos w=1.12u l=0.13u
XPB_n1321 n1321 n1254 ph1 ph1 sg13_lv_pmos w=1.12u l=0.13u
XNA_n1321 n1321 n1245 m_n1321 gn1 sg13_lv_nmos w=0.74u l=0.13u
XNB_n1321 m_n1321 n1254 gn1 gn1 sg13_lv_nmos w=0.74u l=0.13u
CL_n1321 n1321 gn1 2f
XPA_n1322 n1322 n1248 ph1 ph1 sg13_lv_pmos w=1.12u l=0.13u
XPB_n1322 n1322 n1251 ph1 ph1 sg13_lv_pmos w=1.12u l=0.13u
XNA_n1322 n1322 n1248 m_n1322 gn1 sg13_lv_nmos w=0.74u l=0.13u
XNB_n1322 m_n1322 n1251 gn1 gn1 sg13_lv_nmos w=0.74u l=0.13u
CL_n1322 n1322 gn1 2f
XPA_n1324 n1324 n1245 ph1 ph1 sg13_lv_pmos w=1.12u l=0.13u
XPB_n1324 n1324 n1251 ph1 ph1 sg13_lv_pmos w=1.12u l=0.13u
XNA_n1324 n1324 n1245 m_n1324 gn1 sg13_lv_nmos w=0.74u l=0.13u
XNB_n1324 m_n1324 n1251 gn1 gn1 sg13_lv_nmos w=0.74u l=0.13u
CL_n1324 n1324 gn1 2f
XPA_n1325 n1325 n1248 ph1 ph1 sg13_lv_pmos w=1.12u l=0.13u
XPB_n1325 n1325 n1254 ph1 ph1 sg13_lv_pmos w=1.12u l=0.13u
XNA_n1325 n1325 n1248 m_n1325 gn1 sg13_lv_nmos w=0.74u l=0.13u
XNB_n1325 m_n1325 n1254 gn1 gn1 sg13_lv_nmos w=0.74u l=0.13u
CL_n1325 n1325 gn1 2f
XPA_n1327 n1327 n1257 ph1 ph1 sg13_lv_pmos w=1.12u l=0.13u
XPB_n1327 n1327 n1266 ph1 ph1 sg13_lv_pmos w=1.12u l=0.13u
XNA_n1327 n1327 n1257 m_n1327 gn1 sg13_lv_nmos w=0.74u l=0.13u
XNB_n1327 m_n1327 n1266 gn1 gn1 sg13_lv_nmos w=0.74u l=0.13u
CL_n1327 n1327 gn1 2f
XPA_n1328 n1328 n1260 ph1 ph1 sg13_lv_pmos w=1.12u l=0.13u
XPB_n1328 n1328 n1263 ph1 ph1 sg13_lv_pmos w=1.12u l=0.13u
XNA_n1328 n1328 n1260 m_n1328 gn1 sg13_lv_nmos w=0.74u l=0.13u
XNB_n1328 m_n1328 n1263 gn1 gn1 sg13_lv_nmos w=0.74u l=0.13u
CL_n1328 n1328 gn1 2f
XPA_n1330 n1330 n1257 ph1 ph1 sg13_lv_pmos w=1.12u l=0.13u
XPB_n1330 n1330 n1263 ph1 ph1 sg13_lv_pmos w=1.12u l=0.13u
XNA_n1330 n1330 n1257 m_n1330 gn1 sg13_lv_nmos w=0.74u l=0.13u
XNB_n1330 m_n1330 n1263 gn1 gn1 sg13_lv_nmos w=0.74u l=0.13u
CL_n1330 n1330 gn1 2f
XPA_n1331 n1331 n1260 ph1 ph1 sg13_lv_pmos w=1.12u l=0.13u
XPB_n1331 n1331 n1266 ph1 ph1 sg13_lv_pmos w=1.12u l=0.13u
XNA_n1331 n1331 n1260 m_n1331 gn1 sg13_lv_nmos w=0.74u l=0.13u
XNB_n1331 m_n1331 n1266 gn1 gn1 sg13_lv_nmos w=0.74u l=0.13u
CL_n1331 n1331 gn1 2f
XPA_n1333 n1333 n1269 ph1 ph1 sg13_lv_pmos w=1.12u l=0.13u
XPB_n1333 n1333 n1278 ph1 ph1 sg13_lv_pmos w=1.12u l=0.13u
XNA_n1333 n1333 n1269 m_n1333 gn1 sg13_lv_nmos w=0.74u l=0.13u
XNB_n1333 m_n1333 n1278 gn1 gn1 sg13_lv_nmos w=0.74u l=0.13u
CL_n1333 n1333 gn1 2f
XPA_n1334 n1334 n1272 ph1 ph1 sg13_lv_pmos w=1.12u l=0.13u
XPB_n1334 n1334 n1275 ph1 ph1 sg13_lv_pmos w=1.12u l=0.13u
XNA_n1334 n1334 n1272 m_n1334 gn1 sg13_lv_nmos w=0.74u l=0.13u
XNB_n1334 m_n1334 n1275 gn1 gn1 sg13_lv_nmos w=0.74u l=0.13u
CL_n1334 n1334 gn1 2f
XPA_n1336 n1336 n1269 ph1 ph1 sg13_lv_pmos w=1.12u l=0.13u
XPB_n1336 n1336 n1275 ph1 ph1 sg13_lv_pmos w=1.12u l=0.13u
XNA_n1336 n1336 n1269 m_n1336 gn1 sg13_lv_nmos w=0.74u l=0.13u
XNB_n1336 m_n1336 n1275 gn1 gn1 sg13_lv_nmos w=0.74u l=0.13u
CL_n1336 n1336 gn1 2f
XPA_n1337 n1337 n1272 ph1 ph1 sg13_lv_pmos w=1.12u l=0.13u
XPB_n1337 n1337 n1278 ph1 ph1 sg13_lv_pmos w=1.12u l=0.13u
XNA_n1337 n1337 n1272 m_n1337 gn1 sg13_lv_nmos w=0.74u l=0.13u
XNB_n1337 m_n1337 n1278 gn1 gn1 sg13_lv_nmos w=0.74u l=0.13u
CL_n1337 n1337 gn1 2f
XPA_n1339 n1339 n1281 ph1 ph1 sg13_lv_pmos w=1.12u l=0.13u
XPB_n1339 n1339 n1290 ph1 ph1 sg13_lv_pmos w=1.12u l=0.13u
XNA_n1339 n1339 n1281 m_n1339 gn1 sg13_lv_nmos w=0.74u l=0.13u
XNB_n1339 m_n1339 n1290 gn1 gn1 sg13_lv_nmos w=0.74u l=0.13u
CL_n1339 n1339 gn1 2f
XPA_n1340 n1340 n1284 ph1 ph1 sg13_lv_pmos w=1.12u l=0.13u
XPB_n1340 n1340 n1287 ph1 ph1 sg13_lv_pmos w=1.12u l=0.13u
XNA_n1340 n1340 n1284 m_n1340 gn1 sg13_lv_nmos w=0.74u l=0.13u
XNB_n1340 m_n1340 n1287 gn1 gn1 sg13_lv_nmos w=0.74u l=0.13u
CL_n1340 n1340 gn1 2f
XPA_n1342 n1342 n1281 ph1 ph1 sg13_lv_pmos w=1.12u l=0.13u
XPB_n1342 n1342 n1287 ph1 ph1 sg13_lv_pmos w=1.12u l=0.13u
XNA_n1342 n1342 n1281 m_n1342 gn1 sg13_lv_nmos w=0.74u l=0.13u
XNB_n1342 m_n1342 n1287 gn1 gn1 sg13_lv_nmos w=0.74u l=0.13u
CL_n1342 n1342 gn1 2f
XPA_n1343 n1343 n1284 ph1 ph1 sg13_lv_pmos w=1.12u l=0.13u
XPB_n1343 n1343 n1290 ph1 ph1 sg13_lv_pmos w=1.12u l=0.13u
XNA_n1343 n1343 n1284 m_n1343 gn1 sg13_lv_nmos w=0.74u l=0.13u
XNB_n1343 m_n1343 n1290 gn1 gn1 sg13_lv_nmos w=0.74u l=0.13u
CL_n1343 n1343 gn1 2f
XPA_n1345 n1345 n1293 ph1 ph1 sg13_lv_pmos w=1.12u l=0.13u
XPB_n1345 n1345 n1302 ph1 ph1 sg13_lv_pmos w=1.12u l=0.13u
XNA_n1345 n1345 n1293 m_n1345 gn1 sg13_lv_nmos w=0.74u l=0.13u
XNB_n1345 m_n1345 n1302 gn1 gn1 sg13_lv_nmos w=0.74u l=0.13u
CL_n1345 n1345 gn1 2f
XPA_n1346 n1346 n1296 ph1 ph1 sg13_lv_pmos w=1.12u l=0.13u
XPB_n1346 n1346 n1299 ph1 ph1 sg13_lv_pmos w=1.12u l=0.13u
XNA_n1346 n1346 n1296 m_n1346 gn1 sg13_lv_nmos w=0.74u l=0.13u
XNB_n1346 m_n1346 n1299 gn1 gn1 sg13_lv_nmos w=0.74u l=0.13u
CL_n1346 n1346 gn1 2f
XPA_n1348 n1348 n1293 ph1 ph1 sg13_lv_pmos w=1.12u l=0.13u
XPB_n1348 n1348 n1299 ph1 ph1 sg13_lv_pmos w=1.12u l=0.13u
XNA_n1348 n1348 n1293 m_n1348 gn1 sg13_lv_nmos w=0.74u l=0.13u
XNB_n1348 m_n1348 n1299 gn1 gn1 sg13_lv_nmos w=0.74u l=0.13u
CL_n1348 n1348 gn1 2f
XPA_n1349 n1349 n1296 ph1 ph1 sg13_lv_pmos w=1.12u l=0.13u
XPB_n1349 n1349 n1302 ph1 ph1 sg13_lv_pmos w=1.12u l=0.13u
XNA_n1349 n1349 n1296 m_n1349 gn1 sg13_lv_nmos w=0.74u l=0.13u
XNB_n1349 m_n1349 n1302 gn1 gn1 sg13_lv_nmos w=0.74u l=0.13u
CL_n1349 n1349 gn1 2f
XPA_n211 n211 n153 ph1 ph1 sg13_lv_pmos w=1.12u l=0.13u
XPB_n211 n211 n162 ph1 ph1 sg13_lv_pmos w=1.12u l=0.13u
XNA_n211 n211 n153 m_n211 gn1 sg13_lv_nmos w=0.74u l=0.13u
XNB_n211 m_n211 n162 gn1 gn1 sg13_lv_nmos w=0.74u l=0.13u
CL_n211 n211 gn1 2f
XPA_n212 n212 n156 ph1 ph1 sg13_lv_pmos w=1.12u l=0.13u
XPB_n212 n212 n159 ph1 ph1 sg13_lv_pmos w=1.12u l=0.13u
XNA_n212 n212 n156 m_n212 gn1 sg13_lv_nmos w=0.74u l=0.13u
XNB_n212 m_n212 n159 gn1 gn1 sg13_lv_nmos w=0.74u l=0.13u
CL_n212 n212 gn1 2f
XPA_n214 n214 n153 ph1 ph1 sg13_lv_pmos w=1.12u l=0.13u
XPB_n214 n214 n159 ph1 ph1 sg13_lv_pmos w=1.12u l=0.13u
XNA_n214 n214 n153 m_n214 gn1 sg13_lv_nmos w=0.74u l=0.13u
XNB_n214 m_n214 n159 gn1 gn1 sg13_lv_nmos w=0.74u l=0.13u
CL_n214 n214 gn1 2f
XPA_n215 n215 n156 ph1 ph1 sg13_lv_pmos w=1.12u l=0.13u
XPB_n215 n215 n162 ph1 ph1 sg13_lv_pmos w=1.12u l=0.13u
XNA_n215 n215 n156 m_n215 gn1 sg13_lv_nmos w=0.74u l=0.13u
XNB_n215 m_n215 n162 gn1 gn1 sg13_lv_nmos w=0.74u l=0.13u
CL_n215 n215 gn1 2f
XPA_n217 n217 n165 ph1 ph1 sg13_lv_pmos w=1.12u l=0.13u
XPB_n217 n217 n174 ph1 ph1 sg13_lv_pmos w=1.12u l=0.13u
XNA_n217 n217 n165 m_n217 gn1 sg13_lv_nmos w=0.74u l=0.13u
XNB_n217 m_n217 n174 gn1 gn1 sg13_lv_nmos w=0.74u l=0.13u
CL_n217 n217 gn1 2f
XPA_n218 n218 n168 ph1 ph1 sg13_lv_pmos w=1.12u l=0.13u
XPB_n218 n218 n171 ph1 ph1 sg13_lv_pmos w=1.12u l=0.13u
XNA_n218 n218 n168 m_n218 gn1 sg13_lv_nmos w=0.74u l=0.13u
XNB_n218 m_n218 n171 gn1 gn1 sg13_lv_nmos w=0.74u l=0.13u
CL_n218 n218 gn1 2f
XPA_n220 n220 n165 ph1 ph1 sg13_lv_pmos w=1.12u l=0.13u
XPB_n220 n220 n171 ph1 ph1 sg13_lv_pmos w=1.12u l=0.13u
XNA_n220 n220 n165 m_n220 gn1 sg13_lv_nmos w=0.74u l=0.13u
XNB_n220 m_n220 n171 gn1 gn1 sg13_lv_nmos w=0.74u l=0.13u
CL_n220 n220 gn1 2f
XPA_n221 n221 n168 ph1 ph1 sg13_lv_pmos w=1.12u l=0.13u
XPB_n221 n221 n174 ph1 ph1 sg13_lv_pmos w=1.12u l=0.13u
XNA_n221 n221 n168 m_n221 gn1 sg13_lv_nmos w=0.74u l=0.13u
XNB_n221 m_n221 n174 gn1 gn1 sg13_lv_nmos w=0.74u l=0.13u
CL_n221 n221 gn1 2f
XPA_n223 n223 n177 ph1 ph1 sg13_lv_pmos w=1.12u l=0.13u
XPB_n223 n223 n186 ph1 ph1 sg13_lv_pmos w=1.12u l=0.13u
XNA_n223 n223 n177 m_n223 gn1 sg13_lv_nmos w=0.74u l=0.13u
XNB_n223 m_n223 n186 gn1 gn1 sg13_lv_nmos w=0.74u l=0.13u
CL_n223 n223 gn1 2f
XPA_n224 n224 n180 ph1 ph1 sg13_lv_pmos w=1.12u l=0.13u
XPB_n224 n224 n183 ph1 ph1 sg13_lv_pmos w=1.12u l=0.13u
XNA_n224 n224 n180 m_n224 gn1 sg13_lv_nmos w=0.74u l=0.13u
XNB_n224 m_n224 n183 gn1 gn1 sg13_lv_nmos w=0.74u l=0.13u
CL_n224 n224 gn1 2f
XPA_n226 n226 n177 ph1 ph1 sg13_lv_pmos w=1.12u l=0.13u
XPB_n226 n226 n183 ph1 ph1 sg13_lv_pmos w=1.12u l=0.13u
XNA_n226 n226 n177 m_n226 gn1 sg13_lv_nmos w=0.74u l=0.13u
XNB_n226 m_n226 n183 gn1 gn1 sg13_lv_nmos w=0.74u l=0.13u
CL_n226 n226 gn1 2f
XPA_n227 n227 n180 ph1 ph1 sg13_lv_pmos w=1.12u l=0.13u
XPB_n227 n227 n186 ph1 ph1 sg13_lv_pmos w=1.12u l=0.13u
XNA_n227 n227 n180 m_n227 gn1 sg13_lv_nmos w=0.74u l=0.13u
XNB_n227 m_n227 n186 gn1 gn1 sg13_lv_nmos w=0.74u l=0.13u
CL_n227 n227 gn1 2f
XPA_n229 n229 n189 ph1 ph1 sg13_lv_pmos w=1.12u l=0.13u
XPB_n229 n229 n198 ph1 ph1 sg13_lv_pmos w=1.12u l=0.13u
XNA_n229 n229 n189 m_n229 gn1 sg13_lv_nmos w=0.74u l=0.13u
XNB_n229 m_n229 n198 gn1 gn1 sg13_lv_nmos w=0.74u l=0.13u
CL_n229 n229 gn1 2f
XPA_n230 n230 n192 ph1 ph1 sg13_lv_pmos w=1.12u l=0.13u
XPB_n230 n230 n195 ph1 ph1 sg13_lv_pmos w=1.12u l=0.13u
XNA_n230 n230 n192 m_n230 gn1 sg13_lv_nmos w=0.74u l=0.13u
XNB_n230 m_n230 n195 gn1 gn1 sg13_lv_nmos w=0.74u l=0.13u
CL_n230 n230 gn1 2f
XPA_n232 n232 n189 ph1 ph1 sg13_lv_pmos w=1.12u l=0.13u
XPB_n232 n232 n195 ph1 ph1 sg13_lv_pmos w=1.12u l=0.13u
XNA_n232 n232 n189 m_n232 gn1 sg13_lv_nmos w=0.74u l=0.13u
XNB_n232 m_n232 n195 gn1 gn1 sg13_lv_nmos w=0.74u l=0.13u
CL_n232 n232 gn1 2f
XPA_n233 n233 n192 ph1 ph1 sg13_lv_pmos w=1.12u l=0.13u
XPB_n233 n233 n198 ph1 ph1 sg13_lv_pmos w=1.12u l=0.13u
XNA_n233 n233 n192 m_n233 gn1 sg13_lv_nmos w=0.74u l=0.13u
XNB_n233 m_n233 n198 gn1 gn1 sg13_lv_nmos w=0.74u l=0.13u
CL_n233 n233 gn1 2f
XPA_n235 n235 n201 ph1 ph1 sg13_lv_pmos w=1.12u l=0.13u
XPB_n235 n235 n210 ph1 ph1 sg13_lv_pmos w=1.12u l=0.13u
XNA_n235 n235 n201 m_n235 gn1 sg13_lv_nmos w=0.74u l=0.13u
XNB_n235 m_n235 n210 gn1 gn1 sg13_lv_nmos w=0.74u l=0.13u
CL_n235 n235 gn1 2f
XPA_n236 n236 n204 ph1 ph1 sg13_lv_pmos w=1.12u l=0.13u
XPB_n236 n236 n207 ph1 ph1 sg13_lv_pmos w=1.12u l=0.13u
XNA_n236 n236 n204 m_n236 gn1 sg13_lv_nmos w=0.74u l=0.13u
XNB_n236 m_n236 n207 gn1 gn1 sg13_lv_nmos w=0.74u l=0.13u
CL_n236 n236 gn1 2f
XPA_n238 n238 n201 ph1 ph1 sg13_lv_pmos w=1.12u l=0.13u
XPB_n238 n238 n207 ph1 ph1 sg13_lv_pmos w=1.12u l=0.13u
XNA_n238 n238 n201 m_n238 gn1 sg13_lv_nmos w=0.74u l=0.13u
XNB_n238 m_n238 n207 gn1 gn1 sg13_lv_nmos w=0.74u l=0.13u
CL_n238 n238 gn1 2f
XPA_n239 n239 n204 ph1 ph1 sg13_lv_pmos w=1.12u l=0.13u
XPB_n239 n239 n210 ph1 ph1 sg13_lv_pmos w=1.12u l=0.13u
XNA_n239 n239 n204 m_n239 gn1 sg13_lv_nmos w=0.74u l=0.13u
XNB_n239 m_n239 n210 gn1 gn1 sg13_lv_nmos w=0.74u l=0.13u
CL_n239 n239 gn1 2f
XPA_n277 n277 n249 ph1 ph1 sg13_lv_pmos w=1.12u l=0.13u
XPB_n277 n277 n258 ph1 ph1 sg13_lv_pmos w=1.12u l=0.13u
XNA_n277 n277 n249 m_n277 gn1 sg13_lv_nmos w=0.74u l=0.13u
XNB_n277 m_n277 n258 gn1 gn1 sg13_lv_nmos w=0.74u l=0.13u
CL_n277 n277 gn1 2f
XPA_n278 n278 n252 ph1 ph1 sg13_lv_pmos w=1.12u l=0.13u
XPB_n278 n278 n255 ph1 ph1 sg13_lv_pmos w=1.12u l=0.13u
XNA_n278 n278 n252 m_n278 gn1 sg13_lv_nmos w=0.74u l=0.13u
XNB_n278 m_n278 n255 gn1 gn1 sg13_lv_nmos w=0.74u l=0.13u
CL_n278 n278 gn1 2f
XPA_n280 n280 n249 ph1 ph1 sg13_lv_pmos w=1.12u l=0.13u
XPB_n280 n280 n255 ph1 ph1 sg13_lv_pmos w=1.12u l=0.13u
XNA_n280 n280 n249 m_n280 gn1 sg13_lv_nmos w=0.74u l=0.13u
XNB_n280 m_n280 n255 gn1 gn1 sg13_lv_nmos w=0.74u l=0.13u
CL_n280 n280 gn1 2f
XPA_n281 n281 n252 ph1 ph1 sg13_lv_pmos w=1.12u l=0.13u
XPB_n281 n281 n258 ph1 ph1 sg13_lv_pmos w=1.12u l=0.13u
XNA_n281 n281 n252 m_n281 gn1 sg13_lv_nmos w=0.74u l=0.13u
XNB_n281 m_n281 n258 gn1 gn1 sg13_lv_nmos w=0.74u l=0.13u
CL_n281 n281 gn1 2f
XPA_n397 n397 n303 ph1 ph1 sg13_lv_pmos w=1.12u l=0.13u
XPB_n397 n397 n312 ph1 ph1 sg13_lv_pmos w=1.12u l=0.13u
XNA_n397 n397 n303 m_n397 gn1 sg13_lv_nmos w=0.74u l=0.13u
XNB_n397 m_n397 n312 gn1 gn1 sg13_lv_nmos w=0.74u l=0.13u
CL_n397 n397 gn1 2f
XPA_n398 n398 n306 ph1 ph1 sg13_lv_pmos w=1.12u l=0.13u
XPB_n398 n398 n309 ph1 ph1 sg13_lv_pmos w=1.12u l=0.13u
XNA_n398 n398 n306 m_n398 gn1 sg13_lv_nmos w=0.74u l=0.13u
XNB_n398 m_n398 n309 gn1 gn1 sg13_lv_nmos w=0.74u l=0.13u
CL_n398 n398 gn1 2f
XPA_n400 n400 n303 ph1 ph1 sg13_lv_pmos w=1.12u l=0.13u
XPB_n400 n400 n309 ph1 ph1 sg13_lv_pmos w=1.12u l=0.13u
XNA_n400 n400 n303 m_n400 gn1 sg13_lv_nmos w=0.74u l=0.13u
XNB_n400 m_n400 n309 gn1 gn1 sg13_lv_nmos w=0.74u l=0.13u
CL_n400 n400 gn1 2f
XPA_n401 n401 n306 ph1 ph1 sg13_lv_pmos w=1.12u l=0.13u
XPB_n401 n401 n312 ph1 ph1 sg13_lv_pmos w=1.12u l=0.13u
XNA_n401 n401 n306 m_n401 gn1 sg13_lv_nmos w=0.74u l=0.13u
XNB_n401 m_n401 n312 gn1 gn1 sg13_lv_nmos w=0.74u l=0.13u
CL_n401 n401 gn1 2f
XPA_n403 n403 n315 ph1 ph1 sg13_lv_pmos w=1.12u l=0.13u
XPB_n403 n403 n324 ph1 ph1 sg13_lv_pmos w=1.12u l=0.13u
XNA_n403 n403 n315 m_n403 gn1 sg13_lv_nmos w=0.74u l=0.13u
XNB_n403 m_n403 n324 gn1 gn1 sg13_lv_nmos w=0.74u l=0.13u
CL_n403 n403 gn1 2f
XPA_n404 n404 n318 ph1 ph1 sg13_lv_pmos w=1.12u l=0.13u
XPB_n404 n404 n321 ph1 ph1 sg13_lv_pmos w=1.12u l=0.13u
XNA_n404 n404 n318 m_n404 gn1 sg13_lv_nmos w=0.74u l=0.13u
XNB_n404 m_n404 n321 gn1 gn1 sg13_lv_nmos w=0.74u l=0.13u
CL_n404 n404 gn1 2f
XPA_n406 n406 n315 ph1 ph1 sg13_lv_pmos w=1.12u l=0.13u
XPB_n406 n406 n321 ph1 ph1 sg13_lv_pmos w=1.12u l=0.13u
XNA_n406 n406 n315 m_n406 gn1 sg13_lv_nmos w=0.74u l=0.13u
XNB_n406 m_n406 n321 gn1 gn1 sg13_lv_nmos w=0.74u l=0.13u
CL_n406 n406 gn1 2f
XPA_n407 n407 n318 ph1 ph1 sg13_lv_pmos w=1.12u l=0.13u
XPB_n407 n407 n324 ph1 ph1 sg13_lv_pmos w=1.12u l=0.13u
XNA_n407 n407 n318 m_n407 gn1 sg13_lv_nmos w=0.74u l=0.13u
XNB_n407 m_n407 n324 gn1 gn1 sg13_lv_nmos w=0.74u l=0.13u
CL_n407 n407 gn1 2f
XPA_n409 n409 n327 ph1 ph1 sg13_lv_pmos w=1.12u l=0.13u
XPB_n409 n409 n336 ph1 ph1 sg13_lv_pmos w=1.12u l=0.13u
XNA_n409 n409 n327 m_n409 gn1 sg13_lv_nmos w=0.74u l=0.13u
XNB_n409 m_n409 n336 gn1 gn1 sg13_lv_nmos w=0.74u l=0.13u
CL_n409 n409 gn1 2f
XPA_n410 n410 n330 ph1 ph1 sg13_lv_pmos w=1.12u l=0.13u
XPB_n410 n410 n333 ph1 ph1 sg13_lv_pmos w=1.12u l=0.13u
XNA_n410 n410 n330 m_n410 gn1 sg13_lv_nmos w=0.74u l=0.13u
XNB_n410 m_n410 n333 gn1 gn1 sg13_lv_nmos w=0.74u l=0.13u
CL_n410 n410 gn1 2f
XPA_n412 n412 n327 ph1 ph1 sg13_lv_pmos w=1.12u l=0.13u
XPB_n412 n412 n333 ph1 ph1 sg13_lv_pmos w=1.12u l=0.13u
XNA_n412 n412 n327 m_n412 gn1 sg13_lv_nmos w=0.74u l=0.13u
XNB_n412 m_n412 n333 gn1 gn1 sg13_lv_nmos w=0.74u l=0.13u
CL_n412 n412 gn1 2f
XPA_n413 n413 n330 ph1 ph1 sg13_lv_pmos w=1.12u l=0.13u
XPB_n413 n413 n336 ph1 ph1 sg13_lv_pmos w=1.12u l=0.13u
XNA_n413 n413 n330 m_n413 gn1 sg13_lv_nmos w=0.74u l=0.13u
XNB_n413 m_n413 n336 gn1 gn1 sg13_lv_nmos w=0.74u l=0.13u
CL_n413 n413 gn1 2f
XPA_n415 n415 n339 ph1 ph1 sg13_lv_pmos w=1.12u l=0.13u
XPB_n415 n415 n348 ph1 ph1 sg13_lv_pmos w=1.12u l=0.13u
XNA_n415 n415 n339 m_n415 gn1 sg13_lv_nmos w=0.74u l=0.13u
XNB_n415 m_n415 n348 gn1 gn1 sg13_lv_nmos w=0.74u l=0.13u
CL_n415 n415 gn1 2f
XPA_n416 n416 n342 ph1 ph1 sg13_lv_pmos w=1.12u l=0.13u
XPB_n416 n416 n345 ph1 ph1 sg13_lv_pmos w=1.12u l=0.13u
XNA_n416 n416 n342 m_n416 gn1 sg13_lv_nmos w=0.74u l=0.13u
XNB_n416 m_n416 n345 gn1 gn1 sg13_lv_nmos w=0.74u l=0.13u
CL_n416 n416 gn1 2f
XPA_n418 n418 n339 ph1 ph1 sg13_lv_pmos w=1.12u l=0.13u
XPB_n418 n418 n345 ph1 ph1 sg13_lv_pmos w=1.12u l=0.13u
XNA_n418 n418 n339 m_n418 gn1 sg13_lv_nmos w=0.74u l=0.13u
XNB_n418 m_n418 n345 gn1 gn1 sg13_lv_nmos w=0.74u l=0.13u
CL_n418 n418 gn1 2f
XPA_n419 n419 n342 ph1 ph1 sg13_lv_pmos w=1.12u l=0.13u
XPB_n419 n419 n348 ph1 ph1 sg13_lv_pmos w=1.12u l=0.13u
XNA_n419 n419 n342 m_n419 gn1 sg13_lv_nmos w=0.74u l=0.13u
XNB_n419 m_n419 n348 gn1 gn1 sg13_lv_nmos w=0.74u l=0.13u
CL_n419 n419 gn1 2f
XPA_n421 n421 n351 ph1 ph1 sg13_lv_pmos w=1.12u l=0.13u
XPB_n421 n421 n360 ph1 ph1 sg13_lv_pmos w=1.12u l=0.13u
XNA_n421 n421 n351 m_n421 gn1 sg13_lv_nmos w=0.74u l=0.13u
XNB_n421 m_n421 n360 gn1 gn1 sg13_lv_nmos w=0.74u l=0.13u
CL_n421 n421 gn1 2f
XPA_n422 n422 n354 ph1 ph1 sg13_lv_pmos w=1.12u l=0.13u
XPB_n422 n422 n357 ph1 ph1 sg13_lv_pmos w=1.12u l=0.13u
XNA_n422 n422 n354 m_n422 gn1 sg13_lv_nmos w=0.74u l=0.13u
XNB_n422 m_n422 n357 gn1 gn1 sg13_lv_nmos w=0.74u l=0.13u
CL_n422 n422 gn1 2f
XPA_n424 n424 n351 ph1 ph1 sg13_lv_pmos w=1.12u l=0.13u
XPB_n424 n424 n357 ph1 ph1 sg13_lv_pmos w=1.12u l=0.13u
XNA_n424 n424 n351 m_n424 gn1 sg13_lv_nmos w=0.74u l=0.13u
XNB_n424 m_n424 n357 gn1 gn1 sg13_lv_nmos w=0.74u l=0.13u
CL_n424 n424 gn1 2f
XPA_n425 n425 n354 ph1 ph1 sg13_lv_pmos w=1.12u l=0.13u
XPB_n425 n425 n360 ph1 ph1 sg13_lv_pmos w=1.12u l=0.13u
XNA_n425 n425 n354 m_n425 gn1 sg13_lv_nmos w=0.74u l=0.13u
XNB_n425 m_n425 n360 gn1 gn1 sg13_lv_nmos w=0.74u l=0.13u
CL_n425 n425 gn1 2f
XPA_n427 n427 n363 ph1 ph1 sg13_lv_pmos w=1.12u l=0.13u
XPB_n427 n427 n372 ph1 ph1 sg13_lv_pmos w=1.12u l=0.13u
XNA_n427 n427 n363 m_n427 gn1 sg13_lv_nmos w=0.74u l=0.13u
XNB_n427 m_n427 n372 gn1 gn1 sg13_lv_nmos w=0.74u l=0.13u
CL_n427 n427 gn1 2f
XPA_n428 n428 n366 ph1 ph1 sg13_lv_pmos w=1.12u l=0.13u
XPB_n428 n428 n369 ph1 ph1 sg13_lv_pmos w=1.12u l=0.13u
XNA_n428 n428 n366 m_n428 gn1 sg13_lv_nmos w=0.74u l=0.13u
XNB_n428 m_n428 n369 gn1 gn1 sg13_lv_nmos w=0.74u l=0.13u
CL_n428 n428 gn1 2f
XPA_n430 n430 n363 ph1 ph1 sg13_lv_pmos w=1.12u l=0.13u
XPB_n430 n430 n369 ph1 ph1 sg13_lv_pmos w=1.12u l=0.13u
XNA_n430 n430 n363 m_n430 gn1 sg13_lv_nmos w=0.74u l=0.13u
XNB_n430 m_n430 n369 gn1 gn1 sg13_lv_nmos w=0.74u l=0.13u
CL_n430 n430 gn1 2f
XPA_n431 n431 n366 ph1 ph1 sg13_lv_pmos w=1.12u l=0.13u
XPB_n431 n431 n372 ph1 ph1 sg13_lv_pmos w=1.12u l=0.13u
XNA_n431 n431 n366 m_n431 gn1 sg13_lv_nmos w=0.74u l=0.13u
XNB_n431 m_n431 n372 gn1 gn1 sg13_lv_nmos w=0.74u l=0.13u
CL_n431 n431 gn1 2f
XPA_n433 n433 n375 ph1 ph1 sg13_lv_pmos w=1.12u l=0.13u
XPB_n433 n433 n384 ph1 ph1 sg13_lv_pmos w=1.12u l=0.13u
XNA_n433 n433 n375 m_n433 gn1 sg13_lv_nmos w=0.74u l=0.13u
XNB_n433 m_n433 n384 gn1 gn1 sg13_lv_nmos w=0.74u l=0.13u
CL_n433 n433 gn1 2f
XPA_n434 n434 n378 ph1 ph1 sg13_lv_pmos w=1.12u l=0.13u
XPB_n434 n434 n381 ph1 ph1 sg13_lv_pmos w=1.12u l=0.13u
XNA_n434 n434 n378 m_n434 gn1 sg13_lv_nmos w=0.74u l=0.13u
XNB_n434 m_n434 n381 gn1 gn1 sg13_lv_nmos w=0.74u l=0.13u
CL_n434 n434 gn1 2f
XPA_n436 n436 n375 ph1 ph1 sg13_lv_pmos w=1.12u l=0.13u
XPB_n436 n436 n381 ph1 ph1 sg13_lv_pmos w=1.12u l=0.13u
XNA_n436 n436 n375 m_n436 gn1 sg13_lv_nmos w=0.74u l=0.13u
XNB_n436 m_n436 n381 gn1 gn1 sg13_lv_nmos w=0.74u l=0.13u
CL_n436 n436 gn1 2f
XPA_n437 n437 n378 ph1 ph1 sg13_lv_pmos w=1.12u l=0.13u
XPB_n437 n437 n384 ph1 ph1 sg13_lv_pmos w=1.12u l=0.13u
XNA_n437 n437 n378 m_n437 gn1 sg13_lv_nmos w=0.74u l=0.13u
XNB_n437 m_n437 n384 gn1 gn1 sg13_lv_nmos w=0.74u l=0.13u
CL_n437 n437 gn1 2f
XPA_n439 n439 n387 ph1 ph1 sg13_lv_pmos w=1.12u l=0.13u
XPB_n439 n439 n396 ph1 ph1 sg13_lv_pmos w=1.12u l=0.13u
XNA_n439 n439 n387 m_n439 gn1 sg13_lv_nmos w=0.74u l=0.13u
XNB_n439 m_n439 n396 gn1 gn1 sg13_lv_nmos w=0.74u l=0.13u
CL_n439 n439 gn1 2f
XPA_n440 n440 n390 ph1 ph1 sg13_lv_pmos w=1.12u l=0.13u
XPB_n440 n440 n393 ph1 ph1 sg13_lv_pmos w=1.12u l=0.13u
XNA_n440 n440 n390 m_n440 gn1 sg13_lv_nmos w=0.74u l=0.13u
XNB_n440 m_n440 n393 gn1 gn1 sg13_lv_nmos w=0.74u l=0.13u
CL_n440 n440 gn1 2f
XPA_n442 n442 n387 ph1 ph1 sg13_lv_pmos w=1.12u l=0.13u
XPB_n442 n442 n393 ph1 ph1 sg13_lv_pmos w=1.12u l=0.13u
XNA_n442 n442 n387 m_n442 gn1 sg13_lv_nmos w=0.74u l=0.13u
XNB_n442 m_n442 n393 gn1 gn1 sg13_lv_nmos w=0.74u l=0.13u
CL_n442 n442 gn1 2f
XPA_n443 n443 n390 ph1 ph1 sg13_lv_pmos w=1.12u l=0.13u
XPB_n443 n443 n396 ph1 ph1 sg13_lv_pmos w=1.12u l=0.13u
XNA_n443 n443 n390 m_n443 gn1 sg13_lv_nmos w=0.74u l=0.13u
XNB_n443 m_n443 n396 gn1 gn1 sg13_lv_nmos w=0.74u l=0.13u
CL_n443 n443 gn1 2f
XPA_n571 n571 n489 ph1 ph1 sg13_lv_pmos w=1.12u l=0.13u
XPB_n571 n571 n498 ph1 ph1 sg13_lv_pmos w=1.12u l=0.13u
XNA_n571 n571 n489 m_n571 gn1 sg13_lv_nmos w=0.74u l=0.13u
XNB_n571 m_n571 n498 gn1 gn1 sg13_lv_nmos w=0.74u l=0.13u
CL_n571 n571 gn1 2f
XPA_n572 n572 n492 ph1 ph1 sg13_lv_pmos w=1.12u l=0.13u
XPB_n572 n572 n495 ph1 ph1 sg13_lv_pmos w=1.12u l=0.13u
XNA_n572 n572 n492 m_n572 gn1 sg13_lv_nmos w=0.74u l=0.13u
XNB_n572 m_n572 n495 gn1 gn1 sg13_lv_nmos w=0.74u l=0.13u
CL_n572 n572 gn1 2f
XPA_n574 n574 n489 ph1 ph1 sg13_lv_pmos w=1.12u l=0.13u
XPB_n574 n574 n495 ph1 ph1 sg13_lv_pmos w=1.12u l=0.13u
XNA_n574 n574 n489 m_n574 gn1 sg13_lv_nmos w=0.74u l=0.13u
XNB_n574 m_n574 n495 gn1 gn1 sg13_lv_nmos w=0.74u l=0.13u
CL_n574 n574 gn1 2f
XPA_n575 n575 n492 ph1 ph1 sg13_lv_pmos w=1.12u l=0.13u
XPB_n575 n575 n498 ph1 ph1 sg13_lv_pmos w=1.12u l=0.13u
XNA_n575 n575 n492 m_n575 gn1 sg13_lv_nmos w=0.74u l=0.13u
XNB_n575 m_n575 n498 gn1 gn1 sg13_lv_nmos w=0.74u l=0.13u
CL_n575 n575 gn1 2f
XPA_n577 n577 n501 ph1 ph1 sg13_lv_pmos w=1.12u l=0.13u
XPB_n577 n577 n510 ph1 ph1 sg13_lv_pmos w=1.12u l=0.13u
XNA_n577 n577 n501 m_n577 gn1 sg13_lv_nmos w=0.74u l=0.13u
XNB_n577 m_n577 n510 gn1 gn1 sg13_lv_nmos w=0.74u l=0.13u
CL_n577 n577 gn1 2f
XPA_n578 n578 n504 ph1 ph1 sg13_lv_pmos w=1.12u l=0.13u
XPB_n578 n578 n507 ph1 ph1 sg13_lv_pmos w=1.12u l=0.13u
XNA_n578 n578 n504 m_n578 gn1 sg13_lv_nmos w=0.74u l=0.13u
XNB_n578 m_n578 n507 gn1 gn1 sg13_lv_nmos w=0.74u l=0.13u
CL_n578 n578 gn1 2f
XPA_n580 n580 n501 ph1 ph1 sg13_lv_pmos w=1.12u l=0.13u
XPB_n580 n580 n507 ph1 ph1 sg13_lv_pmos w=1.12u l=0.13u
XNA_n580 n580 n501 m_n580 gn1 sg13_lv_nmos w=0.74u l=0.13u
XNB_n580 m_n580 n507 gn1 gn1 sg13_lv_nmos w=0.74u l=0.13u
CL_n580 n580 gn1 2f
XPA_n581 n581 n504 ph1 ph1 sg13_lv_pmos w=1.12u l=0.13u
XPB_n581 n581 n510 ph1 ph1 sg13_lv_pmos w=1.12u l=0.13u
XNA_n581 n581 n504 m_n581 gn1 sg13_lv_nmos w=0.74u l=0.13u
XNB_n581 m_n581 n510 gn1 gn1 sg13_lv_nmos w=0.74u l=0.13u
CL_n581 n581 gn1 2f
XPA_n583 n583 n513 ph1 ph1 sg13_lv_pmos w=1.12u l=0.13u
XPB_n583 n583 n522 ph1 ph1 sg13_lv_pmos w=1.12u l=0.13u
XNA_n583 n583 n513 m_n583 gn1 sg13_lv_nmos w=0.74u l=0.13u
XNB_n583 m_n583 n522 gn1 gn1 sg13_lv_nmos w=0.74u l=0.13u
CL_n583 n583 gn1 2f
XPA_n584 n584 n516 ph1 ph1 sg13_lv_pmos w=1.12u l=0.13u
XPB_n584 n584 n519 ph1 ph1 sg13_lv_pmos w=1.12u l=0.13u
XNA_n584 n584 n516 m_n584 gn1 sg13_lv_nmos w=0.74u l=0.13u
XNB_n584 m_n584 n519 gn1 gn1 sg13_lv_nmos w=0.74u l=0.13u
CL_n584 n584 gn1 2f
XPA_n586 n586 n513 ph1 ph1 sg13_lv_pmos w=1.12u l=0.13u
XPB_n586 n586 n519 ph1 ph1 sg13_lv_pmos w=1.12u l=0.13u
XNA_n586 n586 n513 m_n586 gn1 sg13_lv_nmos w=0.74u l=0.13u
XNB_n586 m_n586 n519 gn1 gn1 sg13_lv_nmos w=0.74u l=0.13u
CL_n586 n586 gn1 2f
XPA_n587 n587 n516 ph1 ph1 sg13_lv_pmos w=1.12u l=0.13u
XPB_n587 n587 n522 ph1 ph1 sg13_lv_pmos w=1.12u l=0.13u
XNA_n587 n587 n516 m_n587 gn1 sg13_lv_nmos w=0.74u l=0.13u
XNB_n587 m_n587 n522 gn1 gn1 sg13_lv_nmos w=0.74u l=0.13u
CL_n587 n587 gn1 2f
XPA_n589 n589 n525 ph1 ph1 sg13_lv_pmos w=1.12u l=0.13u
XPB_n589 n589 n534 ph1 ph1 sg13_lv_pmos w=1.12u l=0.13u
XNA_n589 n589 n525 m_n589 gn1 sg13_lv_nmos w=0.74u l=0.13u
XNB_n589 m_n589 n534 gn1 gn1 sg13_lv_nmos w=0.74u l=0.13u
CL_n589 n589 gn1 2f
XPA_n590 n590 n528 ph1 ph1 sg13_lv_pmos w=1.12u l=0.13u
XPB_n590 n590 n531 ph1 ph1 sg13_lv_pmos w=1.12u l=0.13u
XNA_n590 n590 n528 m_n590 gn1 sg13_lv_nmos w=0.74u l=0.13u
XNB_n590 m_n590 n531 gn1 gn1 sg13_lv_nmos w=0.74u l=0.13u
CL_n590 n590 gn1 2f
XPA_n592 n592 n525 ph1 ph1 sg13_lv_pmos w=1.12u l=0.13u
XPB_n592 n592 n531 ph1 ph1 sg13_lv_pmos w=1.12u l=0.13u
XNA_n592 n592 n525 m_n592 gn1 sg13_lv_nmos w=0.74u l=0.13u
XNB_n592 m_n592 n531 gn1 gn1 sg13_lv_nmos w=0.74u l=0.13u
CL_n592 n592 gn1 2f
XPA_n593 n593 n528 ph1 ph1 sg13_lv_pmos w=1.12u l=0.13u
XPB_n593 n593 n534 ph1 ph1 sg13_lv_pmos w=1.12u l=0.13u
XNA_n593 n593 n528 m_n593 gn1 sg13_lv_nmos w=0.74u l=0.13u
XNB_n593 m_n593 n534 gn1 gn1 sg13_lv_nmos w=0.74u l=0.13u
CL_n593 n593 gn1 2f
XPA_n595 n595 n537 ph1 ph1 sg13_lv_pmos w=1.12u l=0.13u
XPB_n595 n595 n546 ph1 ph1 sg13_lv_pmos w=1.12u l=0.13u
XNA_n595 n595 n537 m_n595 gn1 sg13_lv_nmos w=0.74u l=0.13u
XNB_n595 m_n595 n546 gn1 gn1 sg13_lv_nmos w=0.74u l=0.13u
CL_n595 n595 gn1 2f
XPA_n596 n596 n540 ph1 ph1 sg13_lv_pmos w=1.12u l=0.13u
XPB_n596 n596 n543 ph1 ph1 sg13_lv_pmos w=1.12u l=0.13u
XNA_n596 n596 n540 m_n596 gn1 sg13_lv_nmos w=0.74u l=0.13u
XNB_n596 m_n596 n543 gn1 gn1 sg13_lv_nmos w=0.74u l=0.13u
CL_n596 n596 gn1 2f
XPA_n598 n598 n537 ph1 ph1 sg13_lv_pmos w=1.12u l=0.13u
XPB_n598 n598 n543 ph1 ph1 sg13_lv_pmos w=1.12u l=0.13u
XNA_n598 n598 n537 m_n598 gn1 sg13_lv_nmos w=0.74u l=0.13u
XNB_n598 m_n598 n543 gn1 gn1 sg13_lv_nmos w=0.74u l=0.13u
CL_n598 n598 gn1 2f
XPA_n599 n599 n540 ph1 ph1 sg13_lv_pmos w=1.12u l=0.13u
XPB_n599 n599 n546 ph1 ph1 sg13_lv_pmos w=1.12u l=0.13u
XNA_n599 n599 n540 m_n599 gn1 sg13_lv_nmos w=0.74u l=0.13u
XNB_n599 m_n599 n546 gn1 gn1 sg13_lv_nmos w=0.74u l=0.13u
CL_n599 n599 gn1 2f
XPA_n601 n601 n549 ph1 ph1 sg13_lv_pmos w=1.12u l=0.13u
XPB_n601 n601 n558 ph1 ph1 sg13_lv_pmos w=1.12u l=0.13u
XNA_n601 n601 n549 m_n601 gn1 sg13_lv_nmos w=0.74u l=0.13u
XNB_n601 m_n601 n558 gn1 gn1 sg13_lv_nmos w=0.74u l=0.13u
CL_n601 n601 gn1 2f
XPA_n602 n602 n552 ph1 ph1 sg13_lv_pmos w=1.12u l=0.13u
XPB_n602 n602 n555 ph1 ph1 sg13_lv_pmos w=1.12u l=0.13u
XNA_n602 n602 n552 m_n602 gn1 sg13_lv_nmos w=0.74u l=0.13u
XNB_n602 m_n602 n555 gn1 gn1 sg13_lv_nmos w=0.74u l=0.13u
CL_n602 n602 gn1 2f
XPA_n604 n604 n549 ph1 ph1 sg13_lv_pmos w=1.12u l=0.13u
XPB_n604 n604 n555 ph1 ph1 sg13_lv_pmos w=1.12u l=0.13u
XNA_n604 n604 n549 m_n604 gn1 sg13_lv_nmos w=0.74u l=0.13u
XNB_n604 m_n604 n555 gn1 gn1 sg13_lv_nmos w=0.74u l=0.13u
CL_n604 n604 gn1 2f
XPA_n605 n605 n552 ph1 ph1 sg13_lv_pmos w=1.12u l=0.13u
XPB_n605 n605 n558 ph1 ph1 sg13_lv_pmos w=1.12u l=0.13u
XNA_n605 n605 n552 m_n605 gn1 sg13_lv_nmos w=0.74u l=0.13u
XNB_n605 m_n605 n558 gn1 gn1 sg13_lv_nmos w=0.74u l=0.13u
CL_n605 n605 gn1 2f
XPA_n607 n607 n561 ph1 ph1 sg13_lv_pmos w=1.12u l=0.13u
XPB_n607 n607 n570 ph1 ph1 sg13_lv_pmos w=1.12u l=0.13u
XNA_n607 n607 n561 m_n607 gn1 sg13_lv_nmos w=0.74u l=0.13u
XNB_n607 m_n607 n570 gn1 gn1 sg13_lv_nmos w=0.74u l=0.13u
CL_n607 n607 gn1 2f
XPA_n608 n608 n564 ph1 ph1 sg13_lv_pmos w=1.12u l=0.13u
XPB_n608 n608 n567 ph1 ph1 sg13_lv_pmos w=1.12u l=0.13u
XNA_n608 n608 n564 m_n608 gn1 sg13_lv_nmos w=0.74u l=0.13u
XNB_n608 m_n608 n567 gn1 gn1 sg13_lv_nmos w=0.74u l=0.13u
CL_n608 n608 gn1 2f
XPA_n61 n61 n3 ph1 ph1 sg13_lv_pmos w=1.12u l=0.13u
XPB_n61 n61 n12 ph1 ph1 sg13_lv_pmos w=1.12u l=0.13u
XNA_n61 n61 n3 m_n61 gn1 sg13_lv_nmos w=0.74u l=0.13u
XNB_n61 m_n61 n12 gn1 gn1 sg13_lv_nmos w=0.74u l=0.13u
CL_n61 n61 gn1 2f
XPA_n610 n610 n561 ph1 ph1 sg13_lv_pmos w=1.12u l=0.13u
XPB_n610 n610 n567 ph1 ph1 sg13_lv_pmos w=1.12u l=0.13u
XNA_n610 n610 n561 m_n610 gn1 sg13_lv_nmos w=0.74u l=0.13u
XNB_n610 m_n610 n567 gn1 gn1 sg13_lv_nmos w=0.74u l=0.13u
CL_n610 n610 gn1 2f
XPA_n611 n611 n564 ph1 ph1 sg13_lv_pmos w=1.12u l=0.13u
XPB_n611 n611 n570 ph1 ph1 sg13_lv_pmos w=1.12u l=0.13u
XNA_n611 n611 n564 m_n611 gn1 sg13_lv_nmos w=0.74u l=0.13u
XNB_n611 m_n611 n570 gn1 gn1 sg13_lv_nmos w=0.74u l=0.13u
CL_n611 n611 gn1 2f
XPA_n62 n62 n6 ph1 ph1 sg13_lv_pmos w=1.12u l=0.13u
XPB_n62 n62 n9 ph1 ph1 sg13_lv_pmos w=1.12u l=0.13u
XNA_n62 n62 n6 m_n62 gn1 sg13_lv_nmos w=0.74u l=0.13u
XNB_n62 m_n62 n9 gn1 gn1 sg13_lv_nmos w=0.74u l=0.13u
CL_n62 n62 gn1 2f
XPA_n64 n64 n3 ph1 ph1 sg13_lv_pmos w=1.12u l=0.13u
XPB_n64 n64 n9 ph1 ph1 sg13_lv_pmos w=1.12u l=0.13u
XNA_n64 n64 n3 m_n64 gn1 sg13_lv_nmos w=0.74u l=0.13u
XNB_n64 m_n64 n9 gn1 gn1 sg13_lv_nmos w=0.74u l=0.13u
CL_n64 n64 gn1 2f
XPA_n65 n65 n6 ph1 ph1 sg13_lv_pmos w=1.12u l=0.13u
XPB_n65 n65 n12 ph1 ph1 sg13_lv_pmos w=1.12u l=0.13u
XNA_n65 n65 n6 m_n65 gn1 sg13_lv_nmos w=0.74u l=0.13u
XNB_n65 m_n65 n12 gn1 gn1 sg13_lv_nmos w=0.74u l=0.13u
CL_n65 n65 gn1 2f
XPA_n67 n67 n15 ph1 ph1 sg13_lv_pmos w=1.12u l=0.13u
XPB_n67 n67 n24 ph1 ph1 sg13_lv_pmos w=1.12u l=0.13u
XNA_n67 n67 n15 m_n67 gn1 sg13_lv_nmos w=0.74u l=0.13u
XNB_n67 m_n67 n24 gn1 gn1 sg13_lv_nmos w=0.74u l=0.13u
CL_n67 n67 gn1 2f
XPA_n673 n673 n663 ph1 ph1 sg13_lv_pmos w=1.12u l=0.13u
XPB_n673 n673 n672 ph1 ph1 sg13_lv_pmos w=1.12u l=0.13u
XNA_n673 n673 n663 m_n673 gn1 sg13_lv_nmos w=0.74u l=0.13u
XNB_n673 m_n673 n672 gn1 gn1 sg13_lv_nmos w=0.74u l=0.13u
CL_n673 n673 gn1 2f
XPA_n674 n674 n666 ph1 ph1 sg13_lv_pmos w=1.12u l=0.13u
XPB_n674 n674 n669 ph1 ph1 sg13_lv_pmos w=1.12u l=0.13u
XNA_n674 n674 n666 m_n674 gn1 sg13_lv_nmos w=0.74u l=0.13u
XNB_n674 m_n674 n669 gn1 gn1 sg13_lv_nmos w=0.74u l=0.13u
CL_n674 n674 gn1 2f
XPA_n676 n676 n663 ph1 ph1 sg13_lv_pmos w=1.12u l=0.13u
XPB_n676 n676 n669 ph1 ph1 sg13_lv_pmos w=1.12u l=0.13u
XNA_n676 n676 n663 m_n676 gn1 sg13_lv_nmos w=0.74u l=0.13u
XNB_n676 m_n676 n669 gn1 gn1 sg13_lv_nmos w=0.74u l=0.13u
CL_n676 n676 gn1 2f
XPA_n677 n677 n666 ph1 ph1 sg13_lv_pmos w=1.12u l=0.13u
XPB_n677 n677 n672 ph1 ph1 sg13_lv_pmos w=1.12u l=0.13u
XNA_n677 n677 n666 m_n677 gn1 sg13_lv_nmos w=0.74u l=0.13u
XNB_n677 m_n677 n672 gn1 gn1 sg13_lv_nmos w=0.74u l=0.13u
CL_n677 n677 gn1 2f
XPA_n68 n68 n18 ph1 ph1 sg13_lv_pmos w=1.12u l=0.13u
XPB_n68 n68 n21 ph1 ph1 sg13_lv_pmos w=1.12u l=0.13u
XNA_n68 n68 n18 m_n68 gn1 sg13_lv_nmos w=0.74u l=0.13u
XNB_n68 m_n68 n21 gn1 gn1 sg13_lv_nmos w=0.74u l=0.13u
CL_n68 n68 gn1 2f
XPA_n70 n70 n15 ph1 ph1 sg13_lv_pmos w=1.12u l=0.13u
XPB_n70 n70 n21 ph1 ph1 sg13_lv_pmos w=1.12u l=0.13u
XNA_n70 n70 n15 m_n70 gn1 sg13_lv_nmos w=0.74u l=0.13u
XNB_n70 m_n70 n21 gn1 gn1 sg13_lv_nmos w=0.74u l=0.13u
CL_n70 n70 gn1 2f
XPA_n71 n71 n18 ph1 ph1 sg13_lv_pmos w=1.12u l=0.13u
XPB_n71 n71 n24 ph1 ph1 sg13_lv_pmos w=1.12u l=0.13u
XNA_n71 n71 n18 m_n71 gn1 sg13_lv_nmos w=0.74u l=0.13u
XNB_n71 m_n71 n24 gn1 gn1 sg13_lv_nmos w=0.74u l=0.13u
CL_n71 n71 gn1 2f
XPA_n73 n73 n27 ph1 ph1 sg13_lv_pmos w=1.12u l=0.13u
XPB_n73 n73 n36 ph1 ph1 sg13_lv_pmos w=1.12u l=0.13u
XNA_n73 n73 n27 m_n73 gn1 sg13_lv_nmos w=0.74u l=0.13u
XNB_n73 m_n73 n36 gn1 gn1 sg13_lv_nmos w=0.74u l=0.13u
CL_n73 n73 gn1 2f
XPA_n74 n74 n30 ph1 ph1 sg13_lv_pmos w=1.12u l=0.13u
XPB_n74 n74 n33 ph1 ph1 sg13_lv_pmos w=1.12u l=0.13u
XNA_n74 n74 n30 m_n74 gn1 sg13_lv_nmos w=0.74u l=0.13u
XNB_n74 m_n74 n33 gn1 gn1 sg13_lv_nmos w=0.74u l=0.13u
CL_n74 n74 gn1 2f
XPA_n76 n76 n27 ph1 ph1 sg13_lv_pmos w=1.12u l=0.13u
XPB_n76 n76 n33 ph1 ph1 sg13_lv_pmos w=1.12u l=0.13u
XNA_n76 n76 n27 m_n76 gn1 sg13_lv_nmos w=0.74u l=0.13u
XNB_n76 m_n76 n33 gn1 gn1 sg13_lv_nmos w=0.74u l=0.13u
CL_n76 n76 gn1 2f
XPA_n77 n77 n30 ph1 ph1 sg13_lv_pmos w=1.12u l=0.13u
XPB_n77 n77 n36 ph1 ph1 sg13_lv_pmos w=1.12u l=0.13u
XNA_n77 n77 n30 m_n77 gn1 sg13_lv_nmos w=0.74u l=0.13u
XNB_n77 m_n77 n36 gn1 gn1 sg13_lv_nmos w=0.74u l=0.13u
CL_n77 n77 gn1 2f
XPA_n775 n775 n687 ph1 ph1 sg13_lv_pmos w=1.12u l=0.13u
XPB_n775 n775 n696 ph1 ph1 sg13_lv_pmos w=1.12u l=0.13u
XNA_n775 n775 n687 m_n775 gn1 sg13_lv_nmos w=0.74u l=0.13u
XNB_n775 m_n775 n696 gn1 gn1 sg13_lv_nmos w=0.74u l=0.13u
CL_n775 n775 gn1 2f
XPA_n776 n776 n690 ph1 ph1 sg13_lv_pmos w=1.12u l=0.13u
XPB_n776 n776 n693 ph1 ph1 sg13_lv_pmos w=1.12u l=0.13u
XNA_n776 n776 n690 m_n776 gn1 sg13_lv_nmos w=0.74u l=0.13u
XNB_n776 m_n776 n693 gn1 gn1 sg13_lv_nmos w=0.74u l=0.13u
CL_n776 n776 gn1 2f
XPA_n778 n778 n687 ph1 ph1 sg13_lv_pmos w=1.12u l=0.13u
XPB_n778 n778 n693 ph1 ph1 sg13_lv_pmos w=1.12u l=0.13u
XNA_n778 n778 n687 m_n778 gn1 sg13_lv_nmos w=0.74u l=0.13u
XNB_n778 m_n778 n693 gn1 gn1 sg13_lv_nmos w=0.74u l=0.13u
CL_n778 n778 gn1 2f
XPA_n779 n779 n690 ph1 ph1 sg13_lv_pmos w=1.12u l=0.13u
XPB_n779 n779 n696 ph1 ph1 sg13_lv_pmos w=1.12u l=0.13u
XNA_n779 n779 n690 m_n779 gn1 sg13_lv_nmos w=0.74u l=0.13u
XNB_n779 m_n779 n696 gn1 gn1 sg13_lv_nmos w=0.74u l=0.13u
CL_n779 n779 gn1 2f
XPA_n781 n781 n699 ph1 ph1 sg13_lv_pmos w=1.12u l=0.13u
XPB_n781 n781 n708 ph1 ph1 sg13_lv_pmos w=1.12u l=0.13u
XNA_n781 n781 n699 m_n781 gn1 sg13_lv_nmos w=0.74u l=0.13u
XNB_n781 m_n781 n708 gn1 gn1 sg13_lv_nmos w=0.74u l=0.13u
CL_n781 n781 gn1 2f
XPA_n782 n782 n702 ph1 ph1 sg13_lv_pmos w=1.12u l=0.13u
XPB_n782 n782 n705 ph1 ph1 sg13_lv_pmos w=1.12u l=0.13u
XNA_n782 n782 n702 m_n782 gn1 sg13_lv_nmos w=0.74u l=0.13u
XNB_n782 m_n782 n705 gn1 gn1 sg13_lv_nmos w=0.74u l=0.13u
CL_n782 n782 gn1 2f
XPA_n784 n784 n699 ph1 ph1 sg13_lv_pmos w=1.12u l=0.13u
XPB_n784 n784 n705 ph1 ph1 sg13_lv_pmos w=1.12u l=0.13u
XNA_n784 n784 n699 m_n784 gn1 sg13_lv_nmos w=0.74u l=0.13u
XNB_n784 m_n784 n705 gn1 gn1 sg13_lv_nmos w=0.74u l=0.13u
CL_n784 n784 gn1 2f
XPA_n785 n785 n702 ph1 ph1 sg13_lv_pmos w=1.12u l=0.13u
XPB_n785 n785 n708 ph1 ph1 sg13_lv_pmos w=1.12u l=0.13u
XNA_n785 n785 n702 m_n785 gn1 sg13_lv_nmos w=0.74u l=0.13u
XNB_n785 m_n785 n708 gn1 gn1 sg13_lv_nmos w=0.74u l=0.13u
CL_n785 n785 gn1 2f
XPA_n787 n787 n711 ph1 ph1 sg13_lv_pmos w=1.12u l=0.13u
XPB_n787 n787 n720 ph1 ph1 sg13_lv_pmos w=1.12u l=0.13u
XNA_n787 n787 n711 m_n787 gn1 sg13_lv_nmos w=0.74u l=0.13u
XNB_n787 m_n787 n720 gn1 gn1 sg13_lv_nmos w=0.74u l=0.13u
CL_n787 n787 gn1 2f
XPA_n788 n788 n714 ph1 ph1 sg13_lv_pmos w=1.12u l=0.13u
XPB_n788 n788 n717 ph1 ph1 sg13_lv_pmos w=1.12u l=0.13u
XNA_n788 n788 n714 m_n788 gn1 sg13_lv_nmos w=0.74u l=0.13u
XNB_n788 m_n788 n717 gn1 gn1 sg13_lv_nmos w=0.74u l=0.13u
CL_n788 n788 gn1 2f
XPA_n79 n79 n39 ph1 ph1 sg13_lv_pmos w=1.12u l=0.13u
XPB_n79 n79 n48 ph1 ph1 sg13_lv_pmos w=1.12u l=0.13u
XNA_n79 n79 n39 m_n79 gn1 sg13_lv_nmos w=0.74u l=0.13u
XNB_n79 m_n79 n48 gn1 gn1 sg13_lv_nmos w=0.74u l=0.13u
CL_n79 n79 gn1 2f
XPA_n790 n790 n711 ph1 ph1 sg13_lv_pmos w=1.12u l=0.13u
XPB_n790 n790 n717 ph1 ph1 sg13_lv_pmos w=1.12u l=0.13u
XNA_n790 n790 n711 m_n790 gn1 sg13_lv_nmos w=0.74u l=0.13u
XNB_n790 m_n790 n717 gn1 gn1 sg13_lv_nmos w=0.74u l=0.13u
CL_n790 n790 gn1 2f
XPA_n791 n791 n714 ph1 ph1 sg13_lv_pmos w=1.12u l=0.13u
XPB_n791 n791 n720 ph1 ph1 sg13_lv_pmos w=1.12u l=0.13u
XNA_n791 n791 n714 m_n791 gn1 sg13_lv_nmos w=0.74u l=0.13u
XNB_n791 m_n791 n720 gn1 gn1 sg13_lv_nmos w=0.74u l=0.13u
CL_n791 n791 gn1 2f
XPA_n793 n793 n723 ph1 ph1 sg13_lv_pmos w=1.12u l=0.13u
XPB_n793 n793 n732 ph1 ph1 sg13_lv_pmos w=1.12u l=0.13u
XNA_n793 n793 n723 m_n793 gn1 sg13_lv_nmos w=0.74u l=0.13u
XNB_n793 m_n793 n732 gn1 gn1 sg13_lv_nmos w=0.74u l=0.13u
CL_n793 n793 gn1 2f
XPA_n794 n794 n726 ph1 ph1 sg13_lv_pmos w=1.12u l=0.13u
XPB_n794 n794 n729 ph1 ph1 sg13_lv_pmos w=1.12u l=0.13u
XNA_n794 n794 n726 m_n794 gn1 sg13_lv_nmos w=0.74u l=0.13u
XNB_n794 m_n794 n729 gn1 gn1 sg13_lv_nmos w=0.74u l=0.13u
CL_n794 n794 gn1 2f
XPA_n796 n796 n723 ph1 ph1 sg13_lv_pmos w=1.12u l=0.13u
XPB_n796 n796 n729 ph1 ph1 sg13_lv_pmos w=1.12u l=0.13u
XNA_n796 n796 n723 m_n796 gn1 sg13_lv_nmos w=0.74u l=0.13u
XNB_n796 m_n796 n729 gn1 gn1 sg13_lv_nmos w=0.74u l=0.13u
CL_n796 n796 gn1 2f
XPA_n797 n797 n726 ph1 ph1 sg13_lv_pmos w=1.12u l=0.13u
XPB_n797 n797 n732 ph1 ph1 sg13_lv_pmos w=1.12u l=0.13u
XNA_n797 n797 n726 m_n797 gn1 sg13_lv_nmos w=0.74u l=0.13u
XNB_n797 m_n797 n732 gn1 gn1 sg13_lv_nmos w=0.74u l=0.13u
CL_n797 n797 gn1 2f
XPA_n799 n799 n735 ph1 ph1 sg13_lv_pmos w=1.12u l=0.13u
XPB_n799 n799 n744 ph1 ph1 sg13_lv_pmos w=1.12u l=0.13u
XNA_n799 n799 n735 m_n799 gn1 sg13_lv_nmos w=0.74u l=0.13u
XNB_n799 m_n799 n744 gn1 gn1 sg13_lv_nmos w=0.74u l=0.13u
CL_n799 n799 gn1 2f
XPA_n80 n80 n42 ph1 ph1 sg13_lv_pmos w=1.12u l=0.13u
XPB_n80 n80 n45 ph1 ph1 sg13_lv_pmos w=1.12u l=0.13u
XNA_n80 n80 n42 m_n80 gn1 sg13_lv_nmos w=0.74u l=0.13u
XNB_n80 m_n80 n45 gn1 gn1 sg13_lv_nmos w=0.74u l=0.13u
CL_n80 n80 gn1 2f
XPA_n800 n800 n738 ph1 ph1 sg13_lv_pmos w=1.12u l=0.13u
XPB_n800 n800 n741 ph1 ph1 sg13_lv_pmos w=1.12u l=0.13u
XNA_n800 n800 n738 m_n800 gn1 sg13_lv_nmos w=0.74u l=0.13u
XNB_n800 m_n800 n741 gn1 gn1 sg13_lv_nmos w=0.74u l=0.13u
CL_n800 n800 gn1 2f
XPA_n802 n802 n735 ph1 ph1 sg13_lv_pmos w=1.12u l=0.13u
XPB_n802 n802 n741 ph1 ph1 sg13_lv_pmos w=1.12u l=0.13u
XNA_n802 n802 n735 m_n802 gn1 sg13_lv_nmos w=0.74u l=0.13u
XNB_n802 m_n802 n741 gn1 gn1 sg13_lv_nmos w=0.74u l=0.13u
CL_n802 n802 gn1 2f
XPA_n803 n803 n738 ph1 ph1 sg13_lv_pmos w=1.12u l=0.13u
XPB_n803 n803 n744 ph1 ph1 sg13_lv_pmos w=1.12u l=0.13u
XNA_n803 n803 n738 m_n803 gn1 sg13_lv_nmos w=0.74u l=0.13u
XNB_n803 m_n803 n744 gn1 gn1 sg13_lv_nmos w=0.74u l=0.13u
CL_n803 n803 gn1 2f
XPA_n805 n805 n747 ph1 ph1 sg13_lv_pmos w=1.12u l=0.13u
XPB_n805 n805 n756 ph1 ph1 sg13_lv_pmos w=1.12u l=0.13u
XNA_n805 n805 n747 m_n805 gn1 sg13_lv_nmos w=0.74u l=0.13u
XNB_n805 m_n805 n756 gn1 gn1 sg13_lv_nmos w=0.74u l=0.13u
CL_n805 n805 gn1 2f
XPA_n806 n806 n750 ph1 ph1 sg13_lv_pmos w=1.12u l=0.13u
XPB_n806 n806 n753 ph1 ph1 sg13_lv_pmos w=1.12u l=0.13u
XNA_n806 n806 n750 m_n806 gn1 sg13_lv_nmos w=0.74u l=0.13u
XNB_n806 m_n806 n753 gn1 gn1 sg13_lv_nmos w=0.74u l=0.13u
CL_n806 n806 gn1 2f
XPA_n808 n808 n747 ph1 ph1 sg13_lv_pmos w=1.12u l=0.13u
XPB_n808 n808 n753 ph1 ph1 sg13_lv_pmos w=1.12u l=0.13u
XNA_n808 n808 n747 m_n808 gn1 sg13_lv_nmos w=0.74u l=0.13u
XNB_n808 m_n808 n753 gn1 gn1 sg13_lv_nmos w=0.74u l=0.13u
CL_n808 n808 gn1 2f
XPA_n809 n809 n750 ph1 ph1 sg13_lv_pmos w=1.12u l=0.13u
XPB_n809 n809 n756 ph1 ph1 sg13_lv_pmos w=1.12u l=0.13u
XNA_n809 n809 n750 m_n809 gn1 sg13_lv_nmos w=0.74u l=0.13u
XNB_n809 m_n809 n756 gn1 gn1 sg13_lv_nmos w=0.74u l=0.13u
CL_n809 n809 gn1 2f
XPA_n811 n811 n759 ph1 ph1 sg13_lv_pmos w=1.12u l=0.13u
XPB_n811 n811 n768 ph1 ph1 sg13_lv_pmos w=1.12u l=0.13u
XNA_n811 n811 n759 m_n811 gn1 sg13_lv_nmos w=0.74u l=0.13u
XNB_n811 m_n811 n768 gn1 gn1 sg13_lv_nmos w=0.74u l=0.13u
CL_n811 n811 gn1 2f
XPA_n812 n812 n762 ph1 ph1 sg13_lv_pmos w=1.12u l=0.13u
XPB_n812 n812 n765 ph1 ph1 sg13_lv_pmos w=1.12u l=0.13u
XNA_n812 n812 n762 m_n812 gn1 sg13_lv_nmos w=0.74u l=0.13u
XNB_n812 m_n812 n765 gn1 gn1 sg13_lv_nmos w=0.74u l=0.13u
CL_n812 n812 gn1 2f
XPA_n814 n814 n759 ph1 ph1 sg13_lv_pmos w=1.12u l=0.13u
XPB_n814 n814 n765 ph1 ph1 sg13_lv_pmos w=1.12u l=0.13u
XNA_n814 n814 n759 m_n814 gn1 sg13_lv_nmos w=0.74u l=0.13u
XNB_n814 m_n814 n765 gn1 gn1 sg13_lv_nmos w=0.74u l=0.13u
CL_n814 n814 gn1 2f
XPA_n815 n815 n762 ph1 ph1 sg13_lv_pmos w=1.12u l=0.13u
XPB_n815 n815 n768 ph1 ph1 sg13_lv_pmos w=1.12u l=0.13u
XNA_n815 n815 n762 m_n815 gn1 sg13_lv_nmos w=0.74u l=0.13u
XNB_n815 m_n815 n768 gn1 gn1 sg13_lv_nmos w=0.74u l=0.13u
CL_n815 n815 gn1 2f
XPA_n82 n82 n39 ph1 ph1 sg13_lv_pmos w=1.12u l=0.13u
XPB_n82 n82 n45 ph1 ph1 sg13_lv_pmos w=1.12u l=0.13u
XNA_n82 n82 n39 m_n82 gn1 sg13_lv_nmos w=0.74u l=0.13u
XNB_n82 m_n82 n45 gn1 gn1 sg13_lv_nmos w=0.74u l=0.13u
CL_n82 n82 gn1 2f
XPA_n83 n83 n42 ph1 ph1 sg13_lv_pmos w=1.12u l=0.13u
XPB_n83 n83 n48 ph1 ph1 sg13_lv_pmos w=1.12u l=0.13u
XNA_n83 n83 n42 m_n83 gn1 sg13_lv_nmos w=0.74u l=0.13u
XNB_n83 m_n83 n48 gn1 gn1 sg13_lv_nmos w=0.74u l=0.13u
CL_n83 n83 gn1 2f
XPA_n85 n85 n51 ph1 ph1 sg13_lv_pmos w=1.12u l=0.13u
XPB_n85 n85 n60 ph1 ph1 sg13_lv_pmos w=1.12u l=0.13u
XNA_n85 n85 n51 m_n85 gn1 sg13_lv_nmos w=0.74u l=0.13u
XNB_n85 m_n85 n60 gn1 gn1 sg13_lv_nmos w=0.74u l=0.13u
CL_n85 n85 gn1 2f
XPA_n86 n86 n54 ph1 ph1 sg13_lv_pmos w=1.12u l=0.13u
XPB_n86 n86 n57 ph1 ph1 sg13_lv_pmos w=1.12u l=0.13u
XNA_n86 n86 n54 m_n86 gn1 sg13_lv_nmos w=0.74u l=0.13u
XNB_n86 m_n86 n57 gn1 gn1 sg13_lv_nmos w=0.74u l=0.13u
CL_n86 n86 gn1 2f
XPA_n88 n88 n51 ph1 ph1 sg13_lv_pmos w=1.12u l=0.13u
XPB_n88 n88 n57 ph1 ph1 sg13_lv_pmos w=1.12u l=0.13u
XNA_n88 n88 n51 m_n88 gn1 sg13_lv_nmos w=0.74u l=0.13u
XNB_n88 m_n88 n57 gn1 gn1 sg13_lv_nmos w=0.74u l=0.13u
CL_n88 n88 gn1 2f
XPA_n89 n89 n54 ph1 ph1 sg13_lv_pmos w=1.12u l=0.13u
XPB_n89 n89 n60 ph1 ph1 sg13_lv_pmos w=1.12u l=0.13u
XNA_n89 n89 n54 m_n89 gn1 sg13_lv_nmos w=0.74u l=0.13u
XNB_n89 m_n89 n60 gn1 gn1 sg13_lv_nmos w=0.74u l=0.13u
CL_n89 n89 gn1 2f
XPA_n943 n943 n861 ph1 ph1 sg13_lv_pmos w=1.12u l=0.13u
XPB_n943 n943 n870 ph1 ph1 sg13_lv_pmos w=1.12u l=0.13u
XNA_n943 n943 n861 m_n943 gn1 sg13_lv_nmos w=0.74u l=0.13u
XNB_n943 m_n943 n870 gn1 gn1 sg13_lv_nmos w=0.74u l=0.13u
CL_n943 n943 gn1 2f
XPA_n944 n944 n864 ph1 ph1 sg13_lv_pmos w=1.12u l=0.13u
XPB_n944 n944 n867 ph1 ph1 sg13_lv_pmos w=1.12u l=0.13u
XNA_n944 n944 n864 m_n944 gn1 sg13_lv_nmos w=0.74u l=0.13u
XNB_n944 m_n944 n867 gn1 gn1 sg13_lv_nmos w=0.74u l=0.13u
CL_n944 n944 gn1 2f
XPA_n946 n946 n861 ph1 ph1 sg13_lv_pmos w=1.12u l=0.13u
XPB_n946 n946 n867 ph1 ph1 sg13_lv_pmos w=1.12u l=0.13u
XNA_n946 n946 n861 m_n946 gn1 sg13_lv_nmos w=0.74u l=0.13u
XNB_n946 m_n946 n867 gn1 gn1 sg13_lv_nmos w=0.74u l=0.13u
CL_n946 n946 gn1 2f
XPA_n947 n947 n864 ph1 ph1 sg13_lv_pmos w=1.12u l=0.13u
XPB_n947 n947 n870 ph1 ph1 sg13_lv_pmos w=1.12u l=0.13u
XNA_n947 n947 n864 m_n947 gn1 sg13_lv_nmos w=0.74u l=0.13u
XNB_n947 m_n947 n870 gn1 gn1 sg13_lv_nmos w=0.74u l=0.13u
CL_n947 n947 gn1 2f
XPA_n949 n949 n873 ph1 ph1 sg13_lv_pmos w=1.12u l=0.13u
XPB_n949 n949 n882 ph1 ph1 sg13_lv_pmos w=1.12u l=0.13u
XNA_n949 n949 n873 m_n949 gn1 sg13_lv_nmos w=0.74u l=0.13u
XNB_n949 m_n949 n882 gn1 gn1 sg13_lv_nmos w=0.74u l=0.13u
CL_n949 n949 gn1 2f
XPA_n950 n950 n876 ph1 ph1 sg13_lv_pmos w=1.12u l=0.13u
XPB_n950 n950 n879 ph1 ph1 sg13_lv_pmos w=1.12u l=0.13u
XNA_n950 n950 n876 m_n950 gn1 sg13_lv_nmos w=0.74u l=0.13u
XNB_n950 m_n950 n879 gn1 gn1 sg13_lv_nmos w=0.74u l=0.13u
CL_n950 n950 gn1 2f
XPA_n952 n952 n873 ph1 ph1 sg13_lv_pmos w=1.12u l=0.13u
XPB_n952 n952 n879 ph1 ph1 sg13_lv_pmos w=1.12u l=0.13u
XNA_n952 n952 n873 m_n952 gn1 sg13_lv_nmos w=0.74u l=0.13u
XNB_n952 m_n952 n879 gn1 gn1 sg13_lv_nmos w=0.74u l=0.13u
CL_n952 n952 gn1 2f
XPA_n953 n953 n876 ph1 ph1 sg13_lv_pmos w=1.12u l=0.13u
XPB_n953 n953 n882 ph1 ph1 sg13_lv_pmos w=1.12u l=0.13u
XNA_n953 n953 n876 m_n953 gn1 sg13_lv_nmos w=0.74u l=0.13u
XNB_n953 m_n953 n882 gn1 gn1 sg13_lv_nmos w=0.74u l=0.13u
CL_n953 n953 gn1 2f
XPA_n955 n955 n885 ph1 ph1 sg13_lv_pmos w=1.12u l=0.13u
XPB_n955 n955 n894 ph1 ph1 sg13_lv_pmos w=1.12u l=0.13u
XNA_n955 n955 n885 m_n955 gn1 sg13_lv_nmos w=0.74u l=0.13u
XNB_n955 m_n955 n894 gn1 gn1 sg13_lv_nmos w=0.74u l=0.13u
CL_n955 n955 gn1 2f
XPA_n956 n956 n888 ph1 ph1 sg13_lv_pmos w=1.12u l=0.13u
XPB_n956 n956 n891 ph1 ph1 sg13_lv_pmos w=1.12u l=0.13u
XNA_n956 n956 n888 m_n956 gn1 sg13_lv_nmos w=0.74u l=0.13u
XNB_n956 m_n956 n891 gn1 gn1 sg13_lv_nmos w=0.74u l=0.13u
CL_n956 n956 gn1 2f
XPA_n958 n958 n885 ph1 ph1 sg13_lv_pmos w=1.12u l=0.13u
XPB_n958 n958 n891 ph1 ph1 sg13_lv_pmos w=1.12u l=0.13u
XNA_n958 n958 n885 m_n958 gn1 sg13_lv_nmos w=0.74u l=0.13u
XNB_n958 m_n958 n891 gn1 gn1 sg13_lv_nmos w=0.74u l=0.13u
CL_n958 n958 gn1 2f
XPA_n959 n959 n888 ph1 ph1 sg13_lv_pmos w=1.12u l=0.13u
XPB_n959 n959 n894 ph1 ph1 sg13_lv_pmos w=1.12u l=0.13u
XNA_n959 n959 n888 m_n959 gn1 sg13_lv_nmos w=0.74u l=0.13u
XNB_n959 m_n959 n894 gn1 gn1 sg13_lv_nmos w=0.74u l=0.13u
CL_n959 n959 gn1 2f
XPA_n961 n961 n897 ph1 ph1 sg13_lv_pmos w=1.12u l=0.13u
XPB_n961 n961 n906 ph1 ph1 sg13_lv_pmos w=1.12u l=0.13u
XNA_n961 n961 n897 m_n961 gn1 sg13_lv_nmos w=0.74u l=0.13u
XNB_n961 m_n961 n906 gn1 gn1 sg13_lv_nmos w=0.74u l=0.13u
CL_n961 n961 gn1 2f
XPA_n962 n962 n900 ph1 ph1 sg13_lv_pmos w=1.12u l=0.13u
XPB_n962 n962 n903 ph1 ph1 sg13_lv_pmos w=1.12u l=0.13u
XNA_n962 n962 n900 m_n962 gn1 sg13_lv_nmos w=0.74u l=0.13u
XNB_n962 m_n962 n903 gn1 gn1 sg13_lv_nmos w=0.74u l=0.13u
CL_n962 n962 gn1 2f
XPA_n964 n964 n897 ph1 ph1 sg13_lv_pmos w=1.12u l=0.13u
XPB_n964 n964 n903 ph1 ph1 sg13_lv_pmos w=1.12u l=0.13u
XNA_n964 n964 n897 m_n964 gn1 sg13_lv_nmos w=0.74u l=0.13u
XNB_n964 m_n964 n903 gn1 gn1 sg13_lv_nmos w=0.74u l=0.13u
CL_n964 n964 gn1 2f
XPA_n965 n965 n900 ph1 ph1 sg13_lv_pmos w=1.12u l=0.13u
XPB_n965 n965 n906 ph1 ph1 sg13_lv_pmos w=1.12u l=0.13u
XNA_n965 n965 n900 m_n965 gn1 sg13_lv_nmos w=0.74u l=0.13u
XNB_n965 m_n965 n906 gn1 gn1 sg13_lv_nmos w=0.74u l=0.13u
CL_n965 n965 gn1 2f
XPA_n967 n967 n909 ph1 ph1 sg13_lv_pmos w=1.12u l=0.13u
XPB_n967 n967 n918 ph1 ph1 sg13_lv_pmos w=1.12u l=0.13u
XNA_n967 n967 n909 m_n967 gn1 sg13_lv_nmos w=0.74u l=0.13u
XNB_n967 m_n967 n918 gn1 gn1 sg13_lv_nmos w=0.74u l=0.13u
CL_n967 n967 gn1 2f
XPA_n968 n968 n912 ph1 ph1 sg13_lv_pmos w=1.12u l=0.13u
XPB_n968 n968 n915 ph1 ph1 sg13_lv_pmos w=1.12u l=0.13u
XNA_n968 n968 n912 m_n968 gn1 sg13_lv_nmos w=0.74u l=0.13u
XNB_n968 m_n968 n915 gn1 gn1 sg13_lv_nmos w=0.74u l=0.13u
CL_n968 n968 gn1 2f
XPA_n970 n970 n909 ph1 ph1 sg13_lv_pmos w=1.12u l=0.13u
XPB_n970 n970 n915 ph1 ph1 sg13_lv_pmos w=1.12u l=0.13u
XNA_n970 n970 n909 m_n970 gn1 sg13_lv_nmos w=0.74u l=0.13u
XNB_n970 m_n970 n915 gn1 gn1 sg13_lv_nmos w=0.74u l=0.13u
CL_n970 n970 gn1 2f
XPA_n971 n971 n912 ph1 ph1 sg13_lv_pmos w=1.12u l=0.13u
XPB_n971 n971 n918 ph1 ph1 sg13_lv_pmos w=1.12u l=0.13u
XNA_n971 n971 n912 m_n971 gn1 sg13_lv_nmos w=0.74u l=0.13u
XNB_n971 m_n971 n918 gn1 gn1 sg13_lv_nmos w=0.74u l=0.13u
CL_n971 n971 gn1 2f
XPA_n973 n973 n921 ph1 ph1 sg13_lv_pmos w=1.12u l=0.13u
XPB_n973 n973 n930 ph1 ph1 sg13_lv_pmos w=1.12u l=0.13u
XNA_n973 n973 n921 m_n973 gn1 sg13_lv_nmos w=0.74u l=0.13u
XNB_n973 m_n973 n930 gn1 gn1 sg13_lv_nmos w=0.74u l=0.13u
CL_n973 n973 gn1 2f
XPA_n974 n974 n924 ph1 ph1 sg13_lv_pmos w=1.12u l=0.13u
XPB_n974 n974 n927 ph1 ph1 sg13_lv_pmos w=1.12u l=0.13u
XNA_n974 n974 n924 m_n974 gn1 sg13_lv_nmos w=0.74u l=0.13u
XNB_n974 m_n974 n927 gn1 gn1 sg13_lv_nmos w=0.74u l=0.13u
CL_n974 n974 gn1 2f
XPA_n976 n976 n921 ph1 ph1 sg13_lv_pmos w=1.12u l=0.13u
XPB_n976 n976 n927 ph1 ph1 sg13_lv_pmos w=1.12u l=0.13u
XNA_n976 n976 n921 m_n976 gn1 sg13_lv_nmos w=0.74u l=0.13u
XNB_n976 m_n976 n927 gn1 gn1 sg13_lv_nmos w=0.74u l=0.13u
CL_n976 n976 gn1 2f
XPA_n977 n977 n924 ph1 ph1 sg13_lv_pmos w=1.12u l=0.13u
XPB_n977 n977 n930 ph1 ph1 sg13_lv_pmos w=1.12u l=0.13u
XNA_n977 n977 n924 m_n977 gn1 sg13_lv_nmos w=0.74u l=0.13u
XNB_n977 m_n977 n930 gn1 gn1 sg13_lv_nmos w=0.74u l=0.13u
CL_n977 n977 gn1 2f
XPA_n979 n979 n933 ph1 ph1 sg13_lv_pmos w=1.12u l=0.13u
XPB_n979 n979 n942 ph1 ph1 sg13_lv_pmos w=1.12u l=0.13u
XNA_n979 n979 n933 m_n979 gn1 sg13_lv_nmos w=0.74u l=0.13u
XNB_n979 m_n979 n942 gn1 gn1 sg13_lv_nmos w=0.74u l=0.13u
CL_n979 n979 gn1 2f
XPA_n980 n980 n936 ph1 ph1 sg13_lv_pmos w=1.12u l=0.13u
XPB_n980 n980 n939 ph1 ph1 sg13_lv_pmos w=1.12u l=0.13u
XNA_n980 n980 n936 m_n980 gn1 sg13_lv_nmos w=0.74u l=0.13u
XNB_n980 m_n980 n939 gn1 gn1 sg13_lv_nmos w=0.74u l=0.13u
CL_n980 n980 gn1 2f
XPA_n982 n982 n933 ph1 ph1 sg13_lv_pmos w=1.12u l=0.13u
XPB_n982 n982 n939 ph1 ph1 sg13_lv_pmos w=1.12u l=0.13u
XNA_n982 n982 n933 m_n982 gn1 sg13_lv_nmos w=0.74u l=0.13u
XNB_n982 m_n982 n939 gn1 gn1 sg13_lv_nmos w=0.74u l=0.13u
CL_n982 n982 gn1 2f
XPA_n983 n983 n936 ph1 ph1 sg13_lv_pmos w=1.12u l=0.13u
XPB_n983 n983 n942 ph1 ph1 sg13_lv_pmos w=1.12u l=0.13u
XNA_n983 n983 n936 m_n983 gn1 sg13_lv_nmos w=0.74u l=0.13u
XNB_n983 m_n983 n942 gn1 gn1 sg13_lv_nmos w=0.74u l=0.13u
CL_n983 n983 gn1 2f
XPA_n1119 n1119 n1117 ph2 ph2 sg13_lv_pmos w=1.12u l=0.13u
XPB_n1119 n1119 n1118 ph2 ph2 sg13_lv_pmos w=1.12u l=0.13u
XNA_n1119 n1119 n1117 m_n1119 gn2 sg13_lv_nmos w=0.74u l=0.13u
XNB_n1119 m_n1119 n1118 gn2 gn2 sg13_lv_nmos w=0.74u l=0.13u
CL_n1119 n1119 gn2 2f
XPA_n1122 n1122 n1120 ph2 ph2 sg13_lv_pmos w=1.12u l=0.13u
XPB_n1122 n1122 n1121 ph2 ph2 sg13_lv_pmos w=1.12u l=0.13u
XNA_n1122 n1122 n1120 m_n1122 gn2 sg13_lv_nmos w=0.74u l=0.13u
XNB_n1122 m_n1122 n1121 gn2 gn2 sg13_lv_nmos w=0.74u l=0.13u
CL_n1122 n1122 gn2 2f
XPA_n1125 n1125 n1123 ph2 ph2 sg13_lv_pmos w=1.12u l=0.13u
XPB_n1125 n1125 n1124 ph2 ph2 sg13_lv_pmos w=1.12u l=0.13u
XNA_n1125 n1125 n1123 m_n1125 gn2 sg13_lv_nmos w=0.74u l=0.13u
XNB_n1125 m_n1125 n1124 gn2 gn2 sg13_lv_nmos w=0.74u l=0.13u
CL_n1125 n1125 gn2 2f
XPA_n1128 n1128 n1126 ph2 ph2 sg13_lv_pmos w=1.12u l=0.13u
XPB_n1128 n1128 n1127 ph2 ph2 sg13_lv_pmos w=1.12u l=0.13u
XNA_n1128 n1128 n1126 m_n1128 gn2 sg13_lv_nmos w=0.74u l=0.13u
XNB_n1128 m_n1128 n1127 gn2 gn2 sg13_lv_nmos w=0.74u l=0.13u
CL_n1128 n1128 gn2 2f
XPA_n1131 n1131 n1129 ph2 ph2 sg13_lv_pmos w=1.12u l=0.13u
XPB_n1131 n1131 n1130 ph2 ph2 sg13_lv_pmos w=1.12u l=0.13u
XNA_n1131 n1131 n1129 m_n1131 gn2 sg13_lv_nmos w=0.74u l=0.13u
XNB_n1131 m_n1131 n1130 gn2 gn2 sg13_lv_nmos w=0.74u l=0.13u
CL_n1131 n1131 gn2 2f
XPA_n1134 n1134 n1132 ph2 ph2 sg13_lv_pmos w=1.12u l=0.13u
XPB_n1134 n1134 n1133 ph2 ph2 sg13_lv_pmos w=1.12u l=0.13u
XNA_n1134 n1134 n1132 m_n1134 gn2 sg13_lv_nmos w=0.74u l=0.13u
XNB_n1134 m_n1134 n1133 gn2 gn2 sg13_lv_nmos w=0.74u l=0.13u
CL_n1134 n1134 gn2 2f
XPA_n1137 n1137 n1135 ph2 ph2 sg13_lv_pmos w=1.12u l=0.13u
XPB_n1137 n1137 n1136 ph2 ph2 sg13_lv_pmos w=1.12u l=0.13u
XNA_n1137 n1137 n1135 m_n1137 gn2 sg13_lv_nmos w=0.74u l=0.13u
XNB_n1137 m_n1137 n1136 gn2 gn2 sg13_lv_nmos w=0.74u l=0.13u
CL_n1137 n1137 gn2 2f
XPA_n1140 n1140 n1138 ph2 ph2 sg13_lv_pmos w=1.12u l=0.13u
XPB_n1140 n1140 n1139 ph2 ph2 sg13_lv_pmos w=1.12u l=0.13u
XNA_n1140 n1140 n1138 m_n1140 gn2 sg13_lv_nmos w=0.74u l=0.13u
XNB_n1140 m_n1140 n1139 gn2 gn2 sg13_lv_nmos w=0.74u l=0.13u
CL_n1140 n1140 gn2 2f
XPA_n1143 n1143 n1141 ph2 ph2 sg13_lv_pmos w=1.12u l=0.13u
XPB_n1143 n1143 n1142 ph2 ph2 sg13_lv_pmos w=1.12u l=0.13u
XNA_n1143 n1143 n1141 m_n1143 gn2 sg13_lv_nmos w=0.74u l=0.13u
XNB_n1143 m_n1143 n1142 gn2 gn2 sg13_lv_nmos w=0.74u l=0.13u
CL_n1143 n1143 gn2 2f
XPA_n1146 n1146 n1144 ph2 ph2 sg13_lv_pmos w=1.12u l=0.13u
XPB_n1146 n1146 n1145 ph2 ph2 sg13_lv_pmos w=1.12u l=0.13u
XNA_n1146 n1146 n1144 m_n1146 gn2 sg13_lv_nmos w=0.74u l=0.13u
XNB_n1146 m_n1146 n1145 gn2 gn2 sg13_lv_nmos w=0.74u l=0.13u
CL_n1146 n1146 gn2 2f
XPA_n1149 n1149 n1147 ph2 ph2 sg13_lv_pmos w=1.12u l=0.13u
XPB_n1149 n1149 n1148 ph2 ph2 sg13_lv_pmos w=1.12u l=0.13u
XNA_n1149 n1149 n1147 m_n1149 gn2 sg13_lv_nmos w=0.74u l=0.13u
XNB_n1149 m_n1149 n1148 gn2 gn2 sg13_lv_nmos w=0.74u l=0.13u
CL_n1149 n1149 gn2 2f
XPA_n1152 n1152 n1150 ph2 ph2 sg13_lv_pmos w=1.12u l=0.13u
XPB_n1152 n1152 n1151 ph2 ph2 sg13_lv_pmos w=1.12u l=0.13u
XNA_n1152 n1152 n1150 m_n1152 gn2 sg13_lv_nmos w=0.74u l=0.13u
XNB_n1152 m_n1152 n1151 gn2 gn2 sg13_lv_nmos w=0.74u l=0.13u
CL_n1152 n1152 gn2 2f
XPA_n1155 n1155 n1153 ph2 ph2 sg13_lv_pmos w=1.12u l=0.13u
XPB_n1155 n1155 n1154 ph2 ph2 sg13_lv_pmos w=1.12u l=0.13u
XNA_n1155 n1155 n1153 m_n1155 gn2 sg13_lv_nmos w=0.74u l=0.13u
XNB_n1155 m_n1155 n1154 gn2 gn2 sg13_lv_nmos w=0.74u l=0.13u
CL_n1155 n1155 gn2 2f
XPA_n1158 n1158 n1156 ph2 ph2 sg13_lv_pmos w=1.12u l=0.13u
XPB_n1158 n1158 n1157 ph2 ph2 sg13_lv_pmos w=1.12u l=0.13u
XNA_n1158 n1158 n1156 m_n1158 gn2 sg13_lv_nmos w=0.74u l=0.13u
XNB_n1158 m_n1158 n1157 gn2 gn2 sg13_lv_nmos w=0.74u l=0.13u
CL_n1158 n1158 gn2 2f
XPA_n129 n129 n127 ph2 ph2 sg13_lv_pmos w=1.12u l=0.13u
XPB_n129 n129 n128 ph2 ph2 sg13_lv_pmos w=1.12u l=0.13u
XNA_n129 n129 n127 m_n129 gn2 sg13_lv_nmos w=0.74u l=0.13u
XNB_n129 m_n129 n128 gn2 gn2 sg13_lv_nmos w=0.74u l=0.13u
CL_n129 n129 gn2 2f
XPA_n1305 n1305 n1303 ph2 ph2 sg13_lv_pmos w=1.12u l=0.13u
XPB_n1305 n1305 n1304 ph2 ph2 sg13_lv_pmos w=1.12u l=0.13u
XNA_n1305 n1305 n1303 m_n1305 gn2 sg13_lv_nmos w=0.74u l=0.13u
XNB_n1305 m_n1305 n1304 gn2 gn2 sg13_lv_nmos w=0.74u l=0.13u
CL_n1305 n1305 gn2 2f
XPA_n1308 n1308 n1306 ph2 ph2 sg13_lv_pmos w=1.12u l=0.13u
XPB_n1308 n1308 n1307 ph2 ph2 sg13_lv_pmos w=1.12u l=0.13u
XNA_n1308 n1308 n1306 m_n1308 gn2 sg13_lv_nmos w=0.74u l=0.13u
XNB_n1308 m_n1308 n1307 gn2 gn2 sg13_lv_nmos w=0.74u l=0.13u
CL_n1308 n1308 gn2 2f
XPA_n1311 n1311 n1309 ph2 ph2 sg13_lv_pmos w=1.12u l=0.13u
XPB_n1311 n1311 n1310 ph2 ph2 sg13_lv_pmos w=1.12u l=0.13u
XNA_n1311 n1311 n1309 m_n1311 gn2 sg13_lv_nmos w=0.74u l=0.13u
XNB_n1311 m_n1311 n1310 gn2 gn2 sg13_lv_nmos w=0.74u l=0.13u
CL_n1311 n1311 gn2 2f
XPA_n1314 n1314 n1312 ph2 ph2 sg13_lv_pmos w=1.12u l=0.13u
XPB_n1314 n1314 n1313 ph2 ph2 sg13_lv_pmos w=1.12u l=0.13u
XNA_n1314 n1314 n1312 m_n1314 gn2 sg13_lv_nmos w=0.74u l=0.13u
XNB_n1314 m_n1314 n1313 gn2 gn2 sg13_lv_nmos w=0.74u l=0.13u
CL_n1314 n1314 gn2 2f
XPA_n1317 n1317 n1315 ph2 ph2 sg13_lv_pmos w=1.12u l=0.13u
XPB_n1317 n1317 n1316 ph2 ph2 sg13_lv_pmos w=1.12u l=0.13u
XNA_n1317 n1317 n1315 m_n1317 gn2 sg13_lv_nmos w=0.74u l=0.13u
XNB_n1317 m_n1317 n1316 gn2 gn2 sg13_lv_nmos w=0.74u l=0.13u
CL_n1317 n1317 gn2 2f
XPA_n132 n132 n130 ph2 ph2 sg13_lv_pmos w=1.12u l=0.13u
XPB_n132 n132 n131 ph2 ph2 sg13_lv_pmos w=1.12u l=0.13u
XNA_n132 n132 n130 m_n132 gn2 sg13_lv_nmos w=0.74u l=0.13u
XNB_n132 m_n132 n131 gn2 gn2 sg13_lv_nmos w=0.74u l=0.13u
CL_n132 n132 gn2 2f
XPA_n1320 n1320 n1318 ph2 ph2 sg13_lv_pmos w=1.12u l=0.13u
XPB_n1320 n1320 n1319 ph2 ph2 sg13_lv_pmos w=1.12u l=0.13u
XNA_n1320 n1320 n1318 m_n1320 gn2 sg13_lv_nmos w=0.74u l=0.13u
XNB_n1320 m_n1320 n1319 gn2 gn2 sg13_lv_nmos w=0.74u l=0.13u
CL_n1320 n1320 gn2 2f
XPA_n1323 n1323 n1321 ph2 ph2 sg13_lv_pmos w=1.12u l=0.13u
XPB_n1323 n1323 n1322 ph2 ph2 sg13_lv_pmos w=1.12u l=0.13u
XNA_n1323 n1323 n1321 m_n1323 gn2 sg13_lv_nmos w=0.74u l=0.13u
XNB_n1323 m_n1323 n1322 gn2 gn2 sg13_lv_nmos w=0.74u l=0.13u
CL_n1323 n1323 gn2 2f
XPA_n1326 n1326 n1324 ph2 ph2 sg13_lv_pmos w=1.12u l=0.13u
XPB_n1326 n1326 n1325 ph2 ph2 sg13_lv_pmos w=1.12u l=0.13u
XNA_n1326 n1326 n1324 m_n1326 gn2 sg13_lv_nmos w=0.74u l=0.13u
XNB_n1326 m_n1326 n1325 gn2 gn2 sg13_lv_nmos w=0.74u l=0.13u
CL_n1326 n1326 gn2 2f
XPA_n1329 n1329 n1327 ph2 ph2 sg13_lv_pmos w=1.12u l=0.13u
XPB_n1329 n1329 n1328 ph2 ph2 sg13_lv_pmos w=1.12u l=0.13u
XNA_n1329 n1329 n1327 m_n1329 gn2 sg13_lv_nmos w=0.74u l=0.13u
XNB_n1329 m_n1329 n1328 gn2 gn2 sg13_lv_nmos w=0.74u l=0.13u
CL_n1329 n1329 gn2 2f
XPA_n1332 n1332 n1330 ph2 ph2 sg13_lv_pmos w=1.12u l=0.13u
XPB_n1332 n1332 n1331 ph2 ph2 sg13_lv_pmos w=1.12u l=0.13u
XNA_n1332 n1332 n1330 m_n1332 gn2 sg13_lv_nmos w=0.74u l=0.13u
XNB_n1332 m_n1332 n1331 gn2 gn2 sg13_lv_nmos w=0.74u l=0.13u
CL_n1332 n1332 gn2 2f
XPA_n1335 n1335 n1333 ph2 ph2 sg13_lv_pmos w=1.12u l=0.13u
XPB_n1335 n1335 n1334 ph2 ph2 sg13_lv_pmos w=1.12u l=0.13u
XNA_n1335 n1335 n1333 m_n1335 gn2 sg13_lv_nmos w=0.74u l=0.13u
XNB_n1335 m_n1335 n1334 gn2 gn2 sg13_lv_nmos w=0.74u l=0.13u
CL_n1335 n1335 gn2 2f
XPA_n1338 n1338 n1336 ph2 ph2 sg13_lv_pmos w=1.12u l=0.13u
XPB_n1338 n1338 n1337 ph2 ph2 sg13_lv_pmos w=1.12u l=0.13u
XNA_n1338 n1338 n1336 m_n1338 gn2 sg13_lv_nmos w=0.74u l=0.13u
XNB_n1338 m_n1338 n1337 gn2 gn2 sg13_lv_nmos w=0.74u l=0.13u
CL_n1338 n1338 gn2 2f
XPA_n1341 n1341 n1339 ph2 ph2 sg13_lv_pmos w=1.12u l=0.13u
XPB_n1341 n1341 n1340 ph2 ph2 sg13_lv_pmos w=1.12u l=0.13u
XNA_n1341 n1341 n1339 m_n1341 gn2 sg13_lv_nmos w=0.74u l=0.13u
XNB_n1341 m_n1341 n1340 gn2 gn2 sg13_lv_nmos w=0.74u l=0.13u
CL_n1341 n1341 gn2 2f
XPA_n1344 n1344 n1342 ph2 ph2 sg13_lv_pmos w=1.12u l=0.13u
XPB_n1344 n1344 n1343 ph2 ph2 sg13_lv_pmos w=1.12u l=0.13u
XNA_n1344 n1344 n1342 m_n1344 gn2 sg13_lv_nmos w=0.74u l=0.13u
XNB_n1344 m_n1344 n1343 gn2 gn2 sg13_lv_nmos w=0.74u l=0.13u
CL_n1344 n1344 gn2 2f
XPA_n1347 n1347 n1345 ph2 ph2 sg13_lv_pmos w=1.12u l=0.13u
XPB_n1347 n1347 n1346 ph2 ph2 sg13_lv_pmos w=1.12u l=0.13u
XNA_n1347 n1347 n1345 m_n1347 gn2 sg13_lv_nmos w=0.74u l=0.13u
XNB_n1347 m_n1347 n1346 gn2 gn2 sg13_lv_nmos w=0.74u l=0.13u
CL_n1347 n1347 gn2 2f
XPA_n1350 n1350 n1348 ph2 ph2 sg13_lv_pmos w=1.12u l=0.13u
XPB_n1350 n1350 n1349 ph2 ph2 sg13_lv_pmos w=1.12u l=0.13u
XNA_n1350 n1350 n1348 m_n1350 gn2 sg13_lv_nmos w=0.74u l=0.13u
XNB_n1350 m_n1350 n1349 gn2 gn2 sg13_lv_nmos w=0.74u l=0.13u
CL_n1350 n1350 gn2 2f
XPA_n213 n213 n211 ph2 ph2 sg13_lv_pmos w=1.12u l=0.13u
XPB_n213 n213 n212 ph2 ph2 sg13_lv_pmos w=1.12u l=0.13u
XNA_n213 n213 n211 m_n213 gn2 sg13_lv_nmos w=0.74u l=0.13u
XNB_n213 m_n213 n212 gn2 gn2 sg13_lv_nmos w=0.74u l=0.13u
CL_n213 n213 gn2 2f
XPA_n216 n216 n214 ph2 ph2 sg13_lv_pmos w=1.12u l=0.13u
XPB_n216 n216 n215 ph2 ph2 sg13_lv_pmos w=1.12u l=0.13u
XNA_n216 n216 n214 m_n216 gn2 sg13_lv_nmos w=0.74u l=0.13u
XNB_n216 m_n216 n215 gn2 gn2 sg13_lv_nmos w=0.74u l=0.13u
CL_n216 n216 gn2 2f
XPA_n219 n219 n217 ph2 ph2 sg13_lv_pmos w=1.12u l=0.13u
XPB_n219 n219 n218 ph2 ph2 sg13_lv_pmos w=1.12u l=0.13u
XNA_n219 n219 n217 m_n219 gn2 sg13_lv_nmos w=0.74u l=0.13u
XNB_n219 m_n219 n218 gn2 gn2 sg13_lv_nmos w=0.74u l=0.13u
CL_n219 n219 gn2 2f
XPA_n222 n222 n220 ph2 ph2 sg13_lv_pmos w=1.12u l=0.13u
XPB_n222 n222 n221 ph2 ph2 sg13_lv_pmos w=1.12u l=0.13u
XNA_n222 n222 n220 m_n222 gn2 sg13_lv_nmos w=0.74u l=0.13u
XNB_n222 m_n222 n221 gn2 gn2 sg13_lv_nmos w=0.74u l=0.13u
CL_n222 n222 gn2 2f
XPA_n225 n225 n223 ph2 ph2 sg13_lv_pmos w=1.12u l=0.13u
XPB_n225 n225 n224 ph2 ph2 sg13_lv_pmos w=1.12u l=0.13u
XNA_n225 n225 n223 m_n225 gn2 sg13_lv_nmos w=0.74u l=0.13u
XNB_n225 m_n225 n224 gn2 gn2 sg13_lv_nmos w=0.74u l=0.13u
CL_n225 n225 gn2 2f
XPA_n228 n228 n226 ph2 ph2 sg13_lv_pmos w=1.12u l=0.13u
XPB_n228 n228 n227 ph2 ph2 sg13_lv_pmos w=1.12u l=0.13u
XNA_n228 n228 n226 m_n228 gn2 sg13_lv_nmos w=0.74u l=0.13u
XNB_n228 m_n228 n227 gn2 gn2 sg13_lv_nmos w=0.74u l=0.13u
CL_n228 n228 gn2 2f
XPA_n231 n231 n229 ph2 ph2 sg13_lv_pmos w=1.12u l=0.13u
XPB_n231 n231 n230 ph2 ph2 sg13_lv_pmos w=1.12u l=0.13u
XNA_n231 n231 n229 m_n231 gn2 sg13_lv_nmos w=0.74u l=0.13u
XNB_n231 m_n231 n230 gn2 gn2 sg13_lv_nmos w=0.74u l=0.13u
CL_n231 n231 gn2 2f
XPA_n234 n234 n232 ph2 ph2 sg13_lv_pmos w=1.12u l=0.13u
XPB_n234 n234 n233 ph2 ph2 sg13_lv_pmos w=1.12u l=0.13u
XNA_n234 n234 n232 m_n234 gn2 sg13_lv_nmos w=0.74u l=0.13u
XNB_n234 m_n234 n233 gn2 gn2 sg13_lv_nmos w=0.74u l=0.13u
CL_n234 n234 gn2 2f
XPA_n237 n237 n235 ph2 ph2 sg13_lv_pmos w=1.12u l=0.13u
XPB_n237 n237 n236 ph2 ph2 sg13_lv_pmos w=1.12u l=0.13u
XNA_n237 n237 n235 m_n237 gn2 sg13_lv_nmos w=0.74u l=0.13u
XNB_n237 m_n237 n236 gn2 gn2 sg13_lv_nmos w=0.74u l=0.13u
CL_n237 n237 gn2 2f
XPA_n240 n240 n238 ph2 ph2 sg13_lv_pmos w=1.12u l=0.13u
XPB_n240 n240 n239 ph2 ph2 sg13_lv_pmos w=1.12u l=0.13u
XNA_n240 n240 n238 m_n240 gn2 sg13_lv_nmos w=0.74u l=0.13u
XNB_n240 m_n240 n239 gn2 gn2 sg13_lv_nmos w=0.74u l=0.13u
CL_n240 n240 gn2 2f
XPA_n279 n279 n277 ph2 ph2 sg13_lv_pmos w=1.12u l=0.13u
XPB_n279 n279 n278 ph2 ph2 sg13_lv_pmos w=1.12u l=0.13u
XNA_n279 n279 n277 m_n279 gn2 sg13_lv_nmos w=0.74u l=0.13u
XNB_n279 m_n279 n278 gn2 gn2 sg13_lv_nmos w=0.74u l=0.13u
CL_n279 n279 gn2 2f
XPA_n282 n282 n280 ph2 ph2 sg13_lv_pmos w=1.12u l=0.13u
XPB_n282 n282 n281 ph2 ph2 sg13_lv_pmos w=1.12u l=0.13u
XNA_n282 n282 n280 m_n282 gn2 sg13_lv_nmos w=0.74u l=0.13u
XNB_n282 m_n282 n281 gn2 gn2 sg13_lv_nmos w=0.74u l=0.13u
CL_n282 n282 gn2 2f
XPA_n399 n399 n397 ph2 ph2 sg13_lv_pmos w=1.12u l=0.13u
XPB_n399 n399 n398 ph2 ph2 sg13_lv_pmos w=1.12u l=0.13u
XNA_n399 n399 n397 m_n399 gn2 sg13_lv_nmos w=0.74u l=0.13u
XNB_n399 m_n399 n398 gn2 gn2 sg13_lv_nmos w=0.74u l=0.13u
CL_n399 n399 gn2 2f
XPA_n402 n402 n400 ph2 ph2 sg13_lv_pmos w=1.12u l=0.13u
XPB_n402 n402 n401 ph2 ph2 sg13_lv_pmos w=1.12u l=0.13u
XNA_n402 n402 n400 m_n402 gn2 sg13_lv_nmos w=0.74u l=0.13u
XNB_n402 m_n402 n401 gn2 gn2 sg13_lv_nmos w=0.74u l=0.13u
CL_n402 n402 gn2 2f
XPA_n405 n405 n403 ph2 ph2 sg13_lv_pmos w=1.12u l=0.13u
XPB_n405 n405 n404 ph2 ph2 sg13_lv_pmos w=1.12u l=0.13u
XNA_n405 n405 n403 m_n405 gn2 sg13_lv_nmos w=0.74u l=0.13u
XNB_n405 m_n405 n404 gn2 gn2 sg13_lv_nmos w=0.74u l=0.13u
CL_n405 n405 gn2 2f
XPA_n408 n408 n406 ph2 ph2 sg13_lv_pmos w=1.12u l=0.13u
XPB_n408 n408 n407 ph2 ph2 sg13_lv_pmos w=1.12u l=0.13u
XNA_n408 n408 n406 m_n408 gn2 sg13_lv_nmos w=0.74u l=0.13u
XNB_n408 m_n408 n407 gn2 gn2 sg13_lv_nmos w=0.74u l=0.13u
CL_n408 n408 gn2 2f
XPA_n411 n411 n409 ph2 ph2 sg13_lv_pmos w=1.12u l=0.13u
XPB_n411 n411 n410 ph2 ph2 sg13_lv_pmos w=1.12u l=0.13u
XNA_n411 n411 n409 m_n411 gn2 sg13_lv_nmos w=0.74u l=0.13u
XNB_n411 m_n411 n410 gn2 gn2 sg13_lv_nmos w=0.74u l=0.13u
CL_n411 n411 gn2 2f
XPA_n414 n414 n412 ph2 ph2 sg13_lv_pmos w=1.12u l=0.13u
XPB_n414 n414 n413 ph2 ph2 sg13_lv_pmos w=1.12u l=0.13u
XNA_n414 n414 n412 m_n414 gn2 sg13_lv_nmos w=0.74u l=0.13u
XNB_n414 m_n414 n413 gn2 gn2 sg13_lv_nmos w=0.74u l=0.13u
CL_n414 n414 gn2 2f
XPA_n417 n417 n415 ph2 ph2 sg13_lv_pmos w=1.12u l=0.13u
XPB_n417 n417 n416 ph2 ph2 sg13_lv_pmos w=1.12u l=0.13u
XNA_n417 n417 n415 m_n417 gn2 sg13_lv_nmos w=0.74u l=0.13u
XNB_n417 m_n417 n416 gn2 gn2 sg13_lv_nmos w=0.74u l=0.13u
CL_n417 n417 gn2 2f
XPA_n420 n420 n418 ph2 ph2 sg13_lv_pmos w=1.12u l=0.13u
XPB_n420 n420 n419 ph2 ph2 sg13_lv_pmos w=1.12u l=0.13u
XNA_n420 n420 n418 m_n420 gn2 sg13_lv_nmos w=0.74u l=0.13u
XNB_n420 m_n420 n419 gn2 gn2 sg13_lv_nmos w=0.74u l=0.13u
CL_n420 n420 gn2 2f
XPA_n423 n423 n421 ph2 ph2 sg13_lv_pmos w=1.12u l=0.13u
XPB_n423 n423 n422 ph2 ph2 sg13_lv_pmos w=1.12u l=0.13u
XNA_n423 n423 n421 m_n423 gn2 sg13_lv_nmos w=0.74u l=0.13u
XNB_n423 m_n423 n422 gn2 gn2 sg13_lv_nmos w=0.74u l=0.13u
CL_n423 n423 gn2 2f
XPA_n426 n426 n424 ph2 ph2 sg13_lv_pmos w=1.12u l=0.13u
XPB_n426 n426 n425 ph2 ph2 sg13_lv_pmos w=1.12u l=0.13u
XNA_n426 n426 n424 m_n426 gn2 sg13_lv_nmos w=0.74u l=0.13u
XNB_n426 m_n426 n425 gn2 gn2 sg13_lv_nmos w=0.74u l=0.13u
CL_n426 n426 gn2 2f
XPA_n429 n429 n427 ph2 ph2 sg13_lv_pmos w=1.12u l=0.13u
XPB_n429 n429 n428 ph2 ph2 sg13_lv_pmos w=1.12u l=0.13u
XNA_n429 n429 n427 m_n429 gn2 sg13_lv_nmos w=0.74u l=0.13u
XNB_n429 m_n429 n428 gn2 gn2 sg13_lv_nmos w=0.74u l=0.13u
CL_n429 n429 gn2 2f
XPA_n432 n432 n430 ph2 ph2 sg13_lv_pmos w=1.12u l=0.13u
XPB_n432 n432 n431 ph2 ph2 sg13_lv_pmos w=1.12u l=0.13u
XNA_n432 n432 n430 m_n432 gn2 sg13_lv_nmos w=0.74u l=0.13u
XNB_n432 m_n432 n431 gn2 gn2 sg13_lv_nmos w=0.74u l=0.13u
CL_n432 n432 gn2 2f
XPA_n435 n435 n433 ph2 ph2 sg13_lv_pmos w=1.12u l=0.13u
XPB_n435 n435 n434 ph2 ph2 sg13_lv_pmos w=1.12u l=0.13u
XNA_n435 n435 n433 m_n435 gn2 sg13_lv_nmos w=0.74u l=0.13u
XNB_n435 m_n435 n434 gn2 gn2 sg13_lv_nmos w=0.74u l=0.13u
CL_n435 n435 gn2 2f
XPA_n438 n438 n436 ph2 ph2 sg13_lv_pmos w=1.12u l=0.13u
XPB_n438 n438 n437 ph2 ph2 sg13_lv_pmos w=1.12u l=0.13u
XNA_n438 n438 n436 m_n438 gn2 sg13_lv_nmos w=0.74u l=0.13u
XNB_n438 m_n438 n437 gn2 gn2 sg13_lv_nmos w=0.74u l=0.13u
CL_n438 n438 gn2 2f
XPA_n441 n441 n439 ph2 ph2 sg13_lv_pmos w=1.12u l=0.13u
XPB_n441 n441 n440 ph2 ph2 sg13_lv_pmos w=1.12u l=0.13u
XNA_n441 n441 n439 m_n441 gn2 sg13_lv_nmos w=0.74u l=0.13u
XNB_n441 m_n441 n440 gn2 gn2 sg13_lv_nmos w=0.74u l=0.13u
CL_n441 n441 gn2 2f
XPA_n444 n444 n442 ph2 ph2 sg13_lv_pmos w=1.12u l=0.13u
XPB_n444 n444 n443 ph2 ph2 sg13_lv_pmos w=1.12u l=0.13u
XNA_n444 n444 n442 m_n444 gn2 sg13_lv_nmos w=0.74u l=0.13u
XNB_n444 m_n444 n443 gn2 gn2 sg13_lv_nmos w=0.74u l=0.13u
CL_n444 n444 gn2 2f
XPA_n573 n573 n571 ph2 ph2 sg13_lv_pmos w=1.12u l=0.13u
XPB_n573 n573 n572 ph2 ph2 sg13_lv_pmos w=1.12u l=0.13u
XNA_n573 n573 n571 m_n573 gn2 sg13_lv_nmos w=0.74u l=0.13u
XNB_n573 m_n573 n572 gn2 gn2 sg13_lv_nmos w=0.74u l=0.13u
CL_n573 n573 gn2 2f
XPA_n576 n576 n574 ph2 ph2 sg13_lv_pmos w=1.12u l=0.13u
XPB_n576 n576 n575 ph2 ph2 sg13_lv_pmos w=1.12u l=0.13u
XNA_n576 n576 n574 m_n576 gn2 sg13_lv_nmos w=0.74u l=0.13u
XNB_n576 m_n576 n575 gn2 gn2 sg13_lv_nmos w=0.74u l=0.13u
CL_n576 n576 gn2 2f
XPA_n579 n579 n577 ph2 ph2 sg13_lv_pmos w=1.12u l=0.13u
XPB_n579 n579 n578 ph2 ph2 sg13_lv_pmos w=1.12u l=0.13u
XNA_n579 n579 n577 m_n579 gn2 sg13_lv_nmos w=0.74u l=0.13u
XNB_n579 m_n579 n578 gn2 gn2 sg13_lv_nmos w=0.74u l=0.13u
CL_n579 n579 gn2 2f
XPA_n582 n582 n580 ph2 ph2 sg13_lv_pmos w=1.12u l=0.13u
XPB_n582 n582 n581 ph2 ph2 sg13_lv_pmos w=1.12u l=0.13u
XNA_n582 n582 n580 m_n582 gn2 sg13_lv_nmos w=0.74u l=0.13u
XNB_n582 m_n582 n581 gn2 gn2 sg13_lv_nmos w=0.74u l=0.13u
CL_n582 n582 gn2 2f
XPA_n585 n585 n583 ph2 ph2 sg13_lv_pmos w=1.12u l=0.13u
XPB_n585 n585 n584 ph2 ph2 sg13_lv_pmos w=1.12u l=0.13u
XNA_n585 n585 n583 m_n585 gn2 sg13_lv_nmos w=0.74u l=0.13u
XNB_n585 m_n585 n584 gn2 gn2 sg13_lv_nmos w=0.74u l=0.13u
CL_n585 n585 gn2 2f
XPA_n588 n588 n586 ph2 ph2 sg13_lv_pmos w=1.12u l=0.13u
XPB_n588 n588 n587 ph2 ph2 sg13_lv_pmos w=1.12u l=0.13u
XNA_n588 n588 n586 m_n588 gn2 sg13_lv_nmos w=0.74u l=0.13u
XNB_n588 m_n588 n587 gn2 gn2 sg13_lv_nmos w=0.74u l=0.13u
CL_n588 n588 gn2 2f
XPA_n591 n591 n589 ph2 ph2 sg13_lv_pmos w=1.12u l=0.13u
XPB_n591 n591 n590 ph2 ph2 sg13_lv_pmos w=1.12u l=0.13u
XNA_n591 n591 n589 m_n591 gn2 sg13_lv_nmos w=0.74u l=0.13u
XNB_n591 m_n591 n590 gn2 gn2 sg13_lv_nmos w=0.74u l=0.13u
CL_n591 n591 gn2 2f
XPA_n594 n594 n592 ph2 ph2 sg13_lv_pmos w=1.12u l=0.13u
XPB_n594 n594 n593 ph2 ph2 sg13_lv_pmos w=1.12u l=0.13u
XNA_n594 n594 n592 m_n594 gn2 sg13_lv_nmos w=0.74u l=0.13u
XNB_n594 m_n594 n593 gn2 gn2 sg13_lv_nmos w=0.74u l=0.13u
CL_n594 n594 gn2 2f
XPA_n597 n597 n595 ph2 ph2 sg13_lv_pmos w=1.12u l=0.13u
XPB_n597 n597 n596 ph2 ph2 sg13_lv_pmos w=1.12u l=0.13u
XNA_n597 n597 n595 m_n597 gn2 sg13_lv_nmos w=0.74u l=0.13u
XNB_n597 m_n597 n596 gn2 gn2 sg13_lv_nmos w=0.74u l=0.13u
CL_n597 n597 gn2 2f
XPA_n600 n600 n598 ph2 ph2 sg13_lv_pmos w=1.12u l=0.13u
XPB_n600 n600 n599 ph2 ph2 sg13_lv_pmos w=1.12u l=0.13u
XNA_n600 n600 n598 m_n600 gn2 sg13_lv_nmos w=0.74u l=0.13u
XNB_n600 m_n600 n599 gn2 gn2 sg13_lv_nmos w=0.74u l=0.13u
CL_n600 n600 gn2 2f
XPA_n603 n603 n601 ph2 ph2 sg13_lv_pmos w=1.12u l=0.13u
XPB_n603 n603 n602 ph2 ph2 sg13_lv_pmos w=1.12u l=0.13u
XNA_n603 n603 n601 m_n603 gn2 sg13_lv_nmos w=0.74u l=0.13u
XNB_n603 m_n603 n602 gn2 gn2 sg13_lv_nmos w=0.74u l=0.13u
CL_n603 n603 gn2 2f
XPA_n606 n606 n604 ph2 ph2 sg13_lv_pmos w=1.12u l=0.13u
XPB_n606 n606 n605 ph2 ph2 sg13_lv_pmos w=1.12u l=0.13u
XNA_n606 n606 n604 m_n606 gn2 sg13_lv_nmos w=0.74u l=0.13u
XNB_n606 m_n606 n605 gn2 gn2 sg13_lv_nmos w=0.74u l=0.13u
CL_n606 n606 gn2 2f
XPA_n609 n609 n607 ph2 ph2 sg13_lv_pmos w=1.12u l=0.13u
XPB_n609 n609 n608 ph2 ph2 sg13_lv_pmos w=1.12u l=0.13u
XNA_n609 n609 n607 m_n609 gn2 sg13_lv_nmos w=0.74u l=0.13u
XNB_n609 m_n609 n608 gn2 gn2 sg13_lv_nmos w=0.74u l=0.13u
CL_n609 n609 gn2 2f
XPA_n612 n612 n610 ph2 ph2 sg13_lv_pmos w=1.12u l=0.13u
XPB_n612 n612 n611 ph2 ph2 sg13_lv_pmos w=1.12u l=0.13u
XNA_n612 n612 n610 m_n612 gn2 sg13_lv_nmos w=0.74u l=0.13u
XNB_n612 m_n612 n611 gn2 gn2 sg13_lv_nmos w=0.74u l=0.13u
CL_n612 n612 gn2 2f
XPA_n63 n63 n61 ph2 ph2 sg13_lv_pmos w=1.12u l=0.13u
XPB_n63 n63 n62 ph2 ph2 sg13_lv_pmos w=1.12u l=0.13u
XNA_n63 n63 n61 m_n63 gn2 sg13_lv_nmos w=0.74u l=0.13u
XNB_n63 m_n63 n62 gn2 gn2 sg13_lv_nmos w=0.74u l=0.13u
CL_n63 n63 gn2 2f
XPA_n66 n66 n64 ph2 ph2 sg13_lv_pmos w=1.12u l=0.13u
XPB_n66 n66 n65 ph2 ph2 sg13_lv_pmos w=1.12u l=0.13u
XNA_n66 n66 n64 m_n66 gn2 sg13_lv_nmos w=0.74u l=0.13u
XNB_n66 m_n66 n65 gn2 gn2 sg13_lv_nmos w=0.74u l=0.13u
CL_n66 n66 gn2 2f
XPA_n675 n675 n673 ph2 ph2 sg13_lv_pmos w=1.12u l=0.13u
XPB_n675 n675 n674 ph2 ph2 sg13_lv_pmos w=1.12u l=0.13u
XNA_n675 n675 n673 m_n675 gn2 sg13_lv_nmos w=0.74u l=0.13u
XNB_n675 m_n675 n674 gn2 gn2 sg13_lv_nmos w=0.74u l=0.13u
CL_n675 n675 gn2 2f
XPA_n678 n678 n676 ph2 ph2 sg13_lv_pmos w=1.12u l=0.13u
XPB_n678 n678 n677 ph2 ph2 sg13_lv_pmos w=1.12u l=0.13u
XNA_n678 n678 n676 m_n678 gn2 sg13_lv_nmos w=0.74u l=0.13u
XNB_n678 m_n678 n677 gn2 gn2 sg13_lv_nmos w=0.74u l=0.13u
CL_n678 n678 gn2 2f
XPA_n69 n69 n67 ph2 ph2 sg13_lv_pmos w=1.12u l=0.13u
XPB_n69 n69 n68 ph2 ph2 sg13_lv_pmos w=1.12u l=0.13u
XNA_n69 n69 n67 m_n69 gn2 sg13_lv_nmos w=0.74u l=0.13u
XNB_n69 m_n69 n68 gn2 gn2 sg13_lv_nmos w=0.74u l=0.13u
CL_n69 n69 gn2 2f
XPA_n72 n72 n70 ph2 ph2 sg13_lv_pmos w=1.12u l=0.13u
XPB_n72 n72 n71 ph2 ph2 sg13_lv_pmos w=1.12u l=0.13u
XNA_n72 n72 n70 m_n72 gn2 sg13_lv_nmos w=0.74u l=0.13u
XNB_n72 m_n72 n71 gn2 gn2 sg13_lv_nmos w=0.74u l=0.13u
CL_n72 n72 gn2 2f
XPA_n75 n75 n73 ph2 ph2 sg13_lv_pmos w=1.12u l=0.13u
XPB_n75 n75 n74 ph2 ph2 sg13_lv_pmos w=1.12u l=0.13u
XNA_n75 n75 n73 m_n75 gn2 sg13_lv_nmos w=0.74u l=0.13u
XNB_n75 m_n75 n74 gn2 gn2 sg13_lv_nmos w=0.74u l=0.13u
CL_n75 n75 gn2 2f
XPA_n777 n777 n775 ph2 ph2 sg13_lv_pmos w=1.12u l=0.13u
XPB_n777 n777 n776 ph2 ph2 sg13_lv_pmos w=1.12u l=0.13u
XNA_n777 n777 n775 m_n777 gn2 sg13_lv_nmos w=0.74u l=0.13u
XNB_n777 m_n777 n776 gn2 gn2 sg13_lv_nmos w=0.74u l=0.13u
CL_n777 n777 gn2 2f
XPA_n78 n78 n76 ph2 ph2 sg13_lv_pmos w=1.12u l=0.13u
XPB_n78 n78 n77 ph2 ph2 sg13_lv_pmos w=1.12u l=0.13u
XNA_n78 n78 n76 m_n78 gn2 sg13_lv_nmos w=0.74u l=0.13u
XNB_n78 m_n78 n77 gn2 gn2 sg13_lv_nmos w=0.74u l=0.13u
CL_n78 n78 gn2 2f
XPA_n780 n780 n778 ph2 ph2 sg13_lv_pmos w=1.12u l=0.13u
XPB_n780 n780 n779 ph2 ph2 sg13_lv_pmos w=1.12u l=0.13u
XNA_n780 n780 n778 m_n780 gn2 sg13_lv_nmos w=0.74u l=0.13u
XNB_n780 m_n780 n779 gn2 gn2 sg13_lv_nmos w=0.74u l=0.13u
CL_n780 n780 gn2 2f
XPA_n783 n783 n781 ph2 ph2 sg13_lv_pmos w=1.12u l=0.13u
XPB_n783 n783 n782 ph2 ph2 sg13_lv_pmos w=1.12u l=0.13u
XNA_n783 n783 n781 m_n783 gn2 sg13_lv_nmos w=0.74u l=0.13u
XNB_n783 m_n783 n782 gn2 gn2 sg13_lv_nmos w=0.74u l=0.13u
CL_n783 n783 gn2 2f
XPA_n786 n786 n784 ph2 ph2 sg13_lv_pmos w=1.12u l=0.13u
XPB_n786 n786 n785 ph2 ph2 sg13_lv_pmos w=1.12u l=0.13u
XNA_n786 n786 n784 m_n786 gn2 sg13_lv_nmos w=0.74u l=0.13u
XNB_n786 m_n786 n785 gn2 gn2 sg13_lv_nmos w=0.74u l=0.13u
CL_n786 n786 gn2 2f
XPA_n789 n789 n787 ph2 ph2 sg13_lv_pmos w=1.12u l=0.13u
XPB_n789 n789 n788 ph2 ph2 sg13_lv_pmos w=1.12u l=0.13u
XNA_n789 n789 n787 m_n789 gn2 sg13_lv_nmos w=0.74u l=0.13u
XNB_n789 m_n789 n788 gn2 gn2 sg13_lv_nmos w=0.74u l=0.13u
CL_n789 n789 gn2 2f
XPA_n792 n792 n790 ph2 ph2 sg13_lv_pmos w=1.12u l=0.13u
XPB_n792 n792 n791 ph2 ph2 sg13_lv_pmos w=1.12u l=0.13u
XNA_n792 n792 n790 m_n792 gn2 sg13_lv_nmos w=0.74u l=0.13u
XNB_n792 m_n792 n791 gn2 gn2 sg13_lv_nmos w=0.74u l=0.13u
CL_n792 n792 gn2 2f
XPA_n795 n795 n793 ph2 ph2 sg13_lv_pmos w=1.12u l=0.13u
XPB_n795 n795 n794 ph2 ph2 sg13_lv_pmos w=1.12u l=0.13u
XNA_n795 n795 n793 m_n795 gn2 sg13_lv_nmos w=0.74u l=0.13u
XNB_n795 m_n795 n794 gn2 gn2 sg13_lv_nmos w=0.74u l=0.13u
CL_n795 n795 gn2 2f
XPA_n798 n798 n796 ph2 ph2 sg13_lv_pmos w=1.12u l=0.13u
XPB_n798 n798 n797 ph2 ph2 sg13_lv_pmos w=1.12u l=0.13u
XNA_n798 n798 n796 m_n798 gn2 sg13_lv_nmos w=0.74u l=0.13u
XNB_n798 m_n798 n797 gn2 gn2 sg13_lv_nmos w=0.74u l=0.13u
CL_n798 n798 gn2 2f
XPA_n801 n801 n799 ph2 ph2 sg13_lv_pmos w=1.12u l=0.13u
XPB_n801 n801 n800 ph2 ph2 sg13_lv_pmos w=1.12u l=0.13u
XNA_n801 n801 n799 m_n801 gn2 sg13_lv_nmos w=0.74u l=0.13u
XNB_n801 m_n801 n800 gn2 gn2 sg13_lv_nmos w=0.74u l=0.13u
CL_n801 n801 gn2 2f
XPA_n804 n804 n802 ph2 ph2 sg13_lv_pmos w=1.12u l=0.13u
XPB_n804 n804 n803 ph2 ph2 sg13_lv_pmos w=1.12u l=0.13u
XNA_n804 n804 n802 m_n804 gn2 sg13_lv_nmos w=0.74u l=0.13u
XNB_n804 m_n804 n803 gn2 gn2 sg13_lv_nmos w=0.74u l=0.13u
CL_n804 n804 gn2 2f
XPA_n807 n807 n805 ph2 ph2 sg13_lv_pmos w=1.12u l=0.13u
XPB_n807 n807 n806 ph2 ph2 sg13_lv_pmos w=1.12u l=0.13u
XNA_n807 n807 n805 m_n807 gn2 sg13_lv_nmos w=0.74u l=0.13u
XNB_n807 m_n807 n806 gn2 gn2 sg13_lv_nmos w=0.74u l=0.13u
CL_n807 n807 gn2 2f
XPA_n81 n81 n79 ph2 ph2 sg13_lv_pmos w=1.12u l=0.13u
XPB_n81 n81 n80 ph2 ph2 sg13_lv_pmos w=1.12u l=0.13u
XNA_n81 n81 n79 m_n81 gn2 sg13_lv_nmos w=0.74u l=0.13u
XNB_n81 m_n81 n80 gn2 gn2 sg13_lv_nmos w=0.74u l=0.13u
CL_n81 n81 gn2 2f
XPA_n810 n810 n808 ph2 ph2 sg13_lv_pmos w=1.12u l=0.13u
XPB_n810 n810 n809 ph2 ph2 sg13_lv_pmos w=1.12u l=0.13u
XNA_n810 n810 n808 m_n810 gn2 sg13_lv_nmos w=0.74u l=0.13u
XNB_n810 m_n810 n809 gn2 gn2 sg13_lv_nmos w=0.74u l=0.13u
CL_n810 n810 gn2 2f
XPA_n813 n813 n811 ph2 ph2 sg13_lv_pmos w=1.12u l=0.13u
XPB_n813 n813 n812 ph2 ph2 sg13_lv_pmos w=1.12u l=0.13u
XNA_n813 n813 n811 m_n813 gn2 sg13_lv_nmos w=0.74u l=0.13u
XNB_n813 m_n813 n812 gn2 gn2 sg13_lv_nmos w=0.74u l=0.13u
CL_n813 n813 gn2 2f
XPA_n816 n816 n814 ph2 ph2 sg13_lv_pmos w=1.12u l=0.13u
XPB_n816 n816 n815 ph2 ph2 sg13_lv_pmos w=1.12u l=0.13u
XNA_n816 n816 n814 m_n816 gn2 sg13_lv_nmos w=0.74u l=0.13u
XNB_n816 m_n816 n815 gn2 gn2 sg13_lv_nmos w=0.74u l=0.13u
CL_n816 n816 gn2 2f
XPA_n84 n84 n82 ph2 ph2 sg13_lv_pmos w=1.12u l=0.13u
XPB_n84 n84 n83 ph2 ph2 sg13_lv_pmos w=1.12u l=0.13u
XNA_n84 n84 n82 m_n84 gn2 sg13_lv_nmos w=0.74u l=0.13u
XNB_n84 m_n84 n83 gn2 gn2 sg13_lv_nmos w=0.74u l=0.13u
CL_n84 n84 gn2 2f
XPA_n87 n87 n85 ph2 ph2 sg13_lv_pmos w=1.12u l=0.13u
XPB_n87 n87 n86 ph2 ph2 sg13_lv_pmos w=1.12u l=0.13u
XNA_n87 n87 n85 m_n87 gn2 sg13_lv_nmos w=0.74u l=0.13u
XNB_n87 m_n87 n86 gn2 gn2 sg13_lv_nmos w=0.74u l=0.13u
CL_n87 n87 gn2 2f
XPA_n90 n90 n88 ph2 ph2 sg13_lv_pmos w=1.12u l=0.13u
XPB_n90 n90 n89 ph2 ph2 sg13_lv_pmos w=1.12u l=0.13u
XNA_n90 n90 n88 m_n90 gn2 sg13_lv_nmos w=0.74u l=0.13u
XNB_n90 m_n90 n89 gn2 gn2 sg13_lv_nmos w=0.74u l=0.13u
CL_n90 n90 gn2 2f
XPA_n945 n945 n943 ph2 ph2 sg13_lv_pmos w=1.12u l=0.13u
XPB_n945 n945 n944 ph2 ph2 sg13_lv_pmos w=1.12u l=0.13u
XNA_n945 n945 n943 m_n945 gn2 sg13_lv_nmos w=0.74u l=0.13u
XNB_n945 m_n945 n944 gn2 gn2 sg13_lv_nmos w=0.74u l=0.13u
CL_n945 n945 gn2 2f
XPA_n948 n948 n946 ph2 ph2 sg13_lv_pmos w=1.12u l=0.13u
XPB_n948 n948 n947 ph2 ph2 sg13_lv_pmos w=1.12u l=0.13u
XNA_n948 n948 n946 m_n948 gn2 sg13_lv_nmos w=0.74u l=0.13u
XNB_n948 m_n948 n947 gn2 gn2 sg13_lv_nmos w=0.74u l=0.13u
CL_n948 n948 gn2 2f
XPA_n951 n951 n949 ph2 ph2 sg13_lv_pmos w=1.12u l=0.13u
XPB_n951 n951 n950 ph2 ph2 sg13_lv_pmos w=1.12u l=0.13u
XNA_n951 n951 n949 m_n951 gn2 sg13_lv_nmos w=0.74u l=0.13u
XNB_n951 m_n951 n950 gn2 gn2 sg13_lv_nmos w=0.74u l=0.13u
CL_n951 n951 gn2 2f
XPA_n954 n954 n952 ph2 ph2 sg13_lv_pmos w=1.12u l=0.13u
XPB_n954 n954 n953 ph2 ph2 sg13_lv_pmos w=1.12u l=0.13u
XNA_n954 n954 n952 m_n954 gn2 sg13_lv_nmos w=0.74u l=0.13u
XNB_n954 m_n954 n953 gn2 gn2 sg13_lv_nmos w=0.74u l=0.13u
CL_n954 n954 gn2 2f
XPA_n957 n957 n955 ph2 ph2 sg13_lv_pmos w=1.12u l=0.13u
XPB_n957 n957 n956 ph2 ph2 sg13_lv_pmos w=1.12u l=0.13u
XNA_n957 n957 n955 m_n957 gn2 sg13_lv_nmos w=0.74u l=0.13u
XNB_n957 m_n957 n956 gn2 gn2 sg13_lv_nmos w=0.74u l=0.13u
CL_n957 n957 gn2 2f
XPA_n960 n960 n958 ph2 ph2 sg13_lv_pmos w=1.12u l=0.13u
XPB_n960 n960 n959 ph2 ph2 sg13_lv_pmos w=1.12u l=0.13u
XNA_n960 n960 n958 m_n960 gn2 sg13_lv_nmos w=0.74u l=0.13u
XNB_n960 m_n960 n959 gn2 gn2 sg13_lv_nmos w=0.74u l=0.13u
CL_n960 n960 gn2 2f
XPA_n963 n963 n961 ph2 ph2 sg13_lv_pmos w=1.12u l=0.13u
XPB_n963 n963 n962 ph2 ph2 sg13_lv_pmos w=1.12u l=0.13u
XNA_n963 n963 n961 m_n963 gn2 sg13_lv_nmos w=0.74u l=0.13u
XNB_n963 m_n963 n962 gn2 gn2 sg13_lv_nmos w=0.74u l=0.13u
CL_n963 n963 gn2 2f
XPA_n966 n966 n964 ph2 ph2 sg13_lv_pmos w=1.12u l=0.13u
XPB_n966 n966 n965 ph2 ph2 sg13_lv_pmos w=1.12u l=0.13u
XNA_n966 n966 n964 m_n966 gn2 sg13_lv_nmos w=0.74u l=0.13u
XNB_n966 m_n966 n965 gn2 gn2 sg13_lv_nmos w=0.74u l=0.13u
CL_n966 n966 gn2 2f
XPA_n969 n969 n967 ph2 ph2 sg13_lv_pmos w=1.12u l=0.13u
XPB_n969 n969 n968 ph2 ph2 sg13_lv_pmos w=1.12u l=0.13u
XNA_n969 n969 n967 m_n969 gn2 sg13_lv_nmos w=0.74u l=0.13u
XNB_n969 m_n969 n968 gn2 gn2 sg13_lv_nmos w=0.74u l=0.13u
CL_n969 n969 gn2 2f
XPA_n972 n972 n970 ph2 ph2 sg13_lv_pmos w=1.12u l=0.13u
XPB_n972 n972 n971 ph2 ph2 sg13_lv_pmos w=1.12u l=0.13u
XNA_n972 n972 n970 m_n972 gn2 sg13_lv_nmos w=0.74u l=0.13u
XNB_n972 m_n972 n971 gn2 gn2 sg13_lv_nmos w=0.74u l=0.13u
CL_n972 n972 gn2 2f
XPA_n975 n975 n973 ph2 ph2 sg13_lv_pmos w=1.12u l=0.13u
XPB_n975 n975 n974 ph2 ph2 sg13_lv_pmos w=1.12u l=0.13u
XNA_n975 n975 n973 m_n975 gn2 sg13_lv_nmos w=0.74u l=0.13u
XNB_n975 m_n975 n974 gn2 gn2 sg13_lv_nmos w=0.74u l=0.13u
CL_n975 n975 gn2 2f
XPA_n978 n978 n976 ph2 ph2 sg13_lv_pmos w=1.12u l=0.13u
XPB_n978 n978 n977 ph2 ph2 sg13_lv_pmos w=1.12u l=0.13u
XNA_n978 n978 n976 m_n978 gn2 sg13_lv_nmos w=0.74u l=0.13u
XNB_n978 m_n978 n977 gn2 gn2 sg13_lv_nmos w=0.74u l=0.13u
CL_n978 n978 gn2 2f
XPA_n981 n981 n979 ph2 ph2 sg13_lv_pmos w=1.12u l=0.13u
XPB_n981 n981 n980 ph2 ph2 sg13_lv_pmos w=1.12u l=0.13u
XNA_n981 n981 n979 m_n981 gn2 sg13_lv_nmos w=0.74u l=0.13u
XNB_n981 m_n981 n980 gn2 gn2 sg13_lv_nmos w=0.74u l=0.13u
CL_n981 n981 gn2 2f
XPA_n984 n984 n982 ph2 ph2 sg13_lv_pmos w=1.12u l=0.13u
XPB_n984 n984 n983 ph2 ph2 sg13_lv_pmos w=1.12u l=0.13u
XNA_n984 n984 n982 m_n984 gn2 sg13_lv_nmos w=0.74u l=0.13u
XNB_n984 m_n984 n983 gn2 gn2 sg13_lv_nmos w=0.74u l=0.13u
CL_n984 n984 gn2 2f
XPA_n1000 n1000 n957 ph2 ph2 sg13_lv_pmos w=1.12u l=0.13u
XPB_n1000 n1000 n963 ph2 ph2 sg13_lv_pmos w=1.12u l=0.13u
XNA_n1000 n1000 n957 m_n1000 gn2 sg13_lv_nmos w=0.74u l=0.13u
XNB_n1000 m_n1000 n963 gn2 gn2 sg13_lv_nmos w=0.74u l=0.13u
CL_n1000 n1000 gn2 2f
XPA_n1001 n1001 n960 ph2 ph2 sg13_lv_pmos w=1.12u l=0.13u
XPB_n1001 n1001 n966 ph2 ph2 sg13_lv_pmos w=1.12u l=0.13u
XNA_n1001 n1001 n960 m_n1001 gn2 sg13_lv_nmos w=0.74u l=0.13u
XNB_n1001 m_n1001 n966 gn2 gn2 sg13_lv_nmos w=0.74u l=0.13u
CL_n1001 n1001 gn2 2f
XPA_n1003 n1003 n969 ph2 ph2 sg13_lv_pmos w=1.12u l=0.13u
XPB_n1003 n1003 n978 ph2 ph2 sg13_lv_pmos w=1.12u l=0.13u
XNA_n1003 n1003 n969 m_n1003 gn2 sg13_lv_nmos w=0.74u l=0.13u
XNB_n1003 m_n1003 n978 gn2 gn2 sg13_lv_nmos w=0.74u l=0.13u
CL_n1003 n1003 gn2 2f
XPA_n1004 n1004 n972 ph2 ph2 sg13_lv_pmos w=1.12u l=0.13u
XPB_n1004 n1004 n975 ph2 ph2 sg13_lv_pmos w=1.12u l=0.13u
XNA_n1004 n1004 n972 m_n1004 gn2 sg13_lv_nmos w=0.74u l=0.13u
XNB_n1004 m_n1004 n975 gn2 gn2 sg13_lv_nmos w=0.74u l=0.13u
CL_n1004 n1004 gn2 2f
XPA_n1006 n1006 n969 ph2 ph2 sg13_lv_pmos w=1.12u l=0.13u
XPB_n1006 n1006 n975 ph2 ph2 sg13_lv_pmos w=1.12u l=0.13u
XNA_n1006 n1006 n969 m_n1006 gn2 sg13_lv_nmos w=0.74u l=0.13u
XNB_n1006 m_n1006 n975 gn2 gn2 sg13_lv_nmos w=0.74u l=0.13u
CL_n1006 n1006 gn2 2f
XPA_n1007 n1007 n972 ph2 ph2 sg13_lv_pmos w=1.12u l=0.13u
XPB_n1007 n1007 n978 ph2 ph2 sg13_lv_pmos w=1.12u l=0.13u
XNA_n1007 n1007 n972 m_n1007 gn2 sg13_lv_nmos w=0.74u l=0.13u
XNB_n1007 m_n1007 n978 gn2 gn2 sg13_lv_nmos w=0.74u l=0.13u
CL_n1007 n1007 gn2 2f
XPA_n1009 n1009 n981 ph2 ph2 sg13_lv_pmos w=1.12u l=0.13u
XPB_n1009 n1009 n990 ph2 ph2 sg13_lv_pmos w=1.12u l=0.13u
XNA_n1009 n1009 n981 m_n1009 gn2 sg13_lv_nmos w=0.74u l=0.13u
XNB_n1009 m_n1009 n990 gn2 gn2 sg13_lv_nmos w=0.74u l=0.13u
CL_n1009 n1009 gn2 2f
XPA_n1010 n1010 n984 ph2 ph2 sg13_lv_pmos w=1.12u l=0.13u
XPB_n1010 n1010 n987 ph2 ph2 sg13_lv_pmos w=1.12u l=0.13u
XNA_n1010 n1010 n984 m_n1010 gn2 sg13_lv_nmos w=0.74u l=0.13u
XNB_n1010 m_n1010 n987 gn2 gn2 sg13_lv_nmos w=0.74u l=0.13u
CL_n1010 n1010 gn2 2f
XPA_n1012 n1012 n981 ph2 ph2 sg13_lv_pmos w=1.12u l=0.13u
XPB_n1012 n1012 n987 ph2 ph2 sg13_lv_pmos w=1.12u l=0.13u
XNA_n1012 n1012 n981 m_n1012 gn2 sg13_lv_nmos w=0.74u l=0.13u
XNB_n1012 m_n1012 n987 gn2 gn2 sg13_lv_nmos w=0.74u l=0.13u
CL_n1012 n1012 gn2 2f
XPA_n1013 n1013 n984 ph2 ph2 sg13_lv_pmos w=1.12u l=0.13u
XPB_n1013 n1013 n990 ph2 ph2 sg13_lv_pmos w=1.12u l=0.13u
XNA_n1013 n1013 n984 m_n1013 gn2 sg13_lv_nmos w=0.74u l=0.13u
XNB_n1013 m_n1013 n990 gn2 gn2 sg13_lv_nmos w=0.74u l=0.13u
CL_n1013 n1013 gn2 2f
XPA_n109 n109 n63 ph2 ph2 sg13_lv_pmos w=1.12u l=0.13u
XPB_n109 n109 n72 ph2 ph2 sg13_lv_pmos w=1.12u l=0.13u
XNA_n109 n109 n63 m_n109 gn2 sg13_lv_nmos w=0.74u l=0.13u
XNB_n109 m_n109 n72 gn2 gn2 sg13_lv_nmos w=0.74u l=0.13u
CL_n109 n109 gn2 2f
XPA_n110 n110 n66 ph2 ph2 sg13_lv_pmos w=1.12u l=0.13u
XPB_n110 n110 n69 ph2 ph2 sg13_lv_pmos w=1.12u l=0.13u
XNA_n110 n110 n66 m_n110 gn2 sg13_lv_nmos w=0.74u l=0.13u
XNB_n110 m_n110 n69 gn2 gn2 sg13_lv_nmos w=0.74u l=0.13u
CL_n110 n110 gn2 2f
XPA_n112 n112 n63 ph2 ph2 sg13_lv_pmos w=1.12u l=0.13u
XPB_n112 n112 n69 ph2 ph2 sg13_lv_pmos w=1.12u l=0.13u
XNA_n112 n112 n63 m_n112 gn2 sg13_lv_nmos w=0.74u l=0.13u
XNB_n112 m_n112 n69 gn2 gn2 sg13_lv_nmos w=0.74u l=0.13u
CL_n112 n112 gn2 2f
XPA_n113 n113 n66 ph2 ph2 sg13_lv_pmos w=1.12u l=0.13u
XPB_n113 n113 n72 ph2 ph2 sg13_lv_pmos w=1.12u l=0.13u
XNA_n113 n113 n66 m_n113 gn2 sg13_lv_nmos w=0.74u l=0.13u
XNB_n113 m_n113 n72 gn2 gn2 sg13_lv_nmos w=0.74u l=0.13u
CL_n113 n113 gn2 2f
XPA_n115 n115 n75 ph2 ph2 sg13_lv_pmos w=1.12u l=0.13u
XPB_n115 n115 n84 ph2 ph2 sg13_lv_pmos w=1.12u l=0.13u
XNA_n115 n115 n75 m_n115 gn2 sg13_lv_nmos w=0.74u l=0.13u
XNB_n115 m_n115 n84 gn2 gn2 sg13_lv_nmos w=0.74u l=0.13u
CL_n115 n115 gn2 2f
XPA_n116 n116 n78 ph2 ph2 sg13_lv_pmos w=1.12u l=0.13u
XPB_n116 n116 n81 ph2 ph2 sg13_lv_pmos w=1.12u l=0.13u
XNA_n116 n116 n78 m_n116 gn2 sg13_lv_nmos w=0.74u l=0.13u
XNB_n116 m_n116 n81 gn2 gn2 sg13_lv_nmos w=0.74u l=0.13u
CL_n116 n116 gn2 2f
XPA_n1165 n1165 n1119 ph2 ph2 sg13_lv_pmos w=1.12u l=0.13u
XPB_n1165 n1165 n1128 ph2 ph2 sg13_lv_pmos w=1.12u l=0.13u
XNA_n1165 n1165 n1119 m_n1165 gn2 sg13_lv_nmos w=0.74u l=0.13u
XNB_n1165 m_n1165 n1128 gn2 gn2 sg13_lv_nmos w=0.74u l=0.13u
CL_n1165 n1165 gn2 2f
XPA_n1166 n1166 n1122 ph2 ph2 sg13_lv_pmos w=1.12u l=0.13u
XPB_n1166 n1166 n1125 ph2 ph2 sg13_lv_pmos w=1.12u l=0.13u
XNA_n1166 n1166 n1122 m_n1166 gn2 sg13_lv_nmos w=0.74u l=0.13u
XNB_n1166 m_n1166 n1125 gn2 gn2 sg13_lv_nmos w=0.74u l=0.13u
CL_n1166 n1166 gn2 2f
XPA_n1168 n1168 n1119 ph2 ph2 sg13_lv_pmos w=1.12u l=0.13u
XPB_n1168 n1168 n1125 ph2 ph2 sg13_lv_pmos w=1.12u l=0.13u
XNA_n1168 n1168 n1119 m_n1168 gn2 sg13_lv_nmos w=0.74u l=0.13u
XNB_n1168 m_n1168 n1125 gn2 gn2 sg13_lv_nmos w=0.74u l=0.13u
CL_n1168 n1168 gn2 2f
XPA_n1169 n1169 n1122 ph2 ph2 sg13_lv_pmos w=1.12u l=0.13u
XPB_n1169 n1169 n1128 ph2 ph2 sg13_lv_pmos w=1.12u l=0.13u
XNA_n1169 n1169 n1122 m_n1169 gn2 sg13_lv_nmos w=0.74u l=0.13u
XNB_n1169 m_n1169 n1128 gn2 gn2 sg13_lv_nmos w=0.74u l=0.13u
CL_n1169 n1169 gn2 2f
XPA_n1171 n1171 n1131 ph2 ph2 sg13_lv_pmos w=1.12u l=0.13u
XPB_n1171 n1171 n1140 ph2 ph2 sg13_lv_pmos w=1.12u l=0.13u
XNA_n1171 n1171 n1131 m_n1171 gn2 sg13_lv_nmos w=0.74u l=0.13u
XNB_n1171 m_n1171 n1140 gn2 gn2 sg13_lv_nmos w=0.74u l=0.13u
CL_n1171 n1171 gn2 2f
XPA_n1172 n1172 n1134 ph2 ph2 sg13_lv_pmos w=1.12u l=0.13u
XPB_n1172 n1172 n1137 ph2 ph2 sg13_lv_pmos w=1.12u l=0.13u
XNA_n1172 n1172 n1134 m_n1172 gn2 sg13_lv_nmos w=0.74u l=0.13u
XNB_n1172 m_n1172 n1137 gn2 gn2 sg13_lv_nmos w=0.74u l=0.13u
CL_n1172 n1172 gn2 2f
XPA_n1174 n1174 n1131 ph2 ph2 sg13_lv_pmos w=1.12u l=0.13u
XPB_n1174 n1174 n1137 ph2 ph2 sg13_lv_pmos w=1.12u l=0.13u
XNA_n1174 n1174 n1131 m_n1174 gn2 sg13_lv_nmos w=0.74u l=0.13u
XNB_n1174 m_n1174 n1137 gn2 gn2 sg13_lv_nmos w=0.74u l=0.13u
CL_n1174 n1174 gn2 2f
XPA_n1175 n1175 n1134 ph2 ph2 sg13_lv_pmos w=1.12u l=0.13u
XPB_n1175 n1175 n1140 ph2 ph2 sg13_lv_pmos w=1.12u l=0.13u
XNA_n1175 n1175 n1134 m_n1175 gn2 sg13_lv_nmos w=0.74u l=0.13u
XNB_n1175 m_n1175 n1140 gn2 gn2 sg13_lv_nmos w=0.74u l=0.13u
CL_n1175 n1175 gn2 2f
XPA_n1177 n1177 n1143 ph2 ph2 sg13_lv_pmos w=1.12u l=0.13u
XPB_n1177 n1177 n1152 ph2 ph2 sg13_lv_pmos w=1.12u l=0.13u
XNA_n1177 n1177 n1143 m_n1177 gn2 sg13_lv_nmos w=0.74u l=0.13u
XNB_n1177 m_n1177 n1152 gn2 gn2 sg13_lv_nmos w=0.74u l=0.13u
CL_n1177 n1177 gn2 2f
XPA_n1178 n1178 n1146 ph2 ph2 sg13_lv_pmos w=1.12u l=0.13u
XPB_n1178 n1178 n1149 ph2 ph2 sg13_lv_pmos w=1.12u l=0.13u
XNA_n1178 n1178 n1146 m_n1178 gn2 sg13_lv_nmos w=0.74u l=0.13u
XNB_n1178 m_n1178 n1149 gn2 gn2 sg13_lv_nmos w=0.74u l=0.13u
CL_n1178 n1178 gn2 2f
XPA_n118 n118 n75 ph2 ph2 sg13_lv_pmos w=1.12u l=0.13u
XPB_n118 n118 n81 ph2 ph2 sg13_lv_pmos w=1.12u l=0.13u
XNA_n118 n118 n75 m_n118 gn2 sg13_lv_nmos w=0.74u l=0.13u
XNB_n118 m_n118 n81 gn2 gn2 sg13_lv_nmos w=0.74u l=0.13u
CL_n118 n118 gn2 2f
XPA_n1180 n1180 n1143 ph2 ph2 sg13_lv_pmos w=1.12u l=0.13u
XPB_n1180 n1180 n1149 ph2 ph2 sg13_lv_pmos w=1.12u l=0.13u
XNA_n1180 n1180 n1143 m_n1180 gn2 sg13_lv_nmos w=0.74u l=0.13u
XNB_n1180 m_n1180 n1149 gn2 gn2 sg13_lv_nmos w=0.74u l=0.13u
CL_n1180 n1180 gn2 2f
XPA_n1181 n1181 n1146 ph2 ph2 sg13_lv_pmos w=1.12u l=0.13u
XPB_n1181 n1181 n1152 ph2 ph2 sg13_lv_pmos w=1.12u l=0.13u
XNA_n1181 n1181 n1146 m_n1181 gn2 sg13_lv_nmos w=0.74u l=0.13u
XNB_n1181 m_n1181 n1152 gn2 gn2 sg13_lv_nmos w=0.74u l=0.13u
CL_n1181 n1181 gn2 2f
XPA_n1183 n1183 n1155 ph2 ph2 sg13_lv_pmos w=1.12u l=0.13u
XPB_n1183 n1183 n1164 ph2 ph2 sg13_lv_pmos w=1.12u l=0.13u
XNA_n1183 n1183 n1155 m_n1183 gn2 sg13_lv_nmos w=0.74u l=0.13u
XNB_n1183 m_n1183 n1164 gn2 gn2 sg13_lv_nmos w=0.74u l=0.13u
CL_n1183 n1183 gn2 2f
XPA_n1184 n1184 n1158 ph2 ph2 sg13_lv_pmos w=1.12u l=0.13u
XPB_n1184 n1184 n1161 ph2 ph2 sg13_lv_pmos w=1.12u l=0.13u
XNA_n1184 n1184 n1158 m_n1184 gn2 sg13_lv_nmos w=0.74u l=0.13u
XNB_n1184 m_n1184 n1161 gn2 gn2 sg13_lv_nmos w=0.74u l=0.13u
CL_n1184 n1184 gn2 2f
XPA_n1186 n1186 n1155 ph2 ph2 sg13_lv_pmos w=1.12u l=0.13u
XPB_n1186 n1186 n1161 ph2 ph2 sg13_lv_pmos w=1.12u l=0.13u
XNA_n1186 n1186 n1155 m_n1186 gn2 sg13_lv_nmos w=0.74u l=0.13u
XNB_n1186 m_n1186 n1161 gn2 gn2 sg13_lv_nmos w=0.74u l=0.13u
CL_n1186 n1186 gn2 2f
XPA_n1187 n1187 n1158 ph2 ph2 sg13_lv_pmos w=1.12u l=0.13u
XPB_n1187 n1187 n1164 ph2 ph2 sg13_lv_pmos w=1.12u l=0.13u
XNA_n1187 n1187 n1158 m_n1187 gn2 sg13_lv_nmos w=0.74u l=0.13u
XNB_n1187 m_n1187 n1164 gn2 gn2 sg13_lv_nmos w=0.74u l=0.13u
CL_n1187 n1187 gn2 2f
XPA_n119 n119 n78 ph2 ph2 sg13_lv_pmos w=1.12u l=0.13u
XPB_n119 n119 n84 ph2 ph2 sg13_lv_pmos w=1.12u l=0.13u
XNA_n119 n119 n78 m_n119 gn2 sg13_lv_nmos w=0.74u l=0.13u
XNB_n119 m_n119 n84 gn2 gn2 sg13_lv_nmos w=0.74u l=0.13u
CL_n119 n119 gn2 2f
XPA_n121 n121 n87 ph2 ph2 sg13_lv_pmos w=1.12u l=0.13u
XPB_n121 n121 n96 ph2 ph2 sg13_lv_pmos w=1.12u l=0.13u
XNA_n121 n121 n87 m_n121 gn2 sg13_lv_nmos w=0.74u l=0.13u
XNB_n121 m_n121 n96 gn2 gn2 sg13_lv_nmos w=0.74u l=0.13u
CL_n121 n121 gn2 2f
XPA_n122 n122 n90 ph2 ph2 sg13_lv_pmos w=1.12u l=0.13u
XPB_n122 n122 n93 ph2 ph2 sg13_lv_pmos w=1.12u l=0.13u
XNA_n122 n122 n90 m_n122 gn2 sg13_lv_nmos w=0.74u l=0.13u
XNB_n122 m_n122 n93 gn2 gn2 sg13_lv_nmos w=0.74u l=0.13u
CL_n122 n122 gn2 2f
XPA_n124 n124 n87 ph2 ph2 sg13_lv_pmos w=1.12u l=0.13u
XPB_n124 n124 n93 ph2 ph2 sg13_lv_pmos w=1.12u l=0.13u
XNA_n124 n124 n87 m_n124 gn2 sg13_lv_nmos w=0.74u l=0.13u
XNB_n124 m_n124 n93 gn2 gn2 sg13_lv_nmos w=0.74u l=0.13u
CL_n124 n124 gn2 2f
XPA_n125 n125 n90 ph2 ph2 sg13_lv_pmos w=1.12u l=0.13u
XPB_n125 n125 n96 ph2 ph2 sg13_lv_pmos w=1.12u l=0.13u
XNA_n125 n125 n90 m_n125 gn2 sg13_lv_nmos w=0.74u l=0.13u
XNB_n125 m_n125 n96 gn2 gn2 sg13_lv_nmos w=0.74u l=0.13u
CL_n125 n125 gn2 2f
XPA_n1351 n1351 n1305 ph2 ph2 sg13_lv_pmos w=1.12u l=0.13u
XPB_n1351 n1351 n1314 ph2 ph2 sg13_lv_pmos w=1.12u l=0.13u
XNA_n1351 n1351 n1305 m_n1351 gn2 sg13_lv_nmos w=0.74u l=0.13u
XNB_n1351 m_n1351 n1314 gn2 gn2 sg13_lv_nmos w=0.74u l=0.13u
CL_n1351 n1351 gn2 2f
XPA_n1352 n1352 n1308 ph2 ph2 sg13_lv_pmos w=1.12u l=0.13u
XPB_n1352 n1352 n1311 ph2 ph2 sg13_lv_pmos w=1.12u l=0.13u
XNA_n1352 n1352 n1308 m_n1352 gn2 sg13_lv_nmos w=0.74u l=0.13u
XNB_n1352 m_n1352 n1311 gn2 gn2 sg13_lv_nmos w=0.74u l=0.13u
CL_n1352 n1352 gn2 2f
XPA_n1354 n1354 n1305 ph2 ph2 sg13_lv_pmos w=1.12u l=0.13u
XPB_n1354 n1354 n1311 ph2 ph2 sg13_lv_pmos w=1.12u l=0.13u
XNA_n1354 n1354 n1305 m_n1354 gn2 sg13_lv_nmos w=0.74u l=0.13u
XNB_n1354 m_n1354 n1311 gn2 gn2 sg13_lv_nmos w=0.74u l=0.13u
CL_n1354 n1354 gn2 2f
XPA_n1355 n1355 n1308 ph2 ph2 sg13_lv_pmos w=1.12u l=0.13u
XPB_n1355 n1355 n1314 ph2 ph2 sg13_lv_pmos w=1.12u l=0.13u
XNA_n1355 n1355 n1308 m_n1355 gn2 sg13_lv_nmos w=0.74u l=0.13u
XNB_n1355 m_n1355 n1314 gn2 gn2 sg13_lv_nmos w=0.74u l=0.13u
CL_n1355 n1355 gn2 2f
XPA_n1357 n1357 n1317 ph2 ph2 sg13_lv_pmos w=1.12u l=0.13u
XPB_n1357 n1357 n1326 ph2 ph2 sg13_lv_pmos w=1.12u l=0.13u
XNA_n1357 n1357 n1317 m_n1357 gn2 sg13_lv_nmos w=0.74u l=0.13u
XNB_n1357 m_n1357 n1326 gn2 gn2 sg13_lv_nmos w=0.74u l=0.13u
CL_n1357 n1357 gn2 2f
XPA_n1358 n1358 n1320 ph2 ph2 sg13_lv_pmos w=1.12u l=0.13u
XPB_n1358 n1358 n1323 ph2 ph2 sg13_lv_pmos w=1.12u l=0.13u
XNA_n1358 n1358 n1320 m_n1358 gn2 sg13_lv_nmos w=0.74u l=0.13u
XNB_n1358 m_n1358 n1323 gn2 gn2 sg13_lv_nmos w=0.74u l=0.13u
CL_n1358 n1358 gn2 2f
XPA_n1360 n1360 n1317 ph2 ph2 sg13_lv_pmos w=1.12u l=0.13u
XPB_n1360 n1360 n1323 ph2 ph2 sg13_lv_pmos w=1.12u l=0.13u
XNA_n1360 n1360 n1317 m_n1360 gn2 sg13_lv_nmos w=0.74u l=0.13u
XNB_n1360 m_n1360 n1323 gn2 gn2 sg13_lv_nmos w=0.74u l=0.13u
CL_n1360 n1360 gn2 2f
XPA_n1361 n1361 n1320 ph2 ph2 sg13_lv_pmos w=1.12u l=0.13u
XPB_n1361 n1361 n1326 ph2 ph2 sg13_lv_pmos w=1.12u l=0.13u
XNA_n1361 n1361 n1320 m_n1361 gn2 sg13_lv_nmos w=0.74u l=0.13u
XNB_n1361 m_n1361 n1326 gn2 gn2 sg13_lv_nmos w=0.74u l=0.13u
CL_n1361 n1361 gn2 2f
XPA_n1363 n1363 n1329 ph2 ph2 sg13_lv_pmos w=1.12u l=0.13u
XPB_n1363 n1363 n1338 ph2 ph2 sg13_lv_pmos w=1.12u l=0.13u
XNA_n1363 n1363 n1329 m_n1363 gn2 sg13_lv_nmos w=0.74u l=0.13u
XNB_n1363 m_n1363 n1338 gn2 gn2 sg13_lv_nmos w=0.74u l=0.13u
CL_n1363 n1363 gn2 2f
XPA_n1364 n1364 n1332 ph2 ph2 sg13_lv_pmos w=1.12u l=0.13u
XPB_n1364 n1364 n1335 ph2 ph2 sg13_lv_pmos w=1.12u l=0.13u
XNA_n1364 n1364 n1332 m_n1364 gn2 sg13_lv_nmos w=0.74u l=0.13u
XNB_n1364 m_n1364 n1335 gn2 gn2 sg13_lv_nmos w=0.74u l=0.13u
CL_n1364 n1364 gn2 2f
XPA_n1366 n1366 n1329 ph2 ph2 sg13_lv_pmos w=1.12u l=0.13u
XPB_n1366 n1366 n1335 ph2 ph2 sg13_lv_pmos w=1.12u l=0.13u
XNA_n1366 n1366 n1329 m_n1366 gn2 sg13_lv_nmos w=0.74u l=0.13u
XNB_n1366 m_n1366 n1335 gn2 gn2 sg13_lv_nmos w=0.74u l=0.13u
CL_n1366 n1366 gn2 2f
XPA_n1367 n1367 n1332 ph2 ph2 sg13_lv_pmos w=1.12u l=0.13u
XPB_n1367 n1367 n1338 ph2 ph2 sg13_lv_pmos w=1.12u l=0.13u
XNA_n1367 n1367 n1332 m_n1367 gn2 sg13_lv_nmos w=0.74u l=0.13u
XNB_n1367 m_n1367 n1338 gn2 gn2 sg13_lv_nmos w=0.74u l=0.13u
CL_n1367 n1367 gn2 2f
XPA_n1369 n1369 n1341 ph2 ph2 sg13_lv_pmos w=1.12u l=0.13u
XPB_n1369 n1369 n1350 ph2 ph2 sg13_lv_pmos w=1.12u l=0.13u
XNA_n1369 n1369 n1341 m_n1369 gn2 sg13_lv_nmos w=0.74u l=0.13u
XNB_n1369 m_n1369 n1350 gn2 gn2 sg13_lv_nmos w=0.74u l=0.13u
CL_n1369 n1369 gn2 2f
XPA_n1370 n1370 n1344 ph2 ph2 sg13_lv_pmos w=1.12u l=0.13u
XPB_n1370 n1370 n1347 ph2 ph2 sg13_lv_pmos w=1.12u l=0.13u
XNA_n1370 n1370 n1344 m_n1370 gn2 sg13_lv_nmos w=0.74u l=0.13u
XNB_n1370 m_n1370 n1347 gn2 gn2 sg13_lv_nmos w=0.74u l=0.13u
CL_n1370 n1370 gn2 2f
XPA_n1372 n1372 n1341 ph2 ph2 sg13_lv_pmos w=1.12u l=0.13u
XPB_n1372 n1372 n1347 ph2 ph2 sg13_lv_pmos w=1.12u l=0.13u
XNA_n1372 n1372 n1341 m_n1372 gn2 sg13_lv_nmos w=0.74u l=0.13u
XNB_n1372 m_n1372 n1347 gn2 gn2 sg13_lv_nmos w=0.74u l=0.13u
CL_n1372 n1372 gn2 2f
XPA_n1373 n1373 n1344 ph2 ph2 sg13_lv_pmos w=1.12u l=0.13u
XPB_n1373 n1373 n1350 ph2 ph2 sg13_lv_pmos w=1.12u l=0.13u
XNA_n1373 n1373 n1344 m_n1373 gn2 sg13_lv_nmos w=0.74u l=0.13u
XNB_n1373 m_n1373 n1350 gn2 gn2 sg13_lv_nmos w=0.74u l=0.13u
CL_n1373 n1373 gn2 2f
XPA_n259 n259 n213 ph2 ph2 sg13_lv_pmos w=1.12u l=0.13u
XPB_n259 n259 n222 ph2 ph2 sg13_lv_pmos w=1.12u l=0.13u
XNA_n259 n259 n213 m_n259 gn2 sg13_lv_nmos w=0.74u l=0.13u
XNB_n259 m_n259 n222 gn2 gn2 sg13_lv_nmos w=0.74u l=0.13u
CL_n259 n259 gn2 2f
XPA_n260 n260 n216 ph2 ph2 sg13_lv_pmos w=1.12u l=0.13u
XPB_n260 n260 n219 ph2 ph2 sg13_lv_pmos w=1.12u l=0.13u
XNA_n260 n260 n216 m_n260 gn2 sg13_lv_nmos w=0.74u l=0.13u
XNB_n260 m_n260 n219 gn2 gn2 sg13_lv_nmos w=0.74u l=0.13u
CL_n260 n260 gn2 2f
XPA_n262 n262 n213 ph2 ph2 sg13_lv_pmos w=1.12u l=0.13u
XPB_n262 n262 n219 ph2 ph2 sg13_lv_pmos w=1.12u l=0.13u
XNA_n262 n262 n213 m_n262 gn2 sg13_lv_nmos w=0.74u l=0.13u
XNB_n262 m_n262 n219 gn2 gn2 sg13_lv_nmos w=0.74u l=0.13u
CL_n262 n262 gn2 2f
XPA_n263 n263 n216 ph2 ph2 sg13_lv_pmos w=1.12u l=0.13u
XPB_n263 n263 n222 ph2 ph2 sg13_lv_pmos w=1.12u l=0.13u
XNA_n263 n263 n216 m_n263 gn2 sg13_lv_nmos w=0.74u l=0.13u
XNB_n263 m_n263 n222 gn2 gn2 sg13_lv_nmos w=0.74u l=0.13u
CL_n263 n263 gn2 2f
XPA_n265 n265 n225 ph2 ph2 sg13_lv_pmos w=1.12u l=0.13u
XPB_n265 n265 n234 ph2 ph2 sg13_lv_pmos w=1.12u l=0.13u
XNA_n265 n265 n225 m_n265 gn2 sg13_lv_nmos w=0.74u l=0.13u
XNB_n265 m_n265 n234 gn2 gn2 sg13_lv_nmos w=0.74u l=0.13u
CL_n265 n265 gn2 2f
XPA_n266 n266 n228 ph2 ph2 sg13_lv_pmos w=1.12u l=0.13u
XPB_n266 n266 n231 ph2 ph2 sg13_lv_pmos w=1.12u l=0.13u
XNA_n266 n266 n228 m_n266 gn2 sg13_lv_nmos w=0.74u l=0.13u
XNB_n266 m_n266 n231 gn2 gn2 sg13_lv_nmos w=0.74u l=0.13u
CL_n266 n266 gn2 2f
XPA_n268 n268 n225 ph2 ph2 sg13_lv_pmos w=1.12u l=0.13u
XPB_n268 n268 n231 ph2 ph2 sg13_lv_pmos w=1.12u l=0.13u
XNA_n268 n268 n225 m_n268 gn2 sg13_lv_nmos w=0.74u l=0.13u
XNB_n268 m_n268 n231 gn2 gn2 sg13_lv_nmos w=0.74u l=0.13u
CL_n268 n268 gn2 2f
XPA_n269 n269 n228 ph2 ph2 sg13_lv_pmos w=1.12u l=0.13u
XPB_n269 n269 n234 ph2 ph2 sg13_lv_pmos w=1.12u l=0.13u
XNA_n269 n269 n228 m_n269 gn2 sg13_lv_nmos w=0.74u l=0.13u
XNB_n269 m_n269 n234 gn2 gn2 sg13_lv_nmos w=0.74u l=0.13u
CL_n269 n269 gn2 2f
XPA_n271 n271 n237 ph2 ph2 sg13_lv_pmos w=1.12u l=0.13u
XPB_n271 n271 n246 ph2 ph2 sg13_lv_pmos w=1.12u l=0.13u
XNA_n271 n271 n237 m_n271 gn2 sg13_lv_nmos w=0.74u l=0.13u
XNB_n271 m_n271 n246 gn2 gn2 sg13_lv_nmos w=0.74u l=0.13u
CL_n271 n271 gn2 2f
XPA_n272 n272 n240 ph2 ph2 sg13_lv_pmos w=1.12u l=0.13u
XPB_n272 n272 n243 ph2 ph2 sg13_lv_pmos w=1.12u l=0.13u
XNA_n272 n272 n240 m_n272 gn2 sg13_lv_nmos w=0.74u l=0.13u
XNB_n272 m_n272 n243 gn2 gn2 sg13_lv_nmos w=0.74u l=0.13u
CL_n272 n272 gn2 2f
XPA_n274 n274 n237 ph2 ph2 sg13_lv_pmos w=1.12u l=0.13u
XPB_n274 n274 n243 ph2 ph2 sg13_lv_pmos w=1.12u l=0.13u
XNA_n274 n274 n237 m_n274 gn2 sg13_lv_nmos w=0.74u l=0.13u
XNB_n274 m_n274 n243 gn2 gn2 sg13_lv_nmos w=0.74u l=0.13u
CL_n274 n274 gn2 2f
XPA_n275 n275 n240 ph2 ph2 sg13_lv_pmos w=1.12u l=0.13u
XPB_n275 n275 n246 ph2 ph2 sg13_lv_pmos w=1.12u l=0.13u
XNA_n275 n275 n240 m_n275 gn2 sg13_lv_nmos w=0.74u l=0.13u
XNB_n275 m_n275 n246 gn2 gn2 sg13_lv_nmos w=0.74u l=0.13u
CL_n275 n275 gn2 2f
XPA_n445 n445 n399 ph2 ph2 sg13_lv_pmos w=1.12u l=0.13u
XPB_n445 n445 n408 ph2 ph2 sg13_lv_pmos w=1.12u l=0.13u
XNA_n445 n445 n399 m_n445 gn2 sg13_lv_nmos w=0.74u l=0.13u
XNB_n445 m_n445 n408 gn2 gn2 sg13_lv_nmos w=0.74u l=0.13u
CL_n445 n445 gn2 2f
XPA_n446 n446 n402 ph2 ph2 sg13_lv_pmos w=1.12u l=0.13u
XPB_n446 n446 n405 ph2 ph2 sg13_lv_pmos w=1.12u l=0.13u
XNA_n446 n446 n402 m_n446 gn2 sg13_lv_nmos w=0.74u l=0.13u
XNB_n446 m_n446 n405 gn2 gn2 sg13_lv_nmos w=0.74u l=0.13u
CL_n446 n446 gn2 2f
XPA_n448 n448 n399 ph2 ph2 sg13_lv_pmos w=1.12u l=0.13u
XPB_n448 n448 n405 ph2 ph2 sg13_lv_pmos w=1.12u l=0.13u
XNA_n448 n448 n399 m_n448 gn2 sg13_lv_nmos w=0.74u l=0.13u
XNB_n448 m_n448 n405 gn2 gn2 sg13_lv_nmos w=0.74u l=0.13u
CL_n448 n448 gn2 2f
XPA_n449 n449 n402 ph2 ph2 sg13_lv_pmos w=1.12u l=0.13u
XPB_n449 n449 n408 ph2 ph2 sg13_lv_pmos w=1.12u l=0.13u
XNA_n449 n449 n402 m_n449 gn2 sg13_lv_nmos w=0.74u l=0.13u
XNB_n449 m_n449 n408 gn2 gn2 sg13_lv_nmos w=0.74u l=0.13u
CL_n449 n449 gn2 2f
XPA_n451 n451 n411 ph2 ph2 sg13_lv_pmos w=1.12u l=0.13u
XPB_n451 n451 n420 ph2 ph2 sg13_lv_pmos w=1.12u l=0.13u
XNA_n451 n451 n411 m_n451 gn2 sg13_lv_nmos w=0.74u l=0.13u
XNB_n451 m_n451 n420 gn2 gn2 sg13_lv_nmos w=0.74u l=0.13u
CL_n451 n451 gn2 2f
XPA_n452 n452 n414 ph2 ph2 sg13_lv_pmos w=1.12u l=0.13u
XPB_n452 n452 n417 ph2 ph2 sg13_lv_pmos w=1.12u l=0.13u
XNA_n452 n452 n414 m_n452 gn2 sg13_lv_nmos w=0.74u l=0.13u
XNB_n452 m_n452 n417 gn2 gn2 sg13_lv_nmos w=0.74u l=0.13u
CL_n452 n452 gn2 2f
XPA_n454 n454 n411 ph2 ph2 sg13_lv_pmos w=1.12u l=0.13u
XPB_n454 n454 n417 ph2 ph2 sg13_lv_pmos w=1.12u l=0.13u
XNA_n454 n454 n411 m_n454 gn2 sg13_lv_nmos w=0.74u l=0.13u
XNB_n454 m_n454 n417 gn2 gn2 sg13_lv_nmos w=0.74u l=0.13u
CL_n454 n454 gn2 2f
XPA_n455 n455 n414 ph2 ph2 sg13_lv_pmos w=1.12u l=0.13u
XPB_n455 n455 n420 ph2 ph2 sg13_lv_pmos w=1.12u l=0.13u
XNA_n455 n455 n414 m_n455 gn2 sg13_lv_nmos w=0.74u l=0.13u
XNB_n455 m_n455 n420 gn2 gn2 sg13_lv_nmos w=0.74u l=0.13u
CL_n455 n455 gn2 2f
XPA_n457 n457 n423 ph2 ph2 sg13_lv_pmos w=1.12u l=0.13u
XPB_n457 n457 n432 ph2 ph2 sg13_lv_pmos w=1.12u l=0.13u
XNA_n457 n457 n423 m_n457 gn2 sg13_lv_nmos w=0.74u l=0.13u
XNB_n457 m_n457 n432 gn2 gn2 sg13_lv_nmos w=0.74u l=0.13u
CL_n457 n457 gn2 2f
XPA_n458 n458 n426 ph2 ph2 sg13_lv_pmos w=1.12u l=0.13u
XPB_n458 n458 n429 ph2 ph2 sg13_lv_pmos w=1.12u l=0.13u
XNA_n458 n458 n426 m_n458 gn2 sg13_lv_nmos w=0.74u l=0.13u
XNB_n458 m_n458 n429 gn2 gn2 sg13_lv_nmos w=0.74u l=0.13u
CL_n458 n458 gn2 2f
XPA_n460 n460 n423 ph2 ph2 sg13_lv_pmos w=1.12u l=0.13u
XPB_n460 n460 n429 ph2 ph2 sg13_lv_pmos w=1.12u l=0.13u
XNA_n460 n460 n423 m_n460 gn2 sg13_lv_nmos w=0.74u l=0.13u
XNB_n460 m_n460 n429 gn2 gn2 sg13_lv_nmos w=0.74u l=0.13u
CL_n460 n460 gn2 2f
XPA_n461 n461 n426 ph2 ph2 sg13_lv_pmos w=1.12u l=0.13u
XPB_n461 n461 n432 ph2 ph2 sg13_lv_pmos w=1.12u l=0.13u
XNA_n461 n461 n426 m_n461 gn2 sg13_lv_nmos w=0.74u l=0.13u
XNB_n461 m_n461 n432 gn2 gn2 sg13_lv_nmos w=0.74u l=0.13u
CL_n461 n461 gn2 2f
XPA_n463 n463 n435 ph2 ph2 sg13_lv_pmos w=1.12u l=0.13u
XPB_n463 n463 n444 ph2 ph2 sg13_lv_pmos w=1.12u l=0.13u
XNA_n463 n463 n435 m_n463 gn2 sg13_lv_nmos w=0.74u l=0.13u
XNB_n463 m_n463 n444 gn2 gn2 sg13_lv_nmos w=0.74u l=0.13u
CL_n463 n463 gn2 2f
XPA_n464 n464 n438 ph2 ph2 sg13_lv_pmos w=1.12u l=0.13u
XPB_n464 n464 n441 ph2 ph2 sg13_lv_pmos w=1.12u l=0.13u
XNA_n464 n464 n438 m_n464 gn2 sg13_lv_nmos w=0.74u l=0.13u
XNB_n464 m_n464 n441 gn2 gn2 sg13_lv_nmos w=0.74u l=0.13u
CL_n464 n464 gn2 2f
XPA_n466 n466 n435 ph2 ph2 sg13_lv_pmos w=1.12u l=0.13u
XPB_n466 n466 n441 ph2 ph2 sg13_lv_pmos w=1.12u l=0.13u
XNA_n466 n466 n435 m_n466 gn2 sg13_lv_nmos w=0.74u l=0.13u
XNB_n466 m_n466 n441 gn2 gn2 sg13_lv_nmos w=0.74u l=0.13u
CL_n466 n466 gn2 2f
XPA_n467 n467 n438 ph2 ph2 sg13_lv_pmos w=1.12u l=0.13u
XPB_n467 n467 n444 ph2 ph2 sg13_lv_pmos w=1.12u l=0.13u
XNA_n467 n467 n438 m_n467 gn2 sg13_lv_nmos w=0.74u l=0.13u
XNB_n467 m_n467 n444 gn2 gn2 sg13_lv_nmos w=0.74u l=0.13u
CL_n467 n467 gn2 2f
XPA_n619 n619 n573 ph2 ph2 sg13_lv_pmos w=1.12u l=0.13u
XPB_n619 n619 n582 ph2 ph2 sg13_lv_pmos w=1.12u l=0.13u
XNA_n619 n619 n573 m_n619 gn2 sg13_lv_nmos w=0.74u l=0.13u
XNB_n619 m_n619 n582 gn2 gn2 sg13_lv_nmos w=0.74u l=0.13u
CL_n619 n619 gn2 2f
XPA_n620 n620 n576 ph2 ph2 sg13_lv_pmos w=1.12u l=0.13u
XPB_n620 n620 n579 ph2 ph2 sg13_lv_pmos w=1.12u l=0.13u
XNA_n620 n620 n576 m_n620 gn2 sg13_lv_nmos w=0.74u l=0.13u
XNB_n620 m_n620 n579 gn2 gn2 sg13_lv_nmos w=0.74u l=0.13u
CL_n620 n620 gn2 2f
XPA_n622 n622 n573 ph2 ph2 sg13_lv_pmos w=1.12u l=0.13u
XPB_n622 n622 n579 ph2 ph2 sg13_lv_pmos w=1.12u l=0.13u
XNA_n622 n622 n573 m_n622 gn2 sg13_lv_nmos w=0.74u l=0.13u
XNB_n622 m_n622 n579 gn2 gn2 sg13_lv_nmos w=0.74u l=0.13u
CL_n622 n622 gn2 2f
XPA_n623 n623 n576 ph2 ph2 sg13_lv_pmos w=1.12u l=0.13u
XPB_n623 n623 n582 ph2 ph2 sg13_lv_pmos w=1.12u l=0.13u
XNA_n623 n623 n576 m_n623 gn2 sg13_lv_nmos w=0.74u l=0.13u
XNB_n623 m_n623 n582 gn2 gn2 sg13_lv_nmos w=0.74u l=0.13u
CL_n623 n623 gn2 2f
XPA_n625 n625 n585 ph2 ph2 sg13_lv_pmos w=1.12u l=0.13u
XPB_n625 n625 n594 ph2 ph2 sg13_lv_pmos w=1.12u l=0.13u
XNA_n625 n625 n585 m_n625 gn2 sg13_lv_nmos w=0.74u l=0.13u
XNB_n625 m_n625 n594 gn2 gn2 sg13_lv_nmos w=0.74u l=0.13u
CL_n625 n625 gn2 2f
XPA_n626 n626 n588 ph2 ph2 sg13_lv_pmos w=1.12u l=0.13u
XPB_n626 n626 n591 ph2 ph2 sg13_lv_pmos w=1.12u l=0.13u
XNA_n626 n626 n588 m_n626 gn2 sg13_lv_nmos w=0.74u l=0.13u
XNB_n626 m_n626 n591 gn2 gn2 sg13_lv_nmos w=0.74u l=0.13u
CL_n626 n626 gn2 2f
XPA_n628 n628 n585 ph2 ph2 sg13_lv_pmos w=1.12u l=0.13u
XPB_n628 n628 n591 ph2 ph2 sg13_lv_pmos w=1.12u l=0.13u
XNA_n628 n628 n585 m_n628 gn2 sg13_lv_nmos w=0.74u l=0.13u
XNB_n628 m_n628 n591 gn2 gn2 sg13_lv_nmos w=0.74u l=0.13u
CL_n628 n628 gn2 2f
XPA_n629 n629 n588 ph2 ph2 sg13_lv_pmos w=1.12u l=0.13u
XPB_n629 n629 n594 ph2 ph2 sg13_lv_pmos w=1.12u l=0.13u
XNA_n629 n629 n588 m_n629 gn2 sg13_lv_nmos w=0.74u l=0.13u
XNB_n629 m_n629 n594 gn2 gn2 sg13_lv_nmos w=0.74u l=0.13u
CL_n629 n629 gn2 2f
XPA_n631 n631 n597 ph2 ph2 sg13_lv_pmos w=1.12u l=0.13u
XPB_n631 n631 n606 ph2 ph2 sg13_lv_pmos w=1.12u l=0.13u
XNA_n631 n631 n597 m_n631 gn2 sg13_lv_nmos w=0.74u l=0.13u
XNB_n631 m_n631 n606 gn2 gn2 sg13_lv_nmos w=0.74u l=0.13u
CL_n631 n631 gn2 2f
XPA_n632 n632 n600 ph2 ph2 sg13_lv_pmos w=1.12u l=0.13u
XPB_n632 n632 n603 ph2 ph2 sg13_lv_pmos w=1.12u l=0.13u
XNA_n632 n632 n600 m_n632 gn2 sg13_lv_nmos w=0.74u l=0.13u
XNB_n632 m_n632 n603 gn2 gn2 sg13_lv_nmos w=0.74u l=0.13u
CL_n632 n632 gn2 2f
XPA_n634 n634 n597 ph2 ph2 sg13_lv_pmos w=1.12u l=0.13u
XPB_n634 n634 n603 ph2 ph2 sg13_lv_pmos w=1.12u l=0.13u
XNA_n634 n634 n597 m_n634 gn2 sg13_lv_nmos w=0.74u l=0.13u
XNB_n634 m_n634 n603 gn2 gn2 sg13_lv_nmos w=0.74u l=0.13u
CL_n634 n634 gn2 2f
XPA_n635 n635 n600 ph2 ph2 sg13_lv_pmos w=1.12u l=0.13u
XPB_n635 n635 n606 ph2 ph2 sg13_lv_pmos w=1.12u l=0.13u
XNA_n635 n635 n600 m_n635 gn2 sg13_lv_nmos w=0.74u l=0.13u
XNB_n635 m_n635 n606 gn2 gn2 sg13_lv_nmos w=0.74u l=0.13u
CL_n635 n635 gn2 2f
XPA_n637 n637 n609 ph2 ph2 sg13_lv_pmos w=1.12u l=0.13u
XPB_n637 n637 n618 ph2 ph2 sg13_lv_pmos w=1.12u l=0.13u
XNA_n637 n637 n609 m_n637 gn2 sg13_lv_nmos w=0.74u l=0.13u
XNB_n637 m_n637 n618 gn2 gn2 sg13_lv_nmos w=0.74u l=0.13u
CL_n637 n637 gn2 2f
XPA_n638 n638 n612 ph2 ph2 sg13_lv_pmos w=1.12u l=0.13u
XPB_n638 n638 n615 ph2 ph2 sg13_lv_pmos w=1.12u l=0.13u
XNA_n638 n638 n612 m_n638 gn2 sg13_lv_nmos w=0.74u l=0.13u
XNB_n638 m_n638 n615 gn2 gn2 sg13_lv_nmos w=0.74u l=0.13u
CL_n638 n638 gn2 2f
XPA_n640 n640 n609 ph2 ph2 sg13_lv_pmos w=1.12u l=0.13u
XPB_n640 n640 n615 ph2 ph2 sg13_lv_pmos w=1.12u l=0.13u
XNA_n640 n640 n609 m_n640 gn2 sg13_lv_nmos w=0.74u l=0.13u
XNB_n640 m_n640 n615 gn2 gn2 sg13_lv_nmos w=0.74u l=0.13u
CL_n640 n640 gn2 2f
XPA_n641 n641 n612 ph2 ph2 sg13_lv_pmos w=1.12u l=0.13u
XPB_n641 n641 n618 ph2 ph2 sg13_lv_pmos w=1.12u l=0.13u
XNA_n641 n641 n612 m_n641 gn2 sg13_lv_nmos w=0.74u l=0.13u
XNB_n641 m_n641 n618 gn2 gn2 sg13_lv_nmos w=0.74u l=0.13u
CL_n641 n641 gn2 2f
XPA_n769 n769 n675 ph2 ph2 sg13_lv_pmos w=1.12u l=0.13u
XPB_n769 n769 n684 ph2 ph2 sg13_lv_pmos w=1.12u l=0.13u
XNA_n769 n769 n675 m_n769 gn2 sg13_lv_nmos w=0.74u l=0.13u
XNB_n769 m_n769 n684 gn2 gn2 sg13_lv_nmos w=0.74u l=0.13u
CL_n769 n769 gn2 2f
XPA_n770 n770 n678 ph2 ph2 sg13_lv_pmos w=1.12u l=0.13u
XPB_n770 n770 n681 ph2 ph2 sg13_lv_pmos w=1.12u l=0.13u
XNA_n770 n770 n678 m_n770 gn2 sg13_lv_nmos w=0.74u l=0.13u
XNB_n770 m_n770 n681 gn2 gn2 sg13_lv_nmos w=0.74u l=0.13u
CL_n770 n770 gn2 2f
XPA_n772 n772 n675 ph2 ph2 sg13_lv_pmos w=1.12u l=0.13u
XPB_n772 n772 n681 ph2 ph2 sg13_lv_pmos w=1.12u l=0.13u
XNA_n772 n772 n675 m_n772 gn2 sg13_lv_nmos w=0.74u l=0.13u
XNB_n772 m_n772 n681 gn2 gn2 sg13_lv_nmos w=0.74u l=0.13u
CL_n772 n772 gn2 2f
XPA_n773 n773 n678 ph2 ph2 sg13_lv_pmos w=1.12u l=0.13u
XPB_n773 n773 n684 ph2 ph2 sg13_lv_pmos w=1.12u l=0.13u
XNA_n773 n773 n678 m_n773 gn2 sg13_lv_nmos w=0.74u l=0.13u
XNB_n773 m_n773 n684 gn2 gn2 sg13_lv_nmos w=0.74u l=0.13u
CL_n773 n773 gn2 2f
XPA_n823 n823 n783 ph2 ph2 sg13_lv_pmos w=1.12u l=0.13u
XPB_n823 n823 n792 ph2 ph2 sg13_lv_pmos w=1.12u l=0.13u
XNA_n823 n823 n783 m_n823 gn2 sg13_lv_nmos w=0.74u l=0.13u
XNB_n823 m_n823 n792 gn2 gn2 sg13_lv_nmos w=0.74u l=0.13u
CL_n823 n823 gn2 2f
XPA_n824 n824 n786 ph2 ph2 sg13_lv_pmos w=1.12u l=0.13u
XPB_n824 n824 n789 ph2 ph2 sg13_lv_pmos w=1.12u l=0.13u
XNA_n824 n824 n786 m_n824 gn2 sg13_lv_nmos w=0.74u l=0.13u
XNB_n824 m_n824 n789 gn2 gn2 sg13_lv_nmos w=0.74u l=0.13u
CL_n824 n824 gn2 2f
XPA_n826 n826 n783 ph2 ph2 sg13_lv_pmos w=1.12u l=0.13u
XPB_n826 n826 n789 ph2 ph2 sg13_lv_pmos w=1.12u l=0.13u
XNA_n826 n826 n783 m_n826 gn2 sg13_lv_nmos w=0.74u l=0.13u
XNB_n826 m_n826 n789 gn2 gn2 sg13_lv_nmos w=0.74u l=0.13u
CL_n826 n826 gn2 2f
XPA_n827 n827 n786 ph2 ph2 sg13_lv_pmos w=1.12u l=0.13u
XPB_n827 n827 n792 ph2 ph2 sg13_lv_pmos w=1.12u l=0.13u
XNA_n827 n827 n786 m_n827 gn2 sg13_lv_nmos w=0.74u l=0.13u
XNB_n827 m_n827 n792 gn2 gn2 sg13_lv_nmos w=0.74u l=0.13u
CL_n827 n827 gn2 2f
XPA_n829 n829 n795 ph2 ph2 sg13_lv_pmos w=1.12u l=0.13u
XPB_n829 n829 n804 ph2 ph2 sg13_lv_pmos w=1.12u l=0.13u
XNA_n829 n829 n795 m_n829 gn2 sg13_lv_nmos w=0.74u l=0.13u
XNB_n829 m_n829 n804 gn2 gn2 sg13_lv_nmos w=0.74u l=0.13u
CL_n829 n829 gn2 2f
XPA_n830 n830 n798 ph2 ph2 sg13_lv_pmos w=1.12u l=0.13u
XPB_n830 n830 n801 ph2 ph2 sg13_lv_pmos w=1.12u l=0.13u
XNA_n830 n830 n798 m_n830 gn2 sg13_lv_nmos w=0.74u l=0.13u
XNB_n830 m_n830 n801 gn2 gn2 sg13_lv_nmos w=0.74u l=0.13u
CL_n830 n830 gn2 2f
XPA_n832 n832 n795 ph2 ph2 sg13_lv_pmos w=1.12u l=0.13u
XPB_n832 n832 n801 ph2 ph2 sg13_lv_pmos w=1.12u l=0.13u
XNA_n832 n832 n795 m_n832 gn2 sg13_lv_nmos w=0.74u l=0.13u
XNB_n832 m_n832 n801 gn2 gn2 sg13_lv_nmos w=0.74u l=0.13u
CL_n832 n832 gn2 2f
XPA_n833 n833 n798 ph2 ph2 sg13_lv_pmos w=1.12u l=0.13u
XPB_n833 n833 n804 ph2 ph2 sg13_lv_pmos w=1.12u l=0.13u
XNA_n833 n833 n798 m_n833 gn2 sg13_lv_nmos w=0.74u l=0.13u
XNB_n833 m_n833 n804 gn2 gn2 sg13_lv_nmos w=0.74u l=0.13u
CL_n833 n833 gn2 2f
XPA_n835 n835 n807 ph2 ph2 sg13_lv_pmos w=1.12u l=0.13u
XPB_n835 n835 n816 ph2 ph2 sg13_lv_pmos w=1.12u l=0.13u
XNA_n835 n835 n807 m_n835 gn2 sg13_lv_nmos w=0.74u l=0.13u
XNB_n835 m_n835 n816 gn2 gn2 sg13_lv_nmos w=0.74u l=0.13u
CL_n835 n835 gn2 2f
XPA_n836 n836 n810 ph2 ph2 sg13_lv_pmos w=1.12u l=0.13u
XPB_n836 n836 n813 ph2 ph2 sg13_lv_pmos w=1.12u l=0.13u
XNA_n836 n836 n810 m_n836 gn2 sg13_lv_nmos w=0.74u l=0.13u
XNB_n836 m_n836 n813 gn2 gn2 sg13_lv_nmos w=0.74u l=0.13u
CL_n836 n836 gn2 2f
XPA_n838 n838 n807 ph2 ph2 sg13_lv_pmos w=1.12u l=0.13u
XPB_n838 n838 n813 ph2 ph2 sg13_lv_pmos w=1.12u l=0.13u
XNA_n838 n838 n807 m_n838 gn2 sg13_lv_nmos w=0.74u l=0.13u
XNB_n838 m_n838 n813 gn2 gn2 sg13_lv_nmos w=0.74u l=0.13u
CL_n838 n838 gn2 2f
XPA_n839 n839 n810 ph2 ph2 sg13_lv_pmos w=1.12u l=0.13u
XPB_n839 n839 n816 ph2 ph2 sg13_lv_pmos w=1.12u l=0.13u
XNA_n839 n839 n810 m_n839 gn2 sg13_lv_nmos w=0.74u l=0.13u
XNB_n839 m_n839 n816 gn2 gn2 sg13_lv_nmos w=0.74u l=0.13u
CL_n839 n839 gn2 2f
XPA_n991 n991 n945 ph2 ph2 sg13_lv_pmos w=1.12u l=0.13u
XPB_n991 n991 n954 ph2 ph2 sg13_lv_pmos w=1.12u l=0.13u
XNA_n991 n991 n945 m_n991 gn2 sg13_lv_nmos w=0.74u l=0.13u
XNB_n991 m_n991 n954 gn2 gn2 sg13_lv_nmos w=0.74u l=0.13u
CL_n991 n991 gn2 2f
XPA_n992 n992 n948 ph2 ph2 sg13_lv_pmos w=1.12u l=0.13u
XPB_n992 n992 n951 ph2 ph2 sg13_lv_pmos w=1.12u l=0.13u
XNA_n992 n992 n948 m_n992 gn2 sg13_lv_nmos w=0.74u l=0.13u
XNB_n992 m_n992 n951 gn2 gn2 sg13_lv_nmos w=0.74u l=0.13u
CL_n992 n992 gn2 2f
XPA_n994 n994 n945 ph2 ph2 sg13_lv_pmos w=1.12u l=0.13u
XPB_n994 n994 n951 ph2 ph2 sg13_lv_pmos w=1.12u l=0.13u
XNA_n994 n994 n945 m_n994 gn2 sg13_lv_nmos w=0.74u l=0.13u
XNB_n994 m_n994 n951 gn2 gn2 sg13_lv_nmos w=0.74u l=0.13u
CL_n994 n994 gn2 2f
XPA_n995 n995 n948 ph2 ph2 sg13_lv_pmos w=1.12u l=0.13u
XPB_n995 n995 n954 ph2 ph2 sg13_lv_pmos w=1.12u l=0.13u
XNA_n995 n995 n948 m_n995 gn2 sg13_lv_nmos w=0.74u l=0.13u
XNB_n995 m_n995 n954 gn2 gn2 sg13_lv_nmos w=0.74u l=0.13u
CL_n995 n995 gn2 2f
XPA_n997 n997 n957 ph2 ph2 sg13_lv_pmos w=1.12u l=0.13u
XPB_n997 n997 n966 ph2 ph2 sg13_lv_pmos w=1.12u l=0.13u
XNA_n997 n997 n957 m_n997 gn2 sg13_lv_nmos w=0.74u l=0.13u
XNB_n997 m_n997 n966 gn2 gn2 sg13_lv_nmos w=0.74u l=0.13u
CL_n997 n997 gn2 2f
XPA_n998 n998 n960 ph2 ph2 sg13_lv_pmos w=1.12u l=0.13u
XPB_n998 n998 n963 ph2 ph2 sg13_lv_pmos w=1.12u l=0.13u
XNA_n998 n998 n960 m_n998 gn2 sg13_lv_nmos w=0.74u l=0.13u
XNB_n998 m_n998 n963 gn2 gn2 sg13_lv_nmos w=0.74u l=0.13u
CL_n998 n998 gn2 2f
XPA_n1002 n1002 n1000 ph2 ph2 sg13_lv_pmos w=1.12u l=0.13u
XPB_n1002 n1002 n1001 ph2 ph2 sg13_lv_pmos w=1.12u l=0.13u
XNA_n1002 n1002 n1000 m_n1002 gn2 sg13_lv_nmos w=0.74u l=0.13u
XNB_n1002 m_n1002 n1001 gn2 gn2 sg13_lv_nmos w=0.74u l=0.13u
CL_n1002 n1002 gn2 2f
XPA_n1005 n1005 n1003 ph2 ph2 sg13_lv_pmos w=1.12u l=0.13u
XPB_n1005 n1005 n1004 ph2 ph2 sg13_lv_pmos w=1.12u l=0.13u
XNA_n1005 n1005 n1003 m_n1005 gn2 sg13_lv_nmos w=0.74u l=0.13u
XNB_n1005 m_n1005 n1004 gn2 gn2 sg13_lv_nmos w=0.74u l=0.13u
CL_n1005 n1005 gn2 2f
XPA_n1008 n1008 n1006 ph2 ph2 sg13_lv_pmos w=1.12u l=0.13u
XPB_n1008 n1008 n1007 ph2 ph2 sg13_lv_pmos w=1.12u l=0.13u
XNA_n1008 n1008 n1006 m_n1008 gn2 sg13_lv_nmos w=0.74u l=0.13u
XNB_n1008 m_n1008 n1007 gn2 gn2 sg13_lv_nmos w=0.74u l=0.13u
CL_n1008 n1008 gn2 2f
XPA_n1011 n1011 n1009 ph2 ph2 sg13_lv_pmos w=1.12u l=0.13u
XPB_n1011 n1011 n1010 ph2 ph2 sg13_lv_pmos w=1.12u l=0.13u
XNA_n1011 n1011 n1009 m_n1011 gn2 sg13_lv_nmos w=0.74u l=0.13u
XNB_n1011 m_n1011 n1010 gn2 gn2 sg13_lv_nmos w=0.74u l=0.13u
CL_n1011 n1011 gn2 2f
XPA_n1014 n1014 n1012 ph2 ph2 sg13_lv_pmos w=1.12u l=0.13u
XPB_n1014 n1014 n1013 ph2 ph2 sg13_lv_pmos w=1.12u l=0.13u
XNA_n1014 n1014 n1012 m_n1014 gn2 sg13_lv_nmos w=0.74u l=0.13u
XNB_n1014 m_n1014 n1013 gn2 gn2 sg13_lv_nmos w=0.74u l=0.13u
CL_n1014 n1014 gn2 2f
XPA_n111 n111 n109 ph2 ph2 sg13_lv_pmos w=1.12u l=0.13u
XPB_n111 n111 n110 ph2 ph2 sg13_lv_pmos w=1.12u l=0.13u
XNA_n111 n111 n109 m_n111 gn2 sg13_lv_nmos w=0.74u l=0.13u
XNB_n111 m_n111 n110 gn2 gn2 sg13_lv_nmos w=0.74u l=0.13u
CL_n111 n111 gn2 2f
XPA_n114 n114 n112 ph2 ph2 sg13_lv_pmos w=1.12u l=0.13u
XPB_n114 n114 n113 ph2 ph2 sg13_lv_pmos w=1.12u l=0.13u
XNA_n114 n114 n112 m_n114 gn2 sg13_lv_nmos w=0.74u l=0.13u
XNB_n114 m_n114 n113 gn2 gn2 sg13_lv_nmos w=0.74u l=0.13u
CL_n114 n114 gn2 2f
XPA_n1167 n1167 n1165 ph2 ph2 sg13_lv_pmos w=1.12u l=0.13u
XPB_n1167 n1167 n1166 ph2 ph2 sg13_lv_pmos w=1.12u l=0.13u
XNA_n1167 n1167 n1165 m_n1167 gn2 sg13_lv_nmos w=0.74u l=0.13u
XNB_n1167 m_n1167 n1166 gn2 gn2 sg13_lv_nmos w=0.74u l=0.13u
CL_n1167 n1167 gn2 2f
XPA_n117 n117 n115 ph2 ph2 sg13_lv_pmos w=1.12u l=0.13u
XPB_n117 n117 n116 ph2 ph2 sg13_lv_pmos w=1.12u l=0.13u
XNA_n117 n117 n115 m_n117 gn2 sg13_lv_nmos w=0.74u l=0.13u
XNB_n117 m_n117 n116 gn2 gn2 sg13_lv_nmos w=0.74u l=0.13u
CL_n117 n117 gn2 2f
XPA_n1170 n1170 n1168 ph2 ph2 sg13_lv_pmos w=1.12u l=0.13u
XPB_n1170 n1170 n1169 ph2 ph2 sg13_lv_pmos w=1.12u l=0.13u
XNA_n1170 n1170 n1168 m_n1170 gn2 sg13_lv_nmos w=0.74u l=0.13u
XNB_n1170 m_n1170 n1169 gn2 gn2 sg13_lv_nmos w=0.74u l=0.13u
CL_n1170 n1170 gn2 2f
XPA_n1173 n1173 n1171 ph2 ph2 sg13_lv_pmos w=1.12u l=0.13u
XPB_n1173 n1173 n1172 ph2 ph2 sg13_lv_pmos w=1.12u l=0.13u
XNA_n1173 n1173 n1171 m_n1173 gn2 sg13_lv_nmos w=0.74u l=0.13u
XNB_n1173 m_n1173 n1172 gn2 gn2 sg13_lv_nmos w=0.74u l=0.13u
CL_n1173 n1173 gn2 2f
XPA_n1176 n1176 n1174 ph2 ph2 sg13_lv_pmos w=1.12u l=0.13u
XPB_n1176 n1176 n1175 ph2 ph2 sg13_lv_pmos w=1.12u l=0.13u
XNA_n1176 n1176 n1174 m_n1176 gn2 sg13_lv_nmos w=0.74u l=0.13u
XNB_n1176 m_n1176 n1175 gn2 gn2 sg13_lv_nmos w=0.74u l=0.13u
CL_n1176 n1176 gn2 2f
XPA_n1179 n1179 n1177 ph2 ph2 sg13_lv_pmos w=1.12u l=0.13u
XPB_n1179 n1179 n1178 ph2 ph2 sg13_lv_pmos w=1.12u l=0.13u
XNA_n1179 n1179 n1177 m_n1179 gn2 sg13_lv_nmos w=0.74u l=0.13u
XNB_n1179 m_n1179 n1178 gn2 gn2 sg13_lv_nmos w=0.74u l=0.13u
CL_n1179 n1179 gn2 2f
XPA_n1182 n1182 n1180 ph2 ph2 sg13_lv_pmos w=1.12u l=0.13u
XPB_n1182 n1182 n1181 ph2 ph2 sg13_lv_pmos w=1.12u l=0.13u
XNA_n1182 n1182 n1180 m_n1182 gn2 sg13_lv_nmos w=0.74u l=0.13u
XNB_n1182 m_n1182 n1181 gn2 gn2 sg13_lv_nmos w=0.74u l=0.13u
CL_n1182 n1182 gn2 2f
XPA_n1185 n1185 n1183 ph2 ph2 sg13_lv_pmos w=1.12u l=0.13u
XPB_n1185 n1185 n1184 ph2 ph2 sg13_lv_pmos w=1.12u l=0.13u
XNA_n1185 n1185 n1183 m_n1185 gn2 sg13_lv_nmos w=0.74u l=0.13u
XNB_n1185 m_n1185 n1184 gn2 gn2 sg13_lv_nmos w=0.74u l=0.13u
CL_n1185 n1185 gn2 2f
XPA_n1188 n1188 n1186 ph2 ph2 sg13_lv_pmos w=1.12u l=0.13u
XPB_n1188 n1188 n1187 ph2 ph2 sg13_lv_pmos w=1.12u l=0.13u
XNA_n1188 n1188 n1186 m_n1188 gn2 sg13_lv_nmos w=0.74u l=0.13u
XNB_n1188 m_n1188 n1187 gn2 gn2 sg13_lv_nmos w=0.74u l=0.13u
CL_n1188 n1188 gn2 2f
XPA_n120 n120 n118 ph2 ph2 sg13_lv_pmos w=1.12u l=0.13u
XPB_n120 n120 n119 ph2 ph2 sg13_lv_pmos w=1.12u l=0.13u
XNA_n120 n120 n118 m_n120 gn2 sg13_lv_nmos w=0.74u l=0.13u
XNB_n120 m_n120 n119 gn2 gn2 sg13_lv_nmos w=0.74u l=0.13u
CL_n120 n120 gn2 2f
XPA_n123 n123 n121 ph2 ph2 sg13_lv_pmos w=1.12u l=0.13u
XPB_n123 n123 n122 ph2 ph2 sg13_lv_pmos w=1.12u l=0.13u
XNA_n123 n123 n121 m_n123 gn2 sg13_lv_nmos w=0.74u l=0.13u
XNB_n123 m_n123 n122 gn2 gn2 sg13_lv_nmos w=0.74u l=0.13u
CL_n123 n123 gn2 2f
XPA_n126 n126 n124 ph2 ph2 sg13_lv_pmos w=1.12u l=0.13u
XPB_n126 n126 n125 ph2 ph2 sg13_lv_pmos w=1.12u l=0.13u
XNA_n126 n126 n124 m_n126 gn2 sg13_lv_nmos w=0.74u l=0.13u
XNB_n126 m_n126 n125 gn2 gn2 sg13_lv_nmos w=0.74u l=0.13u
CL_n126 n126 gn2 2f
XPA_n1353 n1353 n1351 ph2 ph2 sg13_lv_pmos w=1.12u l=0.13u
XPB_n1353 n1353 n1352 ph2 ph2 sg13_lv_pmos w=1.12u l=0.13u
XNA_n1353 n1353 n1351 m_n1353 gn2 sg13_lv_nmos w=0.74u l=0.13u
XNB_n1353 m_n1353 n1352 gn2 gn2 sg13_lv_nmos w=0.74u l=0.13u
CL_n1353 n1353 gn2 2f
XPA_n1356 n1356 n1354 ph2 ph2 sg13_lv_pmos w=1.12u l=0.13u
XPB_n1356 n1356 n1355 ph2 ph2 sg13_lv_pmos w=1.12u l=0.13u
XNA_n1356 n1356 n1354 m_n1356 gn2 sg13_lv_nmos w=0.74u l=0.13u
XNB_n1356 m_n1356 n1355 gn2 gn2 sg13_lv_nmos w=0.74u l=0.13u
CL_n1356 n1356 gn2 2f
XPA_n1359 n1359 n1357 ph2 ph2 sg13_lv_pmos w=1.12u l=0.13u
XPB_n1359 n1359 n1358 ph2 ph2 sg13_lv_pmos w=1.12u l=0.13u
XNA_n1359 n1359 n1357 m_n1359 gn2 sg13_lv_nmos w=0.74u l=0.13u
XNB_n1359 m_n1359 n1358 gn2 gn2 sg13_lv_nmos w=0.74u l=0.13u
CL_n1359 n1359 gn2 2f
XPA_n1362 n1362 n1360 ph2 ph2 sg13_lv_pmos w=1.12u l=0.13u
XPB_n1362 n1362 n1361 ph2 ph2 sg13_lv_pmos w=1.12u l=0.13u
XNA_n1362 n1362 n1360 m_n1362 gn2 sg13_lv_nmos w=0.74u l=0.13u
XNB_n1362 m_n1362 n1361 gn2 gn2 sg13_lv_nmos w=0.74u l=0.13u
CL_n1362 n1362 gn2 2f
XPA_n1365 n1365 n1363 ph2 ph2 sg13_lv_pmos w=1.12u l=0.13u
XPB_n1365 n1365 n1364 ph2 ph2 sg13_lv_pmos w=1.12u l=0.13u
XNA_n1365 n1365 n1363 m_n1365 gn2 sg13_lv_nmos w=0.74u l=0.13u
XNB_n1365 m_n1365 n1364 gn2 gn2 sg13_lv_nmos w=0.74u l=0.13u
CL_n1365 n1365 gn2 2f
XPA_n1368 n1368 n1366 ph2 ph2 sg13_lv_pmos w=1.12u l=0.13u
XPB_n1368 n1368 n1367 ph2 ph2 sg13_lv_pmos w=1.12u l=0.13u
XNA_n1368 n1368 n1366 m_n1368 gn2 sg13_lv_nmos w=0.74u l=0.13u
XNB_n1368 m_n1368 n1367 gn2 gn2 sg13_lv_nmos w=0.74u l=0.13u
CL_n1368 n1368 gn2 2f
XPA_n1371 n1371 n1369 ph2 ph2 sg13_lv_pmos w=1.12u l=0.13u
XPB_n1371 n1371 n1370 ph2 ph2 sg13_lv_pmos w=1.12u l=0.13u
XNA_n1371 n1371 n1369 m_n1371 gn2 sg13_lv_nmos w=0.74u l=0.13u
XNB_n1371 m_n1371 n1370 gn2 gn2 sg13_lv_nmos w=0.74u l=0.13u
CL_n1371 n1371 gn2 2f
XPA_n1374 n1374 n1372 ph2 ph2 sg13_lv_pmos w=1.12u l=0.13u
XPB_n1374 n1374 n1373 ph2 ph2 sg13_lv_pmos w=1.12u l=0.13u
XNA_n1374 n1374 n1372 m_n1374 gn2 sg13_lv_nmos w=0.74u l=0.13u
XNB_n1374 m_n1374 n1373 gn2 gn2 sg13_lv_nmos w=0.74u l=0.13u
CL_n1374 n1374 gn2 2f
XPA_n261 n261 n259 ph2 ph2 sg13_lv_pmos w=1.12u l=0.13u
XPB_n261 n261 n260 ph2 ph2 sg13_lv_pmos w=1.12u l=0.13u
XNA_n261 n261 n259 m_n261 gn2 sg13_lv_nmos w=0.74u l=0.13u
XNB_n261 m_n261 n260 gn2 gn2 sg13_lv_nmos w=0.74u l=0.13u
CL_n261 n261 gn2 2f
XPA_n264 n264 n262 ph2 ph2 sg13_lv_pmos w=1.12u l=0.13u
XPB_n264 n264 n263 ph2 ph2 sg13_lv_pmos w=1.12u l=0.13u
XNA_n264 n264 n262 m_n264 gn2 sg13_lv_nmos w=0.74u l=0.13u
XNB_n264 m_n264 n263 gn2 gn2 sg13_lv_nmos w=0.74u l=0.13u
CL_n264 n264 gn2 2f
XPA_n267 n267 n265 ph2 ph2 sg13_lv_pmos w=1.12u l=0.13u
XPB_n267 n267 n266 ph2 ph2 sg13_lv_pmos w=1.12u l=0.13u
XNA_n267 n267 n265 m_n267 gn2 sg13_lv_nmos w=0.74u l=0.13u
XNB_n267 m_n267 n266 gn2 gn2 sg13_lv_nmos w=0.74u l=0.13u
CL_n267 n267 gn2 2f
XPA_n270 n270 n268 ph2 ph2 sg13_lv_pmos w=1.12u l=0.13u
XPB_n270 n270 n269 ph2 ph2 sg13_lv_pmos w=1.12u l=0.13u
XNA_n270 n270 n268 m_n270 gn2 sg13_lv_nmos w=0.74u l=0.13u
XNB_n270 m_n270 n269 gn2 gn2 sg13_lv_nmos w=0.74u l=0.13u
CL_n270 n270 gn2 2f
XPA_n273 n273 n271 ph2 ph2 sg13_lv_pmos w=1.12u l=0.13u
XPB_n273 n273 n272 ph2 ph2 sg13_lv_pmos w=1.12u l=0.13u
XNA_n273 n273 n271 m_n273 gn2 sg13_lv_nmos w=0.74u l=0.13u
XNB_n273 m_n273 n272 gn2 gn2 sg13_lv_nmos w=0.74u l=0.13u
CL_n273 n273 gn2 2f
XPA_n276 n276 n274 ph2 ph2 sg13_lv_pmos w=1.12u l=0.13u
XPB_n276 n276 n275 ph2 ph2 sg13_lv_pmos w=1.12u l=0.13u
XNA_n276 n276 n274 m_n276 gn2 sg13_lv_nmos w=0.74u l=0.13u
XNB_n276 m_n276 n275 gn2 gn2 sg13_lv_nmos w=0.74u l=0.13u
CL_n276 n276 gn2 2f
XPA_n447 n447 n445 ph2 ph2 sg13_lv_pmos w=1.12u l=0.13u
XPB_n447 n447 n446 ph2 ph2 sg13_lv_pmos w=1.12u l=0.13u
XNA_n447 n447 n445 m_n447 gn2 sg13_lv_nmos w=0.74u l=0.13u
XNB_n447 m_n447 n446 gn2 gn2 sg13_lv_nmos w=0.74u l=0.13u
CL_n447 n447 gn2 2f
XPA_n450 n450 n448 ph2 ph2 sg13_lv_pmos w=1.12u l=0.13u
XPB_n450 n450 n449 ph2 ph2 sg13_lv_pmos w=1.12u l=0.13u
XNA_n450 n450 n448 m_n450 gn2 sg13_lv_nmos w=0.74u l=0.13u
XNB_n450 m_n450 n449 gn2 gn2 sg13_lv_nmos w=0.74u l=0.13u
CL_n450 n450 gn2 2f
XPA_n453 n453 n451 ph2 ph2 sg13_lv_pmos w=1.12u l=0.13u
XPB_n453 n453 n452 ph2 ph2 sg13_lv_pmos w=1.12u l=0.13u
XNA_n453 n453 n451 m_n453 gn2 sg13_lv_nmos w=0.74u l=0.13u
XNB_n453 m_n453 n452 gn2 gn2 sg13_lv_nmos w=0.74u l=0.13u
CL_n453 n453 gn2 2f
XPA_n456 n456 n454 ph2 ph2 sg13_lv_pmos w=1.12u l=0.13u
XPB_n456 n456 n455 ph2 ph2 sg13_lv_pmos w=1.12u l=0.13u
XNA_n456 n456 n454 m_n456 gn2 sg13_lv_nmos w=0.74u l=0.13u
XNB_n456 m_n456 n455 gn2 gn2 sg13_lv_nmos w=0.74u l=0.13u
CL_n456 n456 gn2 2f
XPA_n459 n459 n457 ph2 ph2 sg13_lv_pmos w=1.12u l=0.13u
XPB_n459 n459 n458 ph2 ph2 sg13_lv_pmos w=1.12u l=0.13u
XNA_n459 n459 n457 m_n459 gn2 sg13_lv_nmos w=0.74u l=0.13u
XNB_n459 m_n459 n458 gn2 gn2 sg13_lv_nmos w=0.74u l=0.13u
CL_n459 n459 gn2 2f
XPA_n462 n462 n460 ph2 ph2 sg13_lv_pmos w=1.12u l=0.13u
XPB_n462 n462 n461 ph2 ph2 sg13_lv_pmos w=1.12u l=0.13u
XNA_n462 n462 n460 m_n462 gn2 sg13_lv_nmos w=0.74u l=0.13u
XNB_n462 m_n462 n461 gn2 gn2 sg13_lv_nmos w=0.74u l=0.13u
CL_n462 n462 gn2 2f
XPA_n465 n465 n463 ph2 ph2 sg13_lv_pmos w=1.12u l=0.13u
XPB_n465 n465 n464 ph2 ph2 sg13_lv_pmos w=1.12u l=0.13u
XNA_n465 n465 n463 m_n465 gn2 sg13_lv_nmos w=0.74u l=0.13u
XNB_n465 m_n465 n464 gn2 gn2 sg13_lv_nmos w=0.74u l=0.13u
CL_n465 n465 gn2 2f
XPA_n468 n468 n466 ph2 ph2 sg13_lv_pmos w=1.12u l=0.13u
XPB_n468 n468 n467 ph2 ph2 sg13_lv_pmos w=1.12u l=0.13u
XNA_n468 n468 n466 m_n468 gn2 sg13_lv_nmos w=0.74u l=0.13u
XNB_n468 m_n468 n467 gn2 gn2 sg13_lv_nmos w=0.74u l=0.13u
CL_n468 n468 gn2 2f
XPA_n621 n621 n619 ph2 ph2 sg13_lv_pmos w=1.12u l=0.13u
XPB_n621 n621 n620 ph2 ph2 sg13_lv_pmos w=1.12u l=0.13u
XNA_n621 n621 n619 m_n621 gn2 sg13_lv_nmos w=0.74u l=0.13u
XNB_n621 m_n621 n620 gn2 gn2 sg13_lv_nmos w=0.74u l=0.13u
CL_n621 n621 gn2 2f
XPA_n624 n624 n622 ph2 ph2 sg13_lv_pmos w=1.12u l=0.13u
XPB_n624 n624 n623 ph2 ph2 sg13_lv_pmos w=1.12u l=0.13u
XNA_n624 n624 n622 m_n624 gn2 sg13_lv_nmos w=0.74u l=0.13u
XNB_n624 m_n624 n623 gn2 gn2 sg13_lv_nmos w=0.74u l=0.13u
CL_n624 n624 gn2 2f
XPA_n627 n627 n625 ph2 ph2 sg13_lv_pmos w=1.12u l=0.13u
XPB_n627 n627 n626 ph2 ph2 sg13_lv_pmos w=1.12u l=0.13u
XNA_n627 n627 n625 m_n627 gn2 sg13_lv_nmos w=0.74u l=0.13u
XNB_n627 m_n627 n626 gn2 gn2 sg13_lv_nmos w=0.74u l=0.13u
CL_n627 n627 gn2 2f
XPA_n630 n630 n628 ph2 ph2 sg13_lv_pmos w=1.12u l=0.13u
XPB_n630 n630 n629 ph2 ph2 sg13_lv_pmos w=1.12u l=0.13u
XNA_n630 n630 n628 m_n630 gn2 sg13_lv_nmos w=0.74u l=0.13u
XNB_n630 m_n630 n629 gn2 gn2 sg13_lv_nmos w=0.74u l=0.13u
CL_n630 n630 gn2 2f
XPA_n633 n633 n631 ph2 ph2 sg13_lv_pmos w=1.12u l=0.13u
XPB_n633 n633 n632 ph2 ph2 sg13_lv_pmos w=1.12u l=0.13u
XNA_n633 n633 n631 m_n633 gn2 sg13_lv_nmos w=0.74u l=0.13u
XNB_n633 m_n633 n632 gn2 gn2 sg13_lv_nmos w=0.74u l=0.13u
CL_n633 n633 gn2 2f
XPA_n636 n636 n634 ph2 ph2 sg13_lv_pmos w=1.12u l=0.13u
XPB_n636 n636 n635 ph2 ph2 sg13_lv_pmos w=1.12u l=0.13u
XNA_n636 n636 n634 m_n636 gn2 sg13_lv_nmos w=0.74u l=0.13u
XNB_n636 m_n636 n635 gn2 gn2 sg13_lv_nmos w=0.74u l=0.13u
CL_n636 n636 gn2 2f
XPA_n639 n639 n637 ph2 ph2 sg13_lv_pmos w=1.12u l=0.13u
XPB_n639 n639 n638 ph2 ph2 sg13_lv_pmos w=1.12u l=0.13u
XNA_n639 n639 n637 m_n639 gn2 sg13_lv_nmos w=0.74u l=0.13u
XNB_n639 m_n639 n638 gn2 gn2 sg13_lv_nmos w=0.74u l=0.13u
CL_n639 n639 gn2 2f
XPA_n642 n642 n640 ph2 ph2 sg13_lv_pmos w=1.12u l=0.13u
XPB_n642 n642 n641 ph2 ph2 sg13_lv_pmos w=1.12u l=0.13u
XNA_n642 n642 n640 m_n642 gn2 sg13_lv_nmos w=0.74u l=0.13u
XNB_n642 m_n642 n641 gn2 gn2 sg13_lv_nmos w=0.74u l=0.13u
CL_n642 n642 gn2 2f
XPA_n771 n771 n769 ph2 ph2 sg13_lv_pmos w=1.12u l=0.13u
XPB_n771 n771 n770 ph2 ph2 sg13_lv_pmos w=1.12u l=0.13u
XNA_n771 n771 n769 m_n771 gn2 sg13_lv_nmos w=0.74u l=0.13u
XNB_n771 m_n771 n770 gn2 gn2 sg13_lv_nmos w=0.74u l=0.13u
CL_n771 n771 gn2 2f
XPA_n774 n774 n772 ph2 ph2 sg13_lv_pmos w=1.12u l=0.13u
XPB_n774 n774 n773 ph2 ph2 sg13_lv_pmos w=1.12u l=0.13u
XNA_n774 n774 n772 m_n774 gn2 sg13_lv_nmos w=0.74u l=0.13u
XNB_n774 m_n774 n773 gn2 gn2 sg13_lv_nmos w=0.74u l=0.13u
CL_n774 n774 gn2 2f
XPA_n825 n825 n823 ph2 ph2 sg13_lv_pmos w=1.12u l=0.13u
XPB_n825 n825 n824 ph2 ph2 sg13_lv_pmos w=1.12u l=0.13u
XNA_n825 n825 n823 m_n825 gn2 sg13_lv_nmos w=0.74u l=0.13u
XNB_n825 m_n825 n824 gn2 gn2 sg13_lv_nmos w=0.74u l=0.13u
CL_n825 n825 gn2 2f
XPA_n828 n828 n826 ph2 ph2 sg13_lv_pmos w=1.12u l=0.13u
XPB_n828 n828 n827 ph2 ph2 sg13_lv_pmos w=1.12u l=0.13u
XNA_n828 n828 n826 m_n828 gn2 sg13_lv_nmos w=0.74u l=0.13u
XNB_n828 m_n828 n827 gn2 gn2 sg13_lv_nmos w=0.74u l=0.13u
CL_n828 n828 gn2 2f
XPA_n831 n831 n829 ph2 ph2 sg13_lv_pmos w=1.12u l=0.13u
XPB_n831 n831 n830 ph2 ph2 sg13_lv_pmos w=1.12u l=0.13u
XNA_n831 n831 n829 m_n831 gn2 sg13_lv_nmos w=0.74u l=0.13u
XNB_n831 m_n831 n830 gn2 gn2 sg13_lv_nmos w=0.74u l=0.13u
CL_n831 n831 gn2 2f
XPA_n834 n834 n832 ph2 ph2 sg13_lv_pmos w=1.12u l=0.13u
XPB_n834 n834 n833 ph2 ph2 sg13_lv_pmos w=1.12u l=0.13u
XNA_n834 n834 n832 m_n834 gn2 sg13_lv_nmos w=0.74u l=0.13u
XNB_n834 m_n834 n833 gn2 gn2 sg13_lv_nmos w=0.74u l=0.13u
CL_n834 n834 gn2 2f
XPA_n837 n837 n835 ph2 ph2 sg13_lv_pmos w=1.12u l=0.13u
XPB_n837 n837 n836 ph2 ph2 sg13_lv_pmos w=1.12u l=0.13u
XNA_n837 n837 n835 m_n837 gn2 sg13_lv_nmos w=0.74u l=0.13u
XNB_n837 m_n837 n836 gn2 gn2 sg13_lv_nmos w=0.74u l=0.13u
CL_n837 n837 gn2 2f
XPA_n840 n840 n838 ph2 ph2 sg13_lv_pmos w=1.12u l=0.13u
XPB_n840 n840 n839 ph2 ph2 sg13_lv_pmos w=1.12u l=0.13u
XNA_n840 n840 n838 m_n840 gn2 sg13_lv_nmos w=0.74u l=0.13u
XNB_n840 m_n840 n839 gn2 gn2 sg13_lv_nmos w=0.74u l=0.13u
CL_n840 n840 gn2 2f
XPA_n993 n993 n991 ph2 ph2 sg13_lv_pmos w=1.12u l=0.13u
XPB_n993 n993 n992 ph2 ph2 sg13_lv_pmos w=1.12u l=0.13u
XNA_n993 n993 n991 m_n993 gn2 sg13_lv_nmos w=0.74u l=0.13u
XNB_n993 m_n993 n992 gn2 gn2 sg13_lv_nmos w=0.74u l=0.13u
CL_n993 n993 gn2 2f
XPA_n996 n996 n994 ph2 ph2 sg13_lv_pmos w=1.12u l=0.13u
XPB_n996 n996 n995 ph2 ph2 sg13_lv_pmos w=1.12u l=0.13u
XNA_n996 n996 n994 m_n996 gn2 sg13_lv_nmos w=0.74u l=0.13u
XNB_n996 m_n996 n995 gn2 gn2 sg13_lv_nmos w=0.74u l=0.13u
CL_n996 n996 gn2 2f
XPA_n999 n999 n997 ph2 ph2 sg13_lv_pmos w=1.12u l=0.13u
XPB_n999 n999 n998 ph2 ph2 sg13_lv_pmos w=1.12u l=0.13u
XNA_n999 n999 n997 m_n999 gn2 sg13_lv_nmos w=0.74u l=0.13u
XNB_n999 m_n999 n998 gn2 gn2 sg13_lv_nmos w=0.74u l=0.13u
CL_n999 n999 gn2 2f
XPA_n1015 n1015 n993 ph3 ph3 sg13_lv_pmos w=1.12u l=0.13u
XPB_n1015 n1015 n1002 ph3 ph3 sg13_lv_pmos w=1.12u l=0.13u
XNA_n1015 n1015 n993 m_n1015 gn3 sg13_lv_nmos w=0.74u l=0.13u
XNB_n1015 m_n1015 n1002 gn3 gn3 sg13_lv_nmos w=0.74u l=0.13u
CL_n1015 n1015 gn3 2f
XPA_n1016 n1016 n996 ph3 ph3 sg13_lv_pmos w=1.12u l=0.13u
XPB_n1016 n1016 n999 ph3 ph3 sg13_lv_pmos w=1.12u l=0.13u
XNA_n1016 n1016 n996 m_n1016 gn3 sg13_lv_nmos w=0.74u l=0.13u
XNB_n1016 m_n1016 n999 gn3 gn3 sg13_lv_nmos w=0.74u l=0.13u
CL_n1016 n1016 gn3 2f
XPA_n1018 n1018 n993 ph3 ph3 sg13_lv_pmos w=1.12u l=0.13u
XPB_n1018 n1018 n999 ph3 ph3 sg13_lv_pmos w=1.12u l=0.13u
XNA_n1018 n1018 n993 m_n1018 gn3 sg13_lv_nmos w=0.74u l=0.13u
XNB_n1018 m_n1018 n999 gn3 gn3 sg13_lv_nmos w=0.74u l=0.13u
CL_n1018 n1018 gn3 2f
XPA_n1019 n1019 n996 ph3 ph3 sg13_lv_pmos w=1.12u l=0.13u
XPB_n1019 n1019 n1002 ph3 ph3 sg13_lv_pmos w=1.12u l=0.13u
XNA_n1019 n1019 n996 m_n1019 gn3 sg13_lv_nmos w=0.74u l=0.13u
XNB_n1019 m_n1019 n1002 gn3 gn3 sg13_lv_nmos w=0.74u l=0.13u
CL_n1019 n1019 gn3 2f
XPA_n1021 n1021 n1005 ph3 ph3 sg13_lv_pmos w=1.12u l=0.13u
XPB_n1021 n1021 n1014 ph3 ph3 sg13_lv_pmos w=1.12u l=0.13u
XNA_n1021 n1021 n1005 m_n1021 gn3 sg13_lv_nmos w=0.74u l=0.13u
XNB_n1021 m_n1021 n1014 gn3 gn3 sg13_lv_nmos w=0.74u l=0.13u
CL_n1021 n1021 gn3 2f
XPA_n1022 n1022 n1008 ph3 ph3 sg13_lv_pmos w=1.12u l=0.13u
XPB_n1022 n1022 n1011 ph3 ph3 sg13_lv_pmos w=1.12u l=0.13u
XNA_n1022 n1022 n1008 m_n1022 gn3 sg13_lv_nmos w=0.74u l=0.13u
XNB_n1022 m_n1022 n1011 gn3 gn3 sg13_lv_nmos w=0.74u l=0.13u
CL_n1022 n1022 gn3 2f
XPA_n1024 n1024 n1005 ph3 ph3 sg13_lv_pmos w=1.12u l=0.13u
XPB_n1024 n1024 n1011 ph3 ph3 sg13_lv_pmos w=1.12u l=0.13u
XNA_n1024 n1024 n1005 m_n1024 gn3 sg13_lv_nmos w=0.74u l=0.13u
XNB_n1024 m_n1024 n1011 gn3 gn3 sg13_lv_nmos w=0.74u l=0.13u
CL_n1024 n1024 gn3 2f
XPA_n1025 n1025 n1008 ph3 ph3 sg13_lv_pmos w=1.12u l=0.13u
XPB_n1025 n1025 n1014 ph3 ph3 sg13_lv_pmos w=1.12u l=0.13u
XNA_n1025 n1025 n1008 m_n1025 gn3 sg13_lv_nmos w=0.74u l=0.13u
XNB_n1025 m_n1025 n1014 gn3 gn3 sg13_lv_nmos w=0.74u l=0.13u
CL_n1025 n1025 gn3 2f
XPA_n1189 n1189 n1167 ph3 ph3 sg13_lv_pmos w=1.12u l=0.13u
XPB_n1189 n1189 n1176 ph3 ph3 sg13_lv_pmos w=1.12u l=0.13u
XNA_n1189 n1189 n1167 m_n1189 gn3 sg13_lv_nmos w=0.74u l=0.13u
XNB_n1189 m_n1189 n1176 gn3 gn3 sg13_lv_nmos w=0.74u l=0.13u
CL_n1189 n1189 gn3 2f
XPA_n1190 n1190 n1170 ph3 ph3 sg13_lv_pmos w=1.12u l=0.13u
XPB_n1190 n1190 n1173 ph3 ph3 sg13_lv_pmos w=1.12u l=0.13u
XNA_n1190 n1190 n1170 m_n1190 gn3 sg13_lv_nmos w=0.74u l=0.13u
XNB_n1190 m_n1190 n1173 gn3 gn3 sg13_lv_nmos w=0.74u l=0.13u
CL_n1190 n1190 gn3 2f
XPA_n1192 n1192 n1167 ph3 ph3 sg13_lv_pmos w=1.12u l=0.13u
XPB_n1192 n1192 n1173 ph3 ph3 sg13_lv_pmos w=1.12u l=0.13u
XNA_n1192 n1192 n1167 m_n1192 gn3 sg13_lv_nmos w=0.74u l=0.13u
XNB_n1192 m_n1192 n1173 gn3 gn3 sg13_lv_nmos w=0.74u l=0.13u
CL_n1192 n1192 gn3 2f
XPA_n1193 n1193 n1170 ph3 ph3 sg13_lv_pmos w=1.12u l=0.13u
XPB_n1193 n1193 n1176 ph3 ph3 sg13_lv_pmos w=1.12u l=0.13u
XNA_n1193 n1193 n1170 m_n1193 gn3 sg13_lv_nmos w=0.74u l=0.13u
XNB_n1193 m_n1193 n1176 gn3 gn3 sg13_lv_nmos w=0.74u l=0.13u
CL_n1193 n1193 gn3 2f
XPA_n1195 n1195 n1179 ph3 ph3 sg13_lv_pmos w=1.12u l=0.13u
XPB_n1195 n1195 n1188 ph3 ph3 sg13_lv_pmos w=1.12u l=0.13u
XNA_n1195 n1195 n1179 m_n1195 gn3 sg13_lv_nmos w=0.74u l=0.13u
XNB_n1195 m_n1195 n1188 gn3 gn3 sg13_lv_nmos w=0.74u l=0.13u
CL_n1195 n1195 gn3 2f
XPA_n1196 n1196 n1182 ph3 ph3 sg13_lv_pmos w=1.12u l=0.13u
XPB_n1196 n1196 n1185 ph3 ph3 sg13_lv_pmos w=1.12u l=0.13u
XNA_n1196 n1196 n1182 m_n1196 gn3 sg13_lv_nmos w=0.74u l=0.13u
XNB_n1196 m_n1196 n1185 gn3 gn3 sg13_lv_nmos w=0.74u l=0.13u
CL_n1196 n1196 gn3 2f
XPA_n1198 n1198 n1179 ph3 ph3 sg13_lv_pmos w=1.12u l=0.13u
XPB_n1198 n1198 n1185 ph3 ph3 sg13_lv_pmos w=1.12u l=0.13u
XNA_n1198 n1198 n1179 m_n1198 gn3 sg13_lv_nmos w=0.74u l=0.13u
XNB_n1198 m_n1198 n1185 gn3 gn3 sg13_lv_nmos w=0.74u l=0.13u
CL_n1198 n1198 gn3 2f
XPA_n1199 n1199 n1182 ph3 ph3 sg13_lv_pmos w=1.12u l=0.13u
XPB_n1199 n1199 n1188 ph3 ph3 sg13_lv_pmos w=1.12u l=0.13u
XNA_n1199 n1199 n1182 m_n1199 gn3 sg13_lv_nmos w=0.74u l=0.13u
XNB_n1199 m_n1199 n1188 gn3 gn3 sg13_lv_nmos w=0.74u l=0.13u
CL_n1199 n1199 gn3 2f
XPA_n133 n133 n111 ph3 ph3 sg13_lv_pmos w=1.12u l=0.13u
XPB_n133 n133 n120 ph3 ph3 sg13_lv_pmos w=1.12u l=0.13u
XNA_n133 n133 n111 m_n133 gn3 sg13_lv_nmos w=0.74u l=0.13u
XNB_n133 m_n133 n120 gn3 gn3 sg13_lv_nmos w=0.74u l=0.13u
CL_n133 n133 gn3 2f
XPA_n134 n134 n114 ph3 ph3 sg13_lv_pmos w=1.12u l=0.13u
XPB_n134 n134 n117 ph3 ph3 sg13_lv_pmos w=1.12u l=0.13u
XNA_n134 n134 n114 m_n134 gn3 sg13_lv_nmos w=0.74u l=0.13u
XNB_n134 m_n134 n117 gn3 gn3 sg13_lv_nmos w=0.74u l=0.13u
CL_n134 n134 gn3 2f
XPA_n136 n136 n111 ph3 ph3 sg13_lv_pmos w=1.12u l=0.13u
XPB_n136 n136 n117 ph3 ph3 sg13_lv_pmos w=1.12u l=0.13u
XNA_n136 n136 n111 m_n136 gn3 sg13_lv_nmos w=0.74u l=0.13u
XNB_n136 m_n136 n117 gn3 gn3 sg13_lv_nmos w=0.74u l=0.13u
CL_n136 n136 gn3 2f
XPA_n137 n137 n114 ph3 ph3 sg13_lv_pmos w=1.12u l=0.13u
XPB_n137 n137 n120 ph3 ph3 sg13_lv_pmos w=1.12u l=0.13u
XNA_n137 n137 n114 m_n137 gn3 sg13_lv_nmos w=0.74u l=0.13u
XNB_n137 m_n137 n120 gn3 gn3 sg13_lv_nmos w=0.74u l=0.13u
CL_n137 n137 gn3 2f
XPA_n1375 n1375 n1353 ph3 ph3 sg13_lv_pmos w=1.12u l=0.13u
XPB_n1375 n1375 n1362 ph3 ph3 sg13_lv_pmos w=1.12u l=0.13u
XNA_n1375 n1375 n1353 m_n1375 gn3 sg13_lv_nmos w=0.74u l=0.13u
XNB_n1375 m_n1375 n1362 gn3 gn3 sg13_lv_nmos w=0.74u l=0.13u
CL_n1375 n1375 gn3 2f
XPA_n1376 n1376 n1356 ph3 ph3 sg13_lv_pmos w=1.12u l=0.13u
XPB_n1376 n1376 n1359 ph3 ph3 sg13_lv_pmos w=1.12u l=0.13u
XNA_n1376 n1376 n1356 m_n1376 gn3 sg13_lv_nmos w=0.74u l=0.13u
XNB_n1376 m_n1376 n1359 gn3 gn3 sg13_lv_nmos w=0.74u l=0.13u
CL_n1376 n1376 gn3 2f
XPA_n1378 n1378 n1353 ph3 ph3 sg13_lv_pmos w=1.12u l=0.13u
XPB_n1378 n1378 n1359 ph3 ph3 sg13_lv_pmos w=1.12u l=0.13u
XNA_n1378 n1378 n1353 m_n1378 gn3 sg13_lv_nmos w=0.74u l=0.13u
XNB_n1378 m_n1378 n1359 gn3 gn3 sg13_lv_nmos w=0.74u l=0.13u
CL_n1378 n1378 gn3 2f
XPA_n1379 n1379 n1356 ph3 ph3 sg13_lv_pmos w=1.12u l=0.13u
XPB_n1379 n1379 n1362 ph3 ph3 sg13_lv_pmos w=1.12u l=0.13u
XNA_n1379 n1379 n1356 m_n1379 gn3 sg13_lv_nmos w=0.74u l=0.13u
XNB_n1379 m_n1379 n1362 gn3 gn3 sg13_lv_nmos w=0.74u l=0.13u
CL_n1379 n1379 gn3 2f
XPA_n1381 n1381 n1365 ph3 ph3 sg13_lv_pmos w=1.12u l=0.13u
XPB_n1381 n1381 n1374 ph3 ph3 sg13_lv_pmos w=1.12u l=0.13u
XNA_n1381 n1381 n1365 m_n1381 gn3 sg13_lv_nmos w=0.74u l=0.13u
XNB_n1381 m_n1381 n1374 gn3 gn3 sg13_lv_nmos w=0.74u l=0.13u
CL_n1381 n1381 gn3 2f
XPA_n1382 n1382 n1368 ph3 ph3 sg13_lv_pmos w=1.12u l=0.13u
XPB_n1382 n1382 n1371 ph3 ph3 sg13_lv_pmos w=1.12u l=0.13u
XNA_n1382 n1382 n1368 m_n1382 gn3 sg13_lv_nmos w=0.74u l=0.13u
XNB_n1382 m_n1382 n1371 gn3 gn3 sg13_lv_nmos w=0.74u l=0.13u
CL_n1382 n1382 gn3 2f
XPA_n1384 n1384 n1365 ph3 ph3 sg13_lv_pmos w=1.12u l=0.13u
XPB_n1384 n1384 n1371 ph3 ph3 sg13_lv_pmos w=1.12u l=0.13u
XNA_n1384 n1384 n1365 m_n1384 gn3 sg13_lv_nmos w=0.74u l=0.13u
XNB_n1384 m_n1384 n1371 gn3 gn3 sg13_lv_nmos w=0.74u l=0.13u
CL_n1384 n1384 gn3 2f
XPA_n1385 n1385 n1368 ph3 ph3 sg13_lv_pmos w=1.12u l=0.13u
XPB_n1385 n1385 n1374 ph3 ph3 sg13_lv_pmos w=1.12u l=0.13u
XNA_n1385 n1385 n1368 m_n1385 gn3 sg13_lv_nmos w=0.74u l=0.13u
XNB_n1385 m_n1385 n1374 gn3 gn3 sg13_lv_nmos w=0.74u l=0.13u
CL_n1385 n1385 gn3 2f
XPA_n139 n139 n123 ph3 ph3 sg13_lv_pmos w=1.12u l=0.13u
XPB_n139 n139 n132 ph3 ph3 sg13_lv_pmos w=1.12u l=0.13u
XNA_n139 n139 n123 m_n139 gn3 sg13_lv_nmos w=0.74u l=0.13u
XNB_n139 m_n139 n132 gn3 gn3 sg13_lv_nmos w=0.74u l=0.13u
CL_n139 n139 gn3 2f
XPA_n140 n140 n126 ph3 ph3 sg13_lv_pmos w=1.12u l=0.13u
XPB_n140 n140 n129 ph3 ph3 sg13_lv_pmos w=1.12u l=0.13u
XNA_n140 n140 n126 m_n140 gn3 sg13_lv_nmos w=0.74u l=0.13u
XNB_n140 m_n140 n129 gn3 gn3 sg13_lv_nmos w=0.74u l=0.13u
CL_n140 n140 gn3 2f
XPA_n142 n142 n123 ph3 ph3 sg13_lv_pmos w=1.12u l=0.13u
XPB_n142 n142 n129 ph3 ph3 sg13_lv_pmos w=1.12u l=0.13u
XNA_n142 n142 n123 m_n142 gn3 sg13_lv_nmos w=0.74u l=0.13u
XNB_n142 m_n142 n129 gn3 gn3 sg13_lv_nmos w=0.74u l=0.13u
CL_n142 n142 gn3 2f
XPA_n143 n143 n126 ph3 ph3 sg13_lv_pmos w=1.12u l=0.13u
XPB_n143 n143 n132 ph3 ph3 sg13_lv_pmos w=1.12u l=0.13u
XNA_n143 n143 n126 m_n143 gn3 sg13_lv_nmos w=0.74u l=0.13u
XNB_n143 m_n143 n132 gn3 gn3 sg13_lv_nmos w=0.74u l=0.13u
CL_n143 n143 gn3 2f
XPA_n283 n283 n261 ph3 ph3 sg13_lv_pmos w=1.12u l=0.13u
XPB_n283 n283 n270 ph3 ph3 sg13_lv_pmos w=1.12u l=0.13u
XNA_n283 n283 n261 m_n283 gn3 sg13_lv_nmos w=0.74u l=0.13u
XNB_n283 m_n283 n270 gn3 gn3 sg13_lv_nmos w=0.74u l=0.13u
CL_n283 n283 gn3 2f
XPA_n284 n284 n264 ph3 ph3 sg13_lv_pmos w=1.12u l=0.13u
XPB_n284 n284 n267 ph3 ph3 sg13_lv_pmos w=1.12u l=0.13u
XNA_n284 n284 n264 m_n284 gn3 sg13_lv_nmos w=0.74u l=0.13u
XNB_n284 m_n284 n267 gn3 gn3 sg13_lv_nmos w=0.74u l=0.13u
CL_n284 n284 gn3 2f
XPA_n286 n286 n261 ph3 ph3 sg13_lv_pmos w=1.12u l=0.13u
XPB_n286 n286 n267 ph3 ph3 sg13_lv_pmos w=1.12u l=0.13u
XNA_n286 n286 n261 m_n286 gn3 sg13_lv_nmos w=0.74u l=0.13u
XNB_n286 m_n286 n267 gn3 gn3 sg13_lv_nmos w=0.74u l=0.13u
CL_n286 n286 gn3 2f
XPA_n287 n287 n264 ph3 ph3 sg13_lv_pmos w=1.12u l=0.13u
XPB_n287 n287 n270 ph3 ph3 sg13_lv_pmos w=1.12u l=0.13u
XNA_n287 n287 n264 m_n287 gn3 sg13_lv_nmos w=0.74u l=0.13u
XNB_n287 m_n287 n270 gn3 gn3 sg13_lv_nmos w=0.74u l=0.13u
CL_n287 n287 gn3 2f
XPA_n289 n289 n273 ph3 ph3 sg13_lv_pmos w=1.12u l=0.13u
XPB_n289 n289 n282 ph3 ph3 sg13_lv_pmos w=1.12u l=0.13u
XNA_n289 n289 n273 m_n289 gn3 sg13_lv_nmos w=0.74u l=0.13u
XNB_n289 m_n289 n282 gn3 gn3 sg13_lv_nmos w=0.74u l=0.13u
CL_n289 n289 gn3 2f
XPA_n290 n290 n276 ph3 ph3 sg13_lv_pmos w=1.12u l=0.13u
XPB_n290 n290 n279 ph3 ph3 sg13_lv_pmos w=1.12u l=0.13u
XNA_n290 n290 n276 m_n290 gn3 sg13_lv_nmos w=0.74u l=0.13u
XNB_n290 m_n290 n279 gn3 gn3 sg13_lv_nmos w=0.74u l=0.13u
CL_n290 n290 gn3 2f
XPA_n292 n292 n273 ph3 ph3 sg13_lv_pmos w=1.12u l=0.13u
XPB_n292 n292 n279 ph3 ph3 sg13_lv_pmos w=1.12u l=0.13u
XNA_n292 n292 n273 m_n292 gn3 sg13_lv_nmos w=0.74u l=0.13u
XNB_n292 m_n292 n279 gn3 gn3 sg13_lv_nmos w=0.74u l=0.13u
CL_n292 n292 gn3 2f
XPA_n293 n293 n276 ph3 ph3 sg13_lv_pmos w=1.12u l=0.13u
XPB_n293 n293 n282 ph3 ph3 sg13_lv_pmos w=1.12u l=0.13u
XNA_n293 n293 n276 m_n293 gn3 sg13_lv_nmos w=0.74u l=0.13u
XNB_n293 m_n293 n282 gn3 gn3 sg13_lv_nmos w=0.74u l=0.13u
CL_n293 n293 gn3 2f
XPA_n469 n469 n447 ph3 ph3 sg13_lv_pmos w=1.12u l=0.13u
XPB_n469 n469 n456 ph3 ph3 sg13_lv_pmos w=1.12u l=0.13u
XNA_n469 n469 n447 m_n469 gn3 sg13_lv_nmos w=0.74u l=0.13u
XNB_n469 m_n469 n456 gn3 gn3 sg13_lv_nmos w=0.74u l=0.13u
CL_n469 n469 gn3 2f
XPA_n470 n470 n450 ph3 ph3 sg13_lv_pmos w=1.12u l=0.13u
XPB_n470 n470 n453 ph3 ph3 sg13_lv_pmos w=1.12u l=0.13u
XNA_n470 n470 n450 m_n470 gn3 sg13_lv_nmos w=0.74u l=0.13u
XNB_n470 m_n470 n453 gn3 gn3 sg13_lv_nmos w=0.74u l=0.13u
CL_n470 n470 gn3 2f
XPA_n472 n472 n447 ph3 ph3 sg13_lv_pmos w=1.12u l=0.13u
XPB_n472 n472 n453 ph3 ph3 sg13_lv_pmos w=1.12u l=0.13u
XNA_n472 n472 n447 m_n472 gn3 sg13_lv_nmos w=0.74u l=0.13u
XNB_n472 m_n472 n453 gn3 gn3 sg13_lv_nmos w=0.74u l=0.13u
CL_n472 n472 gn3 2f
XPA_n473 n473 n450 ph3 ph3 sg13_lv_pmos w=1.12u l=0.13u
XPB_n473 n473 n456 ph3 ph3 sg13_lv_pmos w=1.12u l=0.13u
XNA_n473 n473 n450 m_n473 gn3 sg13_lv_nmos w=0.74u l=0.13u
XNB_n473 m_n473 n456 gn3 gn3 sg13_lv_nmos w=0.74u l=0.13u
CL_n473 n473 gn3 2f
XPA_n475 n475 n459 ph3 ph3 sg13_lv_pmos w=1.12u l=0.13u
XPB_n475 n475 n468 ph3 ph3 sg13_lv_pmos w=1.12u l=0.13u
XNA_n475 n475 n459 m_n475 gn3 sg13_lv_nmos w=0.74u l=0.13u
XNB_n475 m_n475 n468 gn3 gn3 sg13_lv_nmos w=0.74u l=0.13u
CL_n475 n475 gn3 2f
XPA_n476 n476 n462 ph3 ph3 sg13_lv_pmos w=1.12u l=0.13u
XPB_n476 n476 n465 ph3 ph3 sg13_lv_pmos w=1.12u l=0.13u
XNA_n476 n476 n462 m_n476 gn3 sg13_lv_nmos w=0.74u l=0.13u
XNB_n476 m_n476 n465 gn3 gn3 sg13_lv_nmos w=0.74u l=0.13u
CL_n476 n476 gn3 2f
XPA_n478 n478 n459 ph3 ph3 sg13_lv_pmos w=1.12u l=0.13u
XPB_n478 n478 n465 ph3 ph3 sg13_lv_pmos w=1.12u l=0.13u
XNA_n478 n478 n459 m_n478 gn3 sg13_lv_nmos w=0.74u l=0.13u
XNB_n478 m_n478 n465 gn3 gn3 sg13_lv_nmos w=0.74u l=0.13u
CL_n478 n478 gn3 2f
XPA_n479 n479 n462 ph3 ph3 sg13_lv_pmos w=1.12u l=0.13u
XPB_n479 n479 n468 ph3 ph3 sg13_lv_pmos w=1.12u l=0.13u
XNA_n479 n479 n462 m_n479 gn3 sg13_lv_nmos w=0.74u l=0.13u
XNB_n479 m_n479 n468 gn3 gn3 sg13_lv_nmos w=0.74u l=0.13u
CL_n479 n479 gn3 2f
XPA_n643 n643 n621 ph3 ph3 sg13_lv_pmos w=1.12u l=0.13u
XPB_n643 n643 n630 ph3 ph3 sg13_lv_pmos w=1.12u l=0.13u
XNA_n643 n643 n621 m_n643 gn3 sg13_lv_nmos w=0.74u l=0.13u
XNB_n643 m_n643 n630 gn3 gn3 sg13_lv_nmos w=0.74u l=0.13u
CL_n643 n643 gn3 2f
XPA_n644 n644 n624 ph3 ph3 sg13_lv_pmos w=1.12u l=0.13u
XPB_n644 n644 n627 ph3 ph3 sg13_lv_pmos w=1.12u l=0.13u
XNA_n644 n644 n624 m_n644 gn3 sg13_lv_nmos w=0.74u l=0.13u
XNB_n644 m_n644 n627 gn3 gn3 sg13_lv_nmos w=0.74u l=0.13u
CL_n644 n644 gn3 2f
XPA_n646 n646 n621 ph3 ph3 sg13_lv_pmos w=1.12u l=0.13u
XPB_n646 n646 n627 ph3 ph3 sg13_lv_pmos w=1.12u l=0.13u
XNA_n646 n646 n621 m_n646 gn3 sg13_lv_nmos w=0.74u l=0.13u
XNB_n646 m_n646 n627 gn3 gn3 sg13_lv_nmos w=0.74u l=0.13u
CL_n646 n646 gn3 2f
XPA_n647 n647 n624 ph3 ph3 sg13_lv_pmos w=1.12u l=0.13u
XPB_n647 n647 n630 ph3 ph3 sg13_lv_pmos w=1.12u l=0.13u
XNA_n647 n647 n624 m_n647 gn3 sg13_lv_nmos w=0.74u l=0.13u
XNB_n647 m_n647 n630 gn3 gn3 sg13_lv_nmos w=0.74u l=0.13u
CL_n647 n647 gn3 2f
XPA_n649 n649 n633 ph3 ph3 sg13_lv_pmos w=1.12u l=0.13u
XPB_n649 n649 n642 ph3 ph3 sg13_lv_pmos w=1.12u l=0.13u
XNA_n649 n649 n633 m_n649 gn3 sg13_lv_nmos w=0.74u l=0.13u
XNB_n649 m_n649 n642 gn3 gn3 sg13_lv_nmos w=0.74u l=0.13u
CL_n649 n649 gn3 2f
XPA_n650 n650 n636 ph3 ph3 sg13_lv_pmos w=1.12u l=0.13u
XPB_n650 n650 n639 ph3 ph3 sg13_lv_pmos w=1.12u l=0.13u
XNA_n650 n650 n636 m_n650 gn3 sg13_lv_nmos w=0.74u l=0.13u
XNB_n650 m_n650 n639 gn3 gn3 sg13_lv_nmos w=0.74u l=0.13u
CL_n650 n650 gn3 2f
XPA_n652 n652 n633 ph3 ph3 sg13_lv_pmos w=1.12u l=0.13u
XPB_n652 n652 n639 ph3 ph3 sg13_lv_pmos w=1.12u l=0.13u
XNA_n652 n652 n633 m_n652 gn3 sg13_lv_nmos w=0.74u l=0.13u
XNB_n652 m_n652 n639 gn3 gn3 sg13_lv_nmos w=0.74u l=0.13u
CL_n652 n652 gn3 2f
XPA_n653 n653 n636 ph3 ph3 sg13_lv_pmos w=1.12u l=0.13u
XPB_n653 n653 n642 ph3 ph3 sg13_lv_pmos w=1.12u l=0.13u
XNA_n653 n653 n636 m_n653 gn3 sg13_lv_nmos w=0.74u l=0.13u
XNB_n653 m_n653 n642 gn3 gn3 sg13_lv_nmos w=0.74u l=0.13u
CL_n653 n653 gn3 2f
XPA_n817 n817 n771 ph3 ph3 sg13_lv_pmos w=1.12u l=0.13u
XPB_n817 n817 n780 ph3 ph3 sg13_lv_pmos w=1.12u l=0.13u
XNA_n817 n817 n771 m_n817 gn3 sg13_lv_nmos w=0.74u l=0.13u
XNB_n817 m_n817 n780 gn3 gn3 sg13_lv_nmos w=0.74u l=0.13u
CL_n817 n817 gn3 2f
XPA_n818 n818 n774 ph3 ph3 sg13_lv_pmos w=1.12u l=0.13u
XPB_n818 n818 n777 ph3 ph3 sg13_lv_pmos w=1.12u l=0.13u
XNA_n818 n818 n774 m_n818 gn3 sg13_lv_nmos w=0.74u l=0.13u
XNB_n818 m_n818 n777 gn3 gn3 sg13_lv_nmos w=0.74u l=0.13u
CL_n818 n818 gn3 2f
XPA_n820 n820 n771 ph3 ph3 sg13_lv_pmos w=1.12u l=0.13u
XPB_n820 n820 n777 ph3 ph3 sg13_lv_pmos w=1.12u l=0.13u
XNA_n820 n820 n771 m_n820 gn3 sg13_lv_nmos w=0.74u l=0.13u
XNB_n820 m_n820 n777 gn3 gn3 sg13_lv_nmos w=0.74u l=0.13u
CL_n820 n820 gn3 2f
XPA_n821 n821 n774 ph3 ph3 sg13_lv_pmos w=1.12u l=0.13u
XPB_n821 n821 n780 ph3 ph3 sg13_lv_pmos w=1.12u l=0.13u
XNA_n821 n821 n774 m_n821 gn3 sg13_lv_nmos w=0.74u l=0.13u
XNB_n821 m_n821 n780 gn3 gn3 sg13_lv_nmos w=0.74u l=0.13u
CL_n821 n821 gn3 2f
XPA_n847 n847 n831 ph3 ph3 sg13_lv_pmos w=1.12u l=0.13u
XPB_n847 n847 n840 ph3 ph3 sg13_lv_pmos w=1.12u l=0.13u
XNA_n847 n847 n831 m_n847 gn3 sg13_lv_nmos w=0.74u l=0.13u
XNB_n847 m_n847 n840 gn3 gn3 sg13_lv_nmos w=0.74u l=0.13u
CL_n847 n847 gn3 2f
XPA_n848 n848 n834 ph3 ph3 sg13_lv_pmos w=1.12u l=0.13u
XPB_n848 n848 n837 ph3 ph3 sg13_lv_pmos w=1.12u l=0.13u
XNA_n848 n848 n834 m_n848 gn3 sg13_lv_nmos w=0.74u l=0.13u
XNB_n848 m_n848 n837 gn3 gn3 sg13_lv_nmos w=0.74u l=0.13u
CL_n848 n848 gn3 2f
XPA_n850 n850 n831 ph3 ph3 sg13_lv_pmos w=1.12u l=0.13u
XPB_n850 n850 n837 ph3 ph3 sg13_lv_pmos w=1.12u l=0.13u
XNA_n850 n850 n831 m_n850 gn3 sg13_lv_nmos w=0.74u l=0.13u
XNB_n850 m_n850 n837 gn3 gn3 sg13_lv_nmos w=0.74u l=0.13u
CL_n850 n850 gn3 2f
XPA_n851 n851 n834 ph3 ph3 sg13_lv_pmos w=1.12u l=0.13u
XPB_n851 n851 n840 ph3 ph3 sg13_lv_pmos w=1.12u l=0.13u
XNA_n851 n851 n834 m_n851 gn3 sg13_lv_nmos w=0.74u l=0.13u
XNB_n851 m_n851 n840 gn3 gn3 sg13_lv_nmos w=0.74u l=0.13u
CL_n851 n851 gn3 2f
XPA_n1017 n1017 n1015 ph3 ph3 sg13_lv_pmos w=1.12u l=0.13u
XPB_n1017 n1017 n1016 ph3 ph3 sg13_lv_pmos w=1.12u l=0.13u
XNA_n1017 n1017 n1015 m_n1017 gn3 sg13_lv_nmos w=0.74u l=0.13u
XNB_n1017 m_n1017 n1016 gn3 gn3 sg13_lv_nmos w=0.74u l=0.13u
CL_n1017 n1017 gn3 2f
XPA_n1020 n1020 n1018 ph3 ph3 sg13_lv_pmos w=1.12u l=0.13u
XPB_n1020 n1020 n1019 ph3 ph3 sg13_lv_pmos w=1.12u l=0.13u
XNA_n1020 n1020 n1018 m_n1020 gn3 sg13_lv_nmos w=0.74u l=0.13u
XNB_n1020 m_n1020 n1019 gn3 gn3 sg13_lv_nmos w=0.74u l=0.13u
CL_n1020 n1020 gn3 2f
XPA_n1023 n1023 n1021 ph3 ph3 sg13_lv_pmos w=1.12u l=0.13u
XPB_n1023 n1023 n1022 ph3 ph3 sg13_lv_pmos w=1.12u l=0.13u
XNA_n1023 n1023 n1021 m_n1023 gn3 sg13_lv_nmos w=0.74u l=0.13u
XNB_n1023 m_n1023 n1022 gn3 gn3 sg13_lv_nmos w=0.74u l=0.13u
CL_n1023 n1023 gn3 2f
XPA_n1026 n1026 n1024 ph3 ph3 sg13_lv_pmos w=1.12u l=0.13u
XPB_n1026 n1026 n1025 ph3 ph3 sg13_lv_pmos w=1.12u l=0.13u
XNA_n1026 n1026 n1024 m_n1026 gn3 sg13_lv_nmos w=0.74u l=0.13u
XNB_n1026 m_n1026 n1025 gn3 gn3 sg13_lv_nmos w=0.74u l=0.13u
CL_n1026 n1026 gn3 2f
XPA_n1191 n1191 n1189 ph3 ph3 sg13_lv_pmos w=1.12u l=0.13u
XPB_n1191 n1191 n1190 ph3 ph3 sg13_lv_pmos w=1.12u l=0.13u
XNA_n1191 n1191 n1189 m_n1191 gn3 sg13_lv_nmos w=0.74u l=0.13u
XNB_n1191 m_n1191 n1190 gn3 gn3 sg13_lv_nmos w=0.74u l=0.13u
CL_n1191 n1191 gn3 2f
XPA_n1194 n1194 n1192 ph3 ph3 sg13_lv_pmos w=1.12u l=0.13u
XPB_n1194 n1194 n1193 ph3 ph3 sg13_lv_pmos w=1.12u l=0.13u
XNA_n1194 n1194 n1192 m_n1194 gn3 sg13_lv_nmos w=0.74u l=0.13u
XNB_n1194 m_n1194 n1193 gn3 gn3 sg13_lv_nmos w=0.74u l=0.13u
CL_n1194 n1194 gn3 2f
XPA_n1197 n1197 n1195 ph3 ph3 sg13_lv_pmos w=1.12u l=0.13u
XPB_n1197 n1197 n1196 ph3 ph3 sg13_lv_pmos w=1.12u l=0.13u
XNA_n1197 n1197 n1195 m_n1197 gn3 sg13_lv_nmos w=0.74u l=0.13u
XNB_n1197 m_n1197 n1196 gn3 gn3 sg13_lv_nmos w=0.74u l=0.13u
CL_n1197 n1197 gn3 2f
XPA_n1200 n1200 n1198 ph3 ph3 sg13_lv_pmos w=1.12u l=0.13u
XPB_n1200 n1200 n1199 ph3 ph3 sg13_lv_pmos w=1.12u l=0.13u
XNA_n1200 n1200 n1198 m_n1200 gn3 sg13_lv_nmos w=0.74u l=0.13u
XNB_n1200 m_n1200 n1199 gn3 gn3 sg13_lv_nmos w=0.74u l=0.13u
CL_n1200 n1200 gn3 2f
XPA_n135 n135 n133 ph3 ph3 sg13_lv_pmos w=1.12u l=0.13u
XPB_n135 n135 n134 ph3 ph3 sg13_lv_pmos w=1.12u l=0.13u
XNA_n135 n135 n133 m_n135 gn3 sg13_lv_nmos w=0.74u l=0.13u
XNB_n135 m_n135 n134 gn3 gn3 sg13_lv_nmos w=0.74u l=0.13u
CL_n135 n135 gn3 2f
XPA_n1377 n1377 n1375 ph3 ph3 sg13_lv_pmos w=1.12u l=0.13u
XPB_n1377 n1377 n1376 ph3 ph3 sg13_lv_pmos w=1.12u l=0.13u
XNA_n1377 n1377 n1375 m_n1377 gn3 sg13_lv_nmos w=0.74u l=0.13u
XNB_n1377 m_n1377 n1376 gn3 gn3 sg13_lv_nmos w=0.74u l=0.13u
CL_n1377 n1377 gn3 2f
XPA_n138 n138 n136 ph3 ph3 sg13_lv_pmos w=1.12u l=0.13u
XPB_n138 n138 n137 ph3 ph3 sg13_lv_pmos w=1.12u l=0.13u
XNA_n138 n138 n136 m_n138 gn3 sg13_lv_nmos w=0.74u l=0.13u
XNB_n138 m_n138 n137 gn3 gn3 sg13_lv_nmos w=0.74u l=0.13u
CL_n138 n138 gn3 2f
XPA_n1380 n1380 n1378 ph3 ph3 sg13_lv_pmos w=1.12u l=0.13u
XPB_n1380 n1380 n1379 ph3 ph3 sg13_lv_pmos w=1.12u l=0.13u
XNA_n1380 n1380 n1378 m_n1380 gn3 sg13_lv_nmos w=0.74u l=0.13u
XNB_n1380 m_n1380 n1379 gn3 gn3 sg13_lv_nmos w=0.74u l=0.13u
CL_n1380 n1380 gn3 2f
XPA_n1383 n1383 n1381 ph3 ph3 sg13_lv_pmos w=1.12u l=0.13u
XPB_n1383 n1383 n1382 ph3 ph3 sg13_lv_pmos w=1.12u l=0.13u
XNA_n1383 n1383 n1381 m_n1383 gn3 sg13_lv_nmos w=0.74u l=0.13u
XNB_n1383 m_n1383 n1382 gn3 gn3 sg13_lv_nmos w=0.74u l=0.13u
CL_n1383 n1383 gn3 2f
XPA_n1386 n1386 n1384 ph3 ph3 sg13_lv_pmos w=1.12u l=0.13u
XPB_n1386 n1386 n1385 ph3 ph3 sg13_lv_pmos w=1.12u l=0.13u
XNA_n1386 n1386 n1384 m_n1386 gn3 sg13_lv_nmos w=0.74u l=0.13u
XNB_n1386 m_n1386 n1385 gn3 gn3 sg13_lv_nmos w=0.74u l=0.13u
CL_n1386 n1386 gn3 2f
XPA_n141 n141 n139 ph3 ph3 sg13_lv_pmos w=1.12u l=0.13u
XPB_n141 n141 n140 ph3 ph3 sg13_lv_pmos w=1.12u l=0.13u
XNA_n141 n141 n139 m_n141 gn3 sg13_lv_nmos w=0.74u l=0.13u
XNB_n141 m_n141 n140 gn3 gn3 sg13_lv_nmos w=0.74u l=0.13u
CL_n141 n141 gn3 2f
XPA_n144 n144 n142 ph3 ph3 sg13_lv_pmos w=1.12u l=0.13u
XPB_n144 n144 n143 ph3 ph3 sg13_lv_pmos w=1.12u l=0.13u
XNA_n144 n144 n142 m_n144 gn3 sg13_lv_nmos w=0.74u l=0.13u
XNB_n144 m_n144 n143 gn3 gn3 sg13_lv_nmos w=0.74u l=0.13u
CL_n144 n144 gn3 2f
XPA_n285 n285 n283 ph3 ph3 sg13_lv_pmos w=1.12u l=0.13u
XPB_n285 n285 n284 ph3 ph3 sg13_lv_pmos w=1.12u l=0.13u
XNA_n285 n285 n283 m_n285 gn3 sg13_lv_nmos w=0.74u l=0.13u
XNB_n285 m_n285 n284 gn3 gn3 sg13_lv_nmos w=0.74u l=0.13u
CL_n285 n285 gn3 2f
XPA_n288 n288 n286 ph3 ph3 sg13_lv_pmos w=1.12u l=0.13u
XPB_n288 n288 n287 ph3 ph3 sg13_lv_pmos w=1.12u l=0.13u
XNA_n288 n288 n286 m_n288 gn3 sg13_lv_nmos w=0.74u l=0.13u
XNB_n288 m_n288 n287 gn3 gn3 sg13_lv_nmos w=0.74u l=0.13u
CL_n288 n288 gn3 2f
XPA_n291 n291 n289 ph3 ph3 sg13_lv_pmos w=1.12u l=0.13u
XPB_n291 n291 n290 ph3 ph3 sg13_lv_pmos w=1.12u l=0.13u
XNA_n291 n291 n289 m_n291 gn3 sg13_lv_nmos w=0.74u l=0.13u
XNB_n291 m_n291 n290 gn3 gn3 sg13_lv_nmos w=0.74u l=0.13u
CL_n291 n291 gn3 2f
XPA_n294 n294 n292 ph3 ph3 sg13_lv_pmos w=1.12u l=0.13u
XPB_n294 n294 n293 ph3 ph3 sg13_lv_pmos w=1.12u l=0.13u
XNA_n294 n294 n292 m_n294 gn3 sg13_lv_nmos w=0.74u l=0.13u
XNB_n294 m_n294 n293 gn3 gn3 sg13_lv_nmos w=0.74u l=0.13u
CL_n294 n294 gn3 2f
XPA_n471 n471 n469 ph3 ph3 sg13_lv_pmos w=1.12u l=0.13u
XPB_n471 n471 n470 ph3 ph3 sg13_lv_pmos w=1.12u l=0.13u
XNA_n471 n471 n469 m_n471 gn3 sg13_lv_nmos w=0.74u l=0.13u
XNB_n471 m_n471 n470 gn3 gn3 sg13_lv_nmos w=0.74u l=0.13u
CL_n471 n471 gn3 2f
XPA_n474 n474 n472 ph3 ph3 sg13_lv_pmos w=1.12u l=0.13u
XPB_n474 n474 n473 ph3 ph3 sg13_lv_pmos w=1.12u l=0.13u
XNA_n474 n474 n472 m_n474 gn3 sg13_lv_nmos w=0.74u l=0.13u
XNB_n474 m_n474 n473 gn3 gn3 sg13_lv_nmos w=0.74u l=0.13u
CL_n474 n474 gn3 2f
XPA_n477 n477 n475 ph3 ph3 sg13_lv_pmos w=1.12u l=0.13u
XPB_n477 n477 n476 ph3 ph3 sg13_lv_pmos w=1.12u l=0.13u
XNA_n477 n477 n475 m_n477 gn3 sg13_lv_nmos w=0.74u l=0.13u
XNB_n477 m_n477 n476 gn3 gn3 sg13_lv_nmos w=0.74u l=0.13u
CL_n477 n477 gn3 2f
XPA_n480 n480 n478 ph3 ph3 sg13_lv_pmos w=1.12u l=0.13u
XPB_n480 n480 n479 ph3 ph3 sg13_lv_pmos w=1.12u l=0.13u
XNA_n480 n480 n478 m_n480 gn3 sg13_lv_nmos w=0.74u l=0.13u
XNB_n480 m_n480 n479 gn3 gn3 sg13_lv_nmos w=0.74u l=0.13u
CL_n480 n480 gn3 2f
XPA_n645 n645 n643 ph3 ph3 sg13_lv_pmos w=1.12u l=0.13u
XPB_n645 n645 n644 ph3 ph3 sg13_lv_pmos w=1.12u l=0.13u
XNA_n645 n645 n643 m_n645 gn3 sg13_lv_nmos w=0.74u l=0.13u
XNB_n645 m_n645 n644 gn3 gn3 sg13_lv_nmos w=0.74u l=0.13u
CL_n645 n645 gn3 2f
XPA_n648 n648 n646 ph3 ph3 sg13_lv_pmos w=1.12u l=0.13u
XPB_n648 n648 n647 ph3 ph3 sg13_lv_pmos w=1.12u l=0.13u
XNA_n648 n648 n646 m_n648 gn3 sg13_lv_nmos w=0.74u l=0.13u
XNB_n648 m_n648 n647 gn3 gn3 sg13_lv_nmos w=0.74u l=0.13u
CL_n648 n648 gn3 2f
XPA_n651 n651 n649 ph3 ph3 sg13_lv_pmos w=1.12u l=0.13u
XPB_n651 n651 n650 ph3 ph3 sg13_lv_pmos w=1.12u l=0.13u
XNA_n651 n651 n649 m_n651 gn3 sg13_lv_nmos w=0.74u l=0.13u
XNB_n651 m_n651 n650 gn3 gn3 sg13_lv_nmos w=0.74u l=0.13u
CL_n651 n651 gn3 2f
XPA_n654 n654 n652 ph3 ph3 sg13_lv_pmos w=1.12u l=0.13u
XPB_n654 n654 n653 ph3 ph3 sg13_lv_pmos w=1.12u l=0.13u
XNA_n654 n654 n652 m_n654 gn3 sg13_lv_nmos w=0.74u l=0.13u
XNB_n654 m_n654 n653 gn3 gn3 sg13_lv_nmos w=0.74u l=0.13u
CL_n654 n654 gn3 2f
XPA_n819 n819 n817 ph3 ph3 sg13_lv_pmos w=1.12u l=0.13u
XPB_n819 n819 n818 ph3 ph3 sg13_lv_pmos w=1.12u l=0.13u
XNA_n819 n819 n817 m_n819 gn3 sg13_lv_nmos w=0.74u l=0.13u
XNB_n819 m_n819 n818 gn3 gn3 sg13_lv_nmos w=0.74u l=0.13u
CL_n819 n819 gn3 2f
XPA_n822 n822 n820 ph3 ph3 sg13_lv_pmos w=1.12u l=0.13u
XPB_n822 n822 n821 ph3 ph3 sg13_lv_pmos w=1.12u l=0.13u
XNA_n822 n822 n820 m_n822 gn3 sg13_lv_nmos w=0.74u l=0.13u
XNB_n822 m_n822 n821 gn3 gn3 sg13_lv_nmos w=0.74u l=0.13u
CL_n822 n822 gn3 2f
XPA_n849 n849 n847 ph3 ph3 sg13_lv_pmos w=1.12u l=0.13u
XPB_n849 n849 n848 ph3 ph3 sg13_lv_pmos w=1.12u l=0.13u
XNA_n849 n849 n847 m_n849 gn3 sg13_lv_nmos w=0.74u l=0.13u
XNB_n849 m_n849 n848 gn3 gn3 sg13_lv_nmos w=0.74u l=0.13u
CL_n849 n849 gn3 2f
XPA_n852 n852 n850 ph3 ph3 sg13_lv_pmos w=1.12u l=0.13u
XPB_n852 n852 n851 ph3 ph3 sg13_lv_pmos w=1.12u l=0.13u
XNA_n852 n852 n850 m_n852 gn3 sg13_lv_nmos w=0.74u l=0.13u
XNB_n852 m_n852 n851 gn3 gn3 sg13_lv_nmos w=0.74u l=0.13u
CL_n852 n852 gn3 2f
XPA_n1027 n1027 n1017 ph3 ph3 sg13_lv_pmos w=1.12u l=0.13u
XPB_n1027 n1027 n1026 ph3 ph3 sg13_lv_pmos w=1.12u l=0.13u
XNA_n1027 n1027 n1017 m_n1027 gn3 sg13_lv_nmos w=0.74u l=0.13u
XNB_n1027 m_n1027 n1026 gn3 gn3 sg13_lv_nmos w=0.74u l=0.13u
CL_n1027 n1027 gn3 2f
XPA_n1028 n1028 n1020 ph3 ph3 sg13_lv_pmos w=1.12u l=0.13u
XPB_n1028 n1028 n1023 ph3 ph3 sg13_lv_pmos w=1.12u l=0.13u
XNA_n1028 n1028 n1020 m_n1028 gn3 sg13_lv_nmos w=0.74u l=0.13u
XNB_n1028 m_n1028 n1023 gn3 gn3 sg13_lv_nmos w=0.74u l=0.13u
CL_n1028 n1028 gn3 2f
XPA_n1030 n1030 n1017 ph3 ph3 sg13_lv_pmos w=1.12u l=0.13u
XPB_n1030 n1030 n1023 ph3 ph3 sg13_lv_pmos w=1.12u l=0.13u
XNA_n1030 n1030 n1017 m_n1030 gn3 sg13_lv_nmos w=0.74u l=0.13u
XNB_n1030 m_n1030 n1023 gn3 gn3 sg13_lv_nmos w=0.74u l=0.13u
CL_n1030 n1030 gn3 2f
XPA_n1031 n1031 n1020 ph3 ph3 sg13_lv_pmos w=1.12u l=0.13u
XPB_n1031 n1031 n1026 ph3 ph3 sg13_lv_pmos w=1.12u l=0.13u
XNA_n1031 n1031 n1020 m_n1031 gn3 sg13_lv_nmos w=0.74u l=0.13u
XNB_n1031 m_n1031 n1026 gn3 gn3 sg13_lv_nmos w=0.74u l=0.13u
CL_n1031 n1031 gn3 2f
XPA_n1201 n1201 n1191 ph3 ph3 sg13_lv_pmos w=1.12u l=0.13u
XPB_n1201 n1201 n1200 ph3 ph3 sg13_lv_pmos w=1.12u l=0.13u
XNA_n1201 n1201 n1191 m_n1201 gn3 sg13_lv_nmos w=0.74u l=0.13u
XNB_n1201 m_n1201 n1200 gn3 gn3 sg13_lv_nmos w=0.74u l=0.13u
CL_n1201 n1201 gn3 2f
XPA_n1202 n1202 n1194 ph3 ph3 sg13_lv_pmos w=1.12u l=0.13u
XPB_n1202 n1202 n1197 ph3 ph3 sg13_lv_pmos w=1.12u l=0.13u
XNA_n1202 n1202 n1194 m_n1202 gn3 sg13_lv_nmos w=0.74u l=0.13u
XNB_n1202 m_n1202 n1197 gn3 gn3 sg13_lv_nmos w=0.74u l=0.13u
CL_n1202 n1202 gn3 2f
XPA_n1204 n1204 n1191 ph3 ph3 sg13_lv_pmos w=1.12u l=0.13u
XPB_n1204 n1204 n1197 ph3 ph3 sg13_lv_pmos w=1.12u l=0.13u
XNA_n1204 n1204 n1191 m_n1204 gn3 sg13_lv_nmos w=0.74u l=0.13u
XNB_n1204 m_n1204 n1197 gn3 gn3 sg13_lv_nmos w=0.74u l=0.13u
CL_n1204 n1204 gn3 2f
XPA_n1205 n1205 n1194 ph3 ph3 sg13_lv_pmos w=1.12u l=0.13u
XPB_n1205 n1205 n1200 ph3 ph3 sg13_lv_pmos w=1.12u l=0.13u
XNA_n1205 n1205 n1194 m_n1205 gn3 sg13_lv_nmos w=0.74u l=0.13u
XNB_n1205 m_n1205 n1200 gn3 gn3 sg13_lv_nmos w=0.74u l=0.13u
CL_n1205 n1205 gn3 2f
XPA_n1387 n1387 n1377 ph3 ph3 sg13_lv_pmos w=1.12u l=0.13u
XPB_n1387 n1387 n1386 ph3 ph3 sg13_lv_pmos w=1.12u l=0.13u
XNA_n1387 n1387 n1377 m_n1387 gn3 sg13_lv_nmos w=0.74u l=0.13u
XNB_n1387 m_n1387 n1386 gn3 gn3 sg13_lv_nmos w=0.74u l=0.13u
CL_n1387 n1387 gn3 2f
XPA_n1388 n1388 n1380 ph3 ph3 sg13_lv_pmos w=1.12u l=0.13u
XPB_n1388 n1388 n1383 ph3 ph3 sg13_lv_pmos w=1.12u l=0.13u
XNA_n1388 n1388 n1380 m_n1388 gn3 sg13_lv_nmos w=0.74u l=0.13u
XNB_n1388 m_n1388 n1383 gn3 gn3 sg13_lv_nmos w=0.74u l=0.13u
CL_n1388 n1388 gn3 2f
XPA_n1390 n1390 n1377 ph3 ph3 sg13_lv_pmos w=1.12u l=0.13u
XPB_n1390 n1390 n1383 ph3 ph3 sg13_lv_pmos w=1.12u l=0.13u
XNA_n1390 n1390 n1377 m_n1390 gn3 sg13_lv_nmos w=0.74u l=0.13u
XNB_n1390 m_n1390 n1383 gn3 gn3 sg13_lv_nmos w=0.74u l=0.13u
CL_n1390 n1390 gn3 2f
XPA_n1391 n1391 n1380 ph3 ph3 sg13_lv_pmos w=1.12u l=0.13u
XPB_n1391 n1391 n1386 ph3 ph3 sg13_lv_pmos w=1.12u l=0.13u
XNA_n1391 n1391 n1380 m_n1391 gn3 sg13_lv_nmos w=0.74u l=0.13u
XNB_n1391 m_n1391 n1386 gn3 gn3 sg13_lv_nmos w=0.74u l=0.13u
CL_n1391 n1391 gn3 2f
XPA_n145 n145 n135 ph3 ph3 sg13_lv_pmos w=1.12u l=0.13u
XPB_n145 n145 n144 ph3 ph3 sg13_lv_pmos w=1.12u l=0.13u
XNA_n145 n145 n135 m_n145 gn3 sg13_lv_nmos w=0.74u l=0.13u
XNB_n145 m_n145 n144 gn3 gn3 sg13_lv_nmos w=0.74u l=0.13u
CL_n145 n145 gn3 2f
XPA_n146 n146 n138 ph3 ph3 sg13_lv_pmos w=1.12u l=0.13u
XPB_n146 n146 n141 ph3 ph3 sg13_lv_pmos w=1.12u l=0.13u
XNA_n146 n146 n138 m_n146 gn3 sg13_lv_nmos w=0.74u l=0.13u
XNB_n146 m_n146 n141 gn3 gn3 sg13_lv_nmos w=0.74u l=0.13u
CL_n146 n146 gn3 2f
XPA_n148 n148 n135 ph3 ph3 sg13_lv_pmos w=1.12u l=0.13u
XPB_n148 n148 n141 ph3 ph3 sg13_lv_pmos w=1.12u l=0.13u
XNA_n148 n148 n135 m_n148 gn3 sg13_lv_nmos w=0.74u l=0.13u
XNB_n148 m_n148 n141 gn3 gn3 sg13_lv_nmos w=0.74u l=0.13u
CL_n148 n148 gn3 2f
XPA_n149 n149 n138 ph3 ph3 sg13_lv_pmos w=1.12u l=0.13u
XPB_n149 n149 n144 ph3 ph3 sg13_lv_pmos w=1.12u l=0.13u
XNA_n149 n149 n138 m_n149 gn3 sg13_lv_nmos w=0.74u l=0.13u
XNB_n149 m_n149 n144 gn3 gn3 sg13_lv_nmos w=0.74u l=0.13u
CL_n149 n149 gn3 2f
XPA_n295 n295 n285 ph3 ph3 sg13_lv_pmos w=1.12u l=0.13u
XPB_n295 n295 n294 ph3 ph3 sg13_lv_pmos w=1.12u l=0.13u
XNA_n295 n295 n285 m_n295 gn3 sg13_lv_nmos w=0.74u l=0.13u
XNB_n295 m_n295 n294 gn3 gn3 sg13_lv_nmos w=0.74u l=0.13u
CL_n295 n295 gn3 2f
XPA_n296 n296 n288 ph3 ph3 sg13_lv_pmos w=1.12u l=0.13u
XPB_n296 n296 n291 ph3 ph3 sg13_lv_pmos w=1.12u l=0.13u
XNA_n296 n296 n288 m_n296 gn3 sg13_lv_nmos w=0.74u l=0.13u
XNB_n296 m_n296 n291 gn3 gn3 sg13_lv_nmos w=0.74u l=0.13u
CL_n296 n296 gn3 2f
XPA_n298 n298 n285 ph3 ph3 sg13_lv_pmos w=1.12u l=0.13u
XPB_n298 n298 n291 ph3 ph3 sg13_lv_pmos w=1.12u l=0.13u
XNA_n298 n298 n285 m_n298 gn3 sg13_lv_nmos w=0.74u l=0.13u
XNB_n298 m_n298 n291 gn3 gn3 sg13_lv_nmos w=0.74u l=0.13u
CL_n298 n298 gn3 2f
XPA_n299 n299 n288 ph3 ph3 sg13_lv_pmos w=1.12u l=0.13u
XPB_n299 n299 n294 ph3 ph3 sg13_lv_pmos w=1.12u l=0.13u
XNA_n299 n299 n288 m_n299 gn3 sg13_lv_nmos w=0.74u l=0.13u
XNB_n299 m_n299 n294 gn3 gn3 sg13_lv_nmos w=0.74u l=0.13u
CL_n299 n299 gn3 2f
XPA_n481 n481 n471 ph3 ph3 sg13_lv_pmos w=1.12u l=0.13u
XPB_n481 n481 n480 ph3 ph3 sg13_lv_pmos w=1.12u l=0.13u
XNA_n481 n481 n471 m_n481 gn3 sg13_lv_nmos w=0.74u l=0.13u
XNB_n481 m_n481 n480 gn3 gn3 sg13_lv_nmos w=0.74u l=0.13u
CL_n481 n481 gn3 2f
XPA_n482 n482 n474 ph3 ph3 sg13_lv_pmos w=1.12u l=0.13u
XPB_n482 n482 n477 ph3 ph3 sg13_lv_pmos w=1.12u l=0.13u
XNA_n482 n482 n474 m_n482 gn3 sg13_lv_nmos w=0.74u l=0.13u
XNB_n482 m_n482 n477 gn3 gn3 sg13_lv_nmos w=0.74u l=0.13u
CL_n482 n482 gn3 2f
XPA_n484 n484 n471 ph3 ph3 sg13_lv_pmos w=1.12u l=0.13u
XPB_n484 n484 n477 ph3 ph3 sg13_lv_pmos w=1.12u l=0.13u
XNA_n484 n484 n471 m_n484 gn3 sg13_lv_nmos w=0.74u l=0.13u
XNB_n484 m_n484 n477 gn3 gn3 sg13_lv_nmos w=0.74u l=0.13u
CL_n484 n484 gn3 2f
XPA_n485 n485 n474 ph3 ph3 sg13_lv_pmos w=1.12u l=0.13u
XPB_n485 n485 n480 ph3 ph3 sg13_lv_pmos w=1.12u l=0.13u
XNA_n485 n485 n474 m_n485 gn3 sg13_lv_nmos w=0.74u l=0.13u
XNB_n485 m_n485 n480 gn3 gn3 sg13_lv_nmos w=0.74u l=0.13u
CL_n485 n485 gn3 2f
XPA_n655 n655 n645 ph3 ph3 sg13_lv_pmos w=1.12u l=0.13u
XPB_n655 n655 n654 ph3 ph3 sg13_lv_pmos w=1.12u l=0.13u
XNA_n655 n655 n645 m_n655 gn3 sg13_lv_nmos w=0.74u l=0.13u
XNB_n655 m_n655 n654 gn3 gn3 sg13_lv_nmos w=0.74u l=0.13u
CL_n655 n655 gn3 2f
XPA_n656 n656 n648 ph3 ph3 sg13_lv_pmos w=1.12u l=0.13u
XPB_n656 n656 n651 ph3 ph3 sg13_lv_pmos w=1.12u l=0.13u
XNA_n656 n656 n648 m_n656 gn3 sg13_lv_nmos w=0.74u l=0.13u
XNB_n656 m_n656 n651 gn3 gn3 sg13_lv_nmos w=0.74u l=0.13u
CL_n656 n656 gn3 2f
XPA_n658 n658 n645 ph3 ph3 sg13_lv_pmos w=1.12u l=0.13u
XPB_n658 n658 n651 ph3 ph3 sg13_lv_pmos w=1.12u l=0.13u
XNA_n658 n658 n645 m_n658 gn3 sg13_lv_nmos w=0.74u l=0.13u
XNB_n658 m_n658 n651 gn3 gn3 sg13_lv_nmos w=0.74u l=0.13u
CL_n658 n658 gn3 2f
XPA_n659 n659 n648 ph3 ph3 sg13_lv_pmos w=1.12u l=0.13u
XPB_n659 n659 n654 ph3 ph3 sg13_lv_pmos w=1.12u l=0.13u
XNA_n659 n659 n648 m_n659 gn3 sg13_lv_nmos w=0.74u l=0.13u
XNB_n659 m_n659 n654 gn3 gn3 sg13_lv_nmos w=0.74u l=0.13u
CL_n659 n659 gn3 2f
XPA_n841 n841 n819 ph3 ph3 sg13_lv_pmos w=1.12u l=0.13u
XPB_n841 n841 n828 ph3 ph3 sg13_lv_pmos w=1.12u l=0.13u
XNA_n841 n841 n819 m_n841 gn3 sg13_lv_nmos w=0.74u l=0.13u
XNB_n841 m_n841 n828 gn3 gn3 sg13_lv_nmos w=0.74u l=0.13u
CL_n841 n841 gn3 2f
XPA_n842 n842 n822 ph3 ph3 sg13_lv_pmos w=1.12u l=0.13u
XPB_n842 n842 n825 ph3 ph3 sg13_lv_pmos w=1.12u l=0.13u
XNA_n842 n842 n822 m_n842 gn3 sg13_lv_nmos w=0.74u l=0.13u
XNB_n842 m_n842 n825 gn3 gn3 sg13_lv_nmos w=0.74u l=0.13u
CL_n842 n842 gn3 2f
XPA_n844 n844 n819 ph3 ph3 sg13_lv_pmos w=1.12u l=0.13u
XPB_n844 n844 n825 ph3 ph3 sg13_lv_pmos w=1.12u l=0.13u
XNA_n844 n844 n819 m_n844 gn3 sg13_lv_nmos w=0.74u l=0.13u
XNB_n844 m_n844 n825 gn3 gn3 sg13_lv_nmos w=0.74u l=0.13u
CL_n844 n844 gn3 2f
XPA_n845 n845 n822 ph3 ph3 sg13_lv_pmos w=1.12u l=0.13u
XPB_n845 n845 n828 ph3 ph3 sg13_lv_pmos w=1.12u l=0.13u
XNA_n845 n845 n822 m_n845 gn3 sg13_lv_nmos w=0.74u l=0.13u
XNB_n845 m_n845 n828 gn3 gn3 sg13_lv_nmos w=0.74u l=0.13u
CL_n845 n845 gn3 2f
XPA_n1029 n1029 n1027 ph4 ph4 sg13_lv_pmos w=1.12u l=0.13u
XPB_n1029 n1029 n1028 ph4 ph4 sg13_lv_pmos w=1.12u l=0.13u
XNA_n1029 n1029 n1027 m_n1029 gn4 sg13_lv_nmos w=0.74u l=0.13u
XNB_n1029 m_n1029 n1028 gn4 gn4 sg13_lv_nmos w=0.74u l=0.13u
CL_n1029 n1029 gn4 2f
XPA_n1032 n1032 n1030 ph4 ph4 sg13_lv_pmos w=1.12u l=0.13u
XPB_n1032 n1032 n1031 ph4 ph4 sg13_lv_pmos w=1.12u l=0.13u
XNA_n1032 n1032 n1030 m_n1032 gn4 sg13_lv_nmos w=0.74u l=0.13u
XNB_n1032 m_n1032 n1031 gn4 gn4 sg13_lv_nmos w=0.74u l=0.13u
CL_n1032 n1032 gn4 2f
XPA_n1203 n1203 n1201 ph4 ph4 sg13_lv_pmos w=1.12u l=0.13u
XPB_n1203 n1203 n1202 ph4 ph4 sg13_lv_pmos w=1.12u l=0.13u
XNA_n1203 n1203 n1201 m_n1203 gn4 sg13_lv_nmos w=0.74u l=0.13u
XNB_n1203 m_n1203 n1202 gn4 gn4 sg13_lv_nmos w=0.74u l=0.13u
CL_n1203 n1203 gn4 2f
XPA_n1206 n1206 n1204 ph4 ph4 sg13_lv_pmos w=1.12u l=0.13u
XPB_n1206 n1206 n1205 ph4 ph4 sg13_lv_pmos w=1.12u l=0.13u
XNA_n1206 n1206 n1204 m_n1206 gn4 sg13_lv_nmos w=0.74u l=0.13u
XNB_n1206 m_n1206 n1205 gn4 gn4 sg13_lv_nmos w=0.74u l=0.13u
CL_n1206 n1206 gn4 2f
XPA_n1389 n1389 n1387 ph4 ph4 sg13_lv_pmos w=1.12u l=0.13u
XPB_n1389 n1389 n1388 ph4 ph4 sg13_lv_pmos w=1.12u l=0.13u
XNA_n1389 n1389 n1387 m_n1389 gn4 sg13_lv_nmos w=0.74u l=0.13u
XNB_n1389 m_n1389 n1388 gn4 gn4 sg13_lv_nmos w=0.74u l=0.13u
CL_n1389 n1389 gn4 2f
XPA_n1392 n1392 n1390 ph4 ph4 sg13_lv_pmos w=1.12u l=0.13u
XPB_n1392 n1392 n1391 ph4 ph4 sg13_lv_pmos w=1.12u l=0.13u
XNA_n1392 n1392 n1390 m_n1392 gn4 sg13_lv_nmos w=0.74u l=0.13u
XNB_n1392 m_n1392 n1391 gn4 gn4 sg13_lv_nmos w=0.74u l=0.13u
CL_n1392 n1392 gn4 2f
XPA_n147 n147 n145 ph4 ph4 sg13_lv_pmos w=1.12u l=0.13u
XPB_n147 n147 n146 ph4 ph4 sg13_lv_pmos w=1.12u l=0.13u
XNA_n147 n147 n145 m_n147 gn4 sg13_lv_nmos w=0.74u l=0.13u
XNB_n147 m_n147 n146 gn4 gn4 sg13_lv_nmos w=0.74u l=0.13u
CL_n147 n147 gn4 2f
XPA_n150 n150 n148 ph4 ph4 sg13_lv_pmos w=1.12u l=0.13u
XPB_n150 n150 n149 ph4 ph4 sg13_lv_pmos w=1.12u l=0.13u
XNA_n150 n150 n148 m_n150 gn4 sg13_lv_nmos w=0.74u l=0.13u
XNB_n150 m_n150 n149 gn4 gn4 sg13_lv_nmos w=0.74u l=0.13u
CL_n150 n150 gn4 2f
XPA_n297 n297 n295 ph4 ph4 sg13_lv_pmos w=1.12u l=0.13u
XPB_n297 n297 n296 ph4 ph4 sg13_lv_pmos w=1.12u l=0.13u
XNA_n297 n297 n295 m_n297 gn4 sg13_lv_nmos w=0.74u l=0.13u
XNB_n297 m_n297 n296 gn4 gn4 sg13_lv_nmos w=0.74u l=0.13u
CL_n297 n297 gn4 2f
XPA_n300 n300 n298 ph4 ph4 sg13_lv_pmos w=1.12u l=0.13u
XPB_n300 n300 n299 ph4 ph4 sg13_lv_pmos w=1.12u l=0.13u
XNA_n300 n300 n298 m_n300 gn4 sg13_lv_nmos w=0.74u l=0.13u
XNB_n300 m_n300 n299 gn4 gn4 sg13_lv_nmos w=0.74u l=0.13u
CL_n300 n300 gn4 2f
XPA_n483 n483 n481 ph4 ph4 sg13_lv_pmos w=1.12u l=0.13u
XPB_n483 n483 n482 ph4 ph4 sg13_lv_pmos w=1.12u l=0.13u
XNA_n483 n483 n481 m_n483 gn4 sg13_lv_nmos w=0.74u l=0.13u
XNB_n483 m_n483 n482 gn4 gn4 sg13_lv_nmos w=0.74u l=0.13u
CL_n483 n483 gn4 2f
XPA_n486 n486 n484 ph4 ph4 sg13_lv_pmos w=1.12u l=0.13u
XPB_n486 n486 n485 ph4 ph4 sg13_lv_pmos w=1.12u l=0.13u
XNA_n486 n486 n484 m_n486 gn4 sg13_lv_nmos w=0.74u l=0.13u
XNB_n486 m_n486 n485 gn4 gn4 sg13_lv_nmos w=0.74u l=0.13u
CL_n486 n486 gn4 2f
XPA_n657 n657 n655 ph4 ph4 sg13_lv_pmos w=1.12u l=0.13u
XPB_n657 n657 n656 ph4 ph4 sg13_lv_pmos w=1.12u l=0.13u
XNA_n657 n657 n655 m_n657 gn4 sg13_lv_nmos w=0.74u l=0.13u
XNB_n657 m_n657 n656 gn4 gn4 sg13_lv_nmos w=0.74u l=0.13u
CL_n657 n657 gn4 2f
XPA_n660 n660 n658 ph4 ph4 sg13_lv_pmos w=1.12u l=0.13u
XPB_n660 n660 n659 ph4 ph4 sg13_lv_pmos w=1.12u l=0.13u
XNA_n660 n660 n658 m_n660 gn4 sg13_lv_nmos w=0.74u l=0.13u
XNB_n660 m_n660 n659 gn4 gn4 sg13_lv_nmos w=0.74u l=0.13u
CL_n660 n660 gn4 2f
XPA_n843 n843 n841 ph4 ph4 sg13_lv_pmos w=1.12u l=0.13u
XPB_n843 n843 n842 ph4 ph4 sg13_lv_pmos w=1.12u l=0.13u
XNA_n843 n843 n841 m_n843 gn4 sg13_lv_nmos w=0.74u l=0.13u
XNB_n843 m_n843 n842 gn4 gn4 sg13_lv_nmos w=0.74u l=0.13u
CL_n843 n843 gn4 2f
XPA_n846 n846 n844 ph4 ph4 sg13_lv_pmos w=1.12u l=0.13u
XPB_n846 n846 n845 ph4 ph4 sg13_lv_pmos w=1.12u l=0.13u
XNA_n846 n846 n844 m_n846 gn4 sg13_lv_nmos w=0.74u l=0.13u
XNB_n846 m_n846 n845 gn4 gn4 sg13_lv_nmos w=0.74u l=0.13u
CL_n846 n846 gn4 2f
XPA_n853 n853 n843 ph4 ph4 sg13_lv_pmos w=1.12u l=0.13u
XPB_n853 n853 n852 ph4 ph4 sg13_lv_pmos w=1.12u l=0.13u
XNA_n853 n853 n843 m_n853 gn4 sg13_lv_nmos w=0.74u l=0.13u
XNB_n853 m_n853 n852 gn4 gn4 sg13_lv_nmos w=0.74u l=0.13u
CL_n853 n853 gn4 2f
XPA_n854 n854 n846 ph4 ph4 sg13_lv_pmos w=1.12u l=0.13u
XPB_n854 n854 n849 ph4 ph4 sg13_lv_pmos w=1.12u l=0.13u
XNA_n854 n854 n846 m_n854 gn4 sg13_lv_nmos w=0.74u l=0.13u
XNB_n854 m_n854 n849 gn4 gn4 sg13_lv_nmos w=0.74u l=0.13u
CL_n854 n854 gn4 2f
XPA_n856 n856 n843 ph4 ph4 sg13_lv_pmos w=1.12u l=0.13u
XPB_n856 n856 n849 ph4 ph4 sg13_lv_pmos w=1.12u l=0.13u
XNA_n856 n856 n843 m_n856 gn4 sg13_lv_nmos w=0.74u l=0.13u
XNB_n856 m_n856 n849 gn4 gn4 sg13_lv_nmos w=0.74u l=0.13u
CL_n856 n856 gn4 2f
XPA_n857 n857 n846 ph4 ph4 sg13_lv_pmos w=1.12u l=0.13u
XPB_n857 n857 n852 ph4 ph4 sg13_lv_pmos w=1.12u l=0.13u
XNA_n857 n857 n846 m_n857 gn4 sg13_lv_nmos w=0.74u l=0.13u
XNB_n857 m_n857 n852 gn4 gn4 sg13_lv_nmos w=0.74u l=0.13u
CL_n857 n857 gn4 2f
XPA_n855 n855 n853 ph4 ph4 sg13_lv_pmos w=1.12u l=0.13u
XPB_n855 n855 n854 ph4 ph4 sg13_lv_pmos w=1.12u l=0.13u
XNA_n855 n855 n853 m_n855 gn4 sg13_lv_nmos w=0.74u l=0.13u
XNB_n855 m_n855 n854 gn4 gn4 sg13_lv_nmos w=0.74u l=0.13u
CL_n855 n855 gn4 2f
XPA_n858 n858 n856 ph4 ph4 sg13_lv_pmos w=1.12u l=0.13u
XPB_n858 n858 n857 ph4 ph4 sg13_lv_pmos w=1.12u l=0.13u
XNA_n858 n858 n856 m_n858 gn4 sg13_lv_nmos w=0.74u l=0.13u
XNB_n858 m_n858 n857 gn4 gn4 sg13_lv_nmos w=0.74u l=0.13u
CL_n858 n858 gn4 2f
.tran 0.1p 1982p 0 0.25p
.print tran V(ph1) V(ph2) V(ph3) V(ph4) I(VPH1) I(VPH2) I(VPH3) I(VPH4) I(VMG1) I(VMG2) I(VMG3) I(VMG4) V(n1117) V(n1118) V(n1120) V(n1121) V(n1123) V(n1124) V(n1126) V(n1127) V(n1129) V(n1130) V(n1132) V(n1133) V(n1135) V(n1136) V(n1138) V(n1139) V(n1141) V(n1142) V(n1144) V(n1145) V(n1147) V(n1148) V(n1150) V(n1151) V(n1153) V(n1154) V(n1156) V(n1157) V(n1161) V(n1164) V(n127) V(n128) V(n130) V(n1303) V(n1304) V(n1306) V(n1307) V(n1309) V(n131) V(n1310) V(n1312) V(n1313) V(n1315) V(n1316) V(n1318) V(n1319) V(n1321) V(n1322) V(n1324) V(n1325) V(n1327) V(n1328) V(n1330) V(n1331) V(n1333) V(n1334) V(n1336) V(n1337) V(n1339) V(n1340) V(n1342) V(n1343) V(n1345) V(n1346) V(n1348) V(n1349) V(n211) V(n212) V(n214) V(n215) V(n217) V(n218) V(n220) V(n221) V(n223) V(n224) V(n226) V(n227) V(n229) V(n230) V(n232) V(n233) V(n235) V(n236) V(n238) V(n239) V(n243) V(n246) V(n277) V(n278) V(n280) V(n281) V(n397) V(n398) V(n400) V(n401) V(n403) V(n404) V(n406) V(n407) V(n409) V(n410) V(n412) V(n413) V(n415) V(n416) V(n418) V(n419) V(n421) V(n422) V(n424) V(n425) V(n427) V(n428) V(n430) V(n431) V(n433) V(n434) V(n436) V(n437) V(n439) V(n440) V(n442) V(n443) V(n571) V(n572) V(n574) V(n575) V(n577) V(n578) V(n580) V(n581) V(n583) V(n584) V(n586) V(n587) V(n589) V(n590) V(n592) V(n593) V(n595) V(n596) V(n598) V(n599) V(n601) V(n602) V(n604) V(n605) V(n607) V(n608) V(n61) V(n610) V(n611) V(n615) V(n618) V(n62) V(n64) V(n65) V(n67) V(n673) V(n674) V(n676) V(n677) V(n68) V(n681) V(n684) V(n70) V(n71) V(n73) V(n74) V(n76) V(n77) V(n775) V(n776) V(n778) V(n779) V(n781) V(n782) V(n784) V(n785) V(n787) V(n788) V(n79) V(n790) V(n791) V(n793) V(n794) V(n796) V(n797) V(n799) V(n80) V(n800) V(n802) V(n803) V(n805) V(n806) V(n808) V(n809) V(n811) V(n812) V(n814) V(n815) V(n82) V(n83) V(n85) V(n86) V(n88) V(n89) V(n93) V(n943) V(n944) V(n946) V(n947) V(n949) V(n950) V(n952) V(n953) V(n955) V(n956) V(n958) V(n959) V(n96) V(n961) V(n962) V(n964) V(n965) V(n967) V(n968) V(n970) V(n971) V(n973) V(n974) V(n976) V(n977) V(n979) V(n980) V(n982) V(n983) V(n987) V(n990) V(n1002) V(n1005) V(n1008) V(n1011) V(n1014) V(n111) V(n114) V(n1167) V(n117) V(n1170) V(n1173) V(n1176) V(n1179) V(n1182) V(n1185) V(n1188) V(n120) V(n123) V(n126) V(n129) V(n132) V(n1353) V(n1356) V(n1359) V(n1362) V(n1365) V(n1368) V(n1371) V(n1374) V(n261) V(n264) V(n267) V(n270) V(n273) V(n276) V(n279) V(n282) V(n447) V(n450) V(n453) V(n456) V(n459) V(n462) V(n465) V(n468) V(n621) V(n624) V(n627) V(n630) V(n633) V(n636) V(n639) V(n642) V(n771) V(n774) V(n777) V(n780) V(n825) V(n828) V(n831) V(n834) V(n837) V(n840) V(n993) V(n996) V(n999) V(n1027) V(n1028) V(n1030) V(n1031) V(n1201) V(n1202) V(n1204) V(n1205) V(n1387) V(n1388) V(n1390) V(n1391) V(n145) V(n146) V(n148) V(n149) V(n295) V(n296) V(n298) V(n299) V(n481) V(n482) V(n484) V(n485) V(n655) V(n656) V(n658) V(n659) V(n841) V(n842) V(n844) V(n845) V(n849) V(n852) V(n147) V(n297) V(n483) V(n657) V(n855) V(n1029) V(n1203) V(n1389)
.end
