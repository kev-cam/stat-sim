.hdl "/usr/local/share/xyce/verilog-a/psp103/psp103.va"
.include "/usr/local/src/kestrel/sim/models/sg13g2_psp103_tt.lib"
.include "/usr/local/src/stat-sim/qal/sg13lv_compat.sp"
.OPTIONS TIMEINT METHOD=GEAR RELTOL=1e-6 ABSTOL=1e-15 CHGTOL=1e-17
VPH1 phs1 0 PWL(0 0 92p 1.65 184p 1.65 276p 0 368p 1.65 460p 1.65 552p 0 644p 1.65 736p 1.65 828p 0 920p 1.65 1012p 1.65 1104p 0 1196p 1.65 1288p 1.65 1380p 0 1472p 1.65 1564p 1.65 1656p 0 1748p 1.65 1840p 1.65 1932p 0 2024p 1.65 2116p 1.65)
RS1 phs1 ph1 0.001
VPH2 phs2 0 PWL(0 1.65 92p 0 184p 1.65 276p 1.65 368p 0 460p 1.65 552p 1.65 644p 0 736p 1.65 828p 1.65 920p 0 1012p 1.65 1104p 1.65 1196p 0 1288p 1.65 1380p 1.65 1472p 0 1564p 1.65 1656p 1.65 1748p 0 1840p 1.65 1932p 1.65 2024p 0 2116p 1.65 2208p 1.65)
RS2 phs2 ph2 0.001
VPH3 phs3 0 PWL(0 1.65 92p 1.65 184p 0 276p 1.65 368p 1.65 460p 0 552p 1.65 644p 1.65 736p 0 828p 1.65 920p 1.65 1012p 0 1104p 1.65 1196p 1.65 1288p 0 1380p 1.65 1472p 1.65 1564p 0 1656p 1.65 1748p 1.65 1840p 0 1932p 1.65 2024p 1.65 2116p 0 2208p 1.65 2300p 1.65)
RS3 phs3 ph3 0.001
VPH4 phs4 drv4 0
RS4 phs4 ph4 0.001
VPH5 phs5 0 PWL(0 1.65 92p 0 184p 1.65 276p 1.65 368p 0 460p 1.65 552p 1.65 644p 0 736p 1.65 828p 1.65 920p 0 1012p 1.65 1104p 1.65 1196p 0 1288p 1.65 1380p 1.65 1472p 0 1564p 1.65 1656p 1.65 1748p 0 1840p 1.65 1932p 1.65 2024p 0 2116p 1.65 2208p 1.65)
RS5 phs5 ph5 0.001
VPH6 phs6 0 PWL(0 1.65 92p 1.65 184p 0 276p 1.65 368p 1.65 460p 0 552p 1.65 644p 1.65 736p 0 828p 1.65 920p 1.65 1012p 0 1104p 1.65 1196p 1.65 1288p 0 1380p 1.65 1472p 1.65 1564p 0 1656p 1.65 1748p 1.65 1840p 0 1932p 1.65 2024p 1.65 2116p 0 2208p 1.65 2300p 1.65)
RS6 phs6 ph6 0.001
VI1_0 in1_0 0 PWL(0 1.65 275p 1.65 277p 0 551p 0 553p 1.65 827p 1.65 829p 0 1103p 0 1105p 1.65 1379p 1.65 1381p 0 1655p 0 1657p 1.65 1931p 1.65 1933p 0)
VI1_1 in1_1 0 PWL(0 1.65 275p 1.65 277p 0 551p 0 553p 1.65 827p 1.65 829p 0 1103p 0 1105p 1.65 1379p 1.65 1381p 0 1655p 0 1657p 1.65 1931p 1.65 1933p 0)
VI1_2 in1_2 0 PWL(0 1.65 275p 1.65 277p 0 551p 0 553p 1.65 827p 1.65 829p 0 1103p 0 1105p 1.65 1379p 1.65 1381p 0 1655p 0 1657p 1.65 1931p 1.65 1933p 0)
VI1_3 in1_3 0 PWL(0 0 275p 0 277p 1.65 551p 1.65 553p 0 827p 0 829p 1.65 1103p 1.65 1105p 0 1379p 0 1381p 1.65 1655p 1.65 1657p 0 1931p 0 1933p 1.65)
VI1_4 in1_4 0 PWL(0 1.65 275p 1.65 277p 0 551p 0 553p 1.65 827p 1.65 829p 0 1103p 0 1105p 1.65 1379p 1.65 1381p 0 1655p 0 1657p 1.65 1931p 1.65 1933p 0)
VI1_5 in1_5 0 PWL(0 0 275p 0 277p 1.65 551p 1.65 553p 0 827p 0 829p 1.65 1103p 1.65 1105p 0 1379p 0 1381p 1.65 1655p 1.65 1657p 0 1931p 0 1933p 1.65)
VI1_6 in1_6 0 PWL(0 0 275p 0 277p 1.65 551p 1.65 553p 0 827p 0 829p 1.65 1103p 1.65 1105p 0 1379p 0 1381p 1.65 1655p 1.65 1657p 0 1931p 0 1933p 1.65)
VI1_7 in1_7 0 PWL(0 1.65 275p 1.65 277p 0 551p 0 553p 1.65 827p 1.65 829p 0 1103p 0 1105p 1.65 1379p 1.65 1381p 0 1655p 0 1657p 1.65 1931p 1.65 1933p 0)
VMG1 gn1 0 0
XP1_1_0 o1_1_0 in1_0 ph1 ph1 sg13_lv_pmos w=1.12u l=0.13u
XN1_1_0 o1_1_0 in1_0 gn1 gn1 sg13_lv_nmos w=0.74u l=0.13u
CL1_1_0 o1_1_0 gn1 2f
XP1_1_1 o1_1_1 in1_1 ph1 ph1 sg13_lv_pmos w=1.12u l=0.13u
XN1_1_1 o1_1_1 in1_1 gn1 gn1 sg13_lv_nmos w=0.74u l=0.13u
CL1_1_1 o1_1_1 gn1 2f
XP1_1_2 o1_1_2 in1_2 ph1 ph1 sg13_lv_pmos w=1.12u l=0.13u
XN1_1_2 o1_1_2 in1_2 gn1 gn1 sg13_lv_nmos w=0.74u l=0.13u
CL1_1_2 o1_1_2 gn1 2f
XP1_1_3 o1_1_3 in1_3 ph1 ph1 sg13_lv_pmos w=1.12u l=0.13u
XN1_1_3 o1_1_3 in1_3 gn1 gn1 sg13_lv_nmos w=0.74u l=0.13u
CL1_1_3 o1_1_3 gn1 2f
XP1_1_4 o1_1_4 in1_4 ph1 ph1 sg13_lv_pmos w=1.12u l=0.13u
XN1_1_4 o1_1_4 in1_4 gn1 gn1 sg13_lv_nmos w=0.74u l=0.13u
CL1_1_4 o1_1_4 gn1 2f
XP1_1_5 o1_1_5 in1_5 ph1 ph1 sg13_lv_pmos w=1.12u l=0.13u
XN1_1_5 o1_1_5 in1_5 gn1 gn1 sg13_lv_nmos w=0.74u l=0.13u
CL1_1_5 o1_1_5 gn1 2f
XP1_1_6 o1_1_6 in1_6 ph1 ph1 sg13_lv_pmos w=1.12u l=0.13u
XN1_1_6 o1_1_6 in1_6 gn1 gn1 sg13_lv_nmos w=0.74u l=0.13u
CL1_1_6 o1_1_6 gn1 2f
XP1_1_7 o1_1_7 in1_7 ph1 ph1 sg13_lv_pmos w=1.12u l=0.13u
XN1_1_7 o1_1_7 in1_7 gn1 gn1 sg13_lv_nmos w=0.74u l=0.13u
CL1_1_7 o1_1_7 gn1 2f
XP1_2_0 o1_2_0 o1_1_0 ph1 ph1 sg13_lv_pmos w=1.12u l=0.13u
XN1_2_0 o1_2_0 o1_1_0 gn1 gn1 sg13_lv_nmos w=0.74u l=0.13u
CL1_2_0 o1_2_0 gn1 2f
XP1_2_1 o1_2_1 o1_1_1 ph1 ph1 sg13_lv_pmos w=1.12u l=0.13u
XN1_2_1 o1_2_1 o1_1_1 gn1 gn1 sg13_lv_nmos w=0.74u l=0.13u
CL1_2_1 o1_2_1 gn1 2f
XP1_2_2 o1_2_2 o1_1_2 ph1 ph1 sg13_lv_pmos w=1.12u l=0.13u
XN1_2_2 o1_2_2 o1_1_2 gn1 gn1 sg13_lv_nmos w=0.74u l=0.13u
CL1_2_2 o1_2_2 gn1 2f
XP1_2_3 o1_2_3 o1_1_3 ph1 ph1 sg13_lv_pmos w=1.12u l=0.13u
XN1_2_3 o1_2_3 o1_1_3 gn1 gn1 sg13_lv_nmos w=0.74u l=0.13u
CL1_2_3 o1_2_3 gn1 2f
XP1_2_4 o1_2_4 o1_1_4 ph1 ph1 sg13_lv_pmos w=1.12u l=0.13u
XN1_2_4 o1_2_4 o1_1_4 gn1 gn1 sg13_lv_nmos w=0.74u l=0.13u
CL1_2_4 o1_2_4 gn1 2f
XP1_2_5 o1_2_5 o1_1_5 ph1 ph1 sg13_lv_pmos w=1.12u l=0.13u
XN1_2_5 o1_2_5 o1_1_5 gn1 gn1 sg13_lv_nmos w=0.74u l=0.13u
CL1_2_5 o1_2_5 gn1 2f
XP1_2_6 o1_2_6 o1_1_6 ph1 ph1 sg13_lv_pmos w=1.12u l=0.13u
XN1_2_6 o1_2_6 o1_1_6 gn1 gn1 sg13_lv_nmos w=0.74u l=0.13u
CL1_2_6 o1_2_6 gn1 2f
XP1_2_7 o1_2_7 o1_1_7 ph1 ph1 sg13_lv_pmos w=1.12u l=0.13u
XN1_2_7 o1_2_7 o1_1_7 gn1 gn1 sg13_lv_nmos w=0.74u l=0.13u
CL1_2_7 o1_2_7 gn1 2f
XP1_3_0 o1_3_0 o1_2_0 ph1 ph1 sg13_lv_pmos w=1.12u l=0.13u
XN1_3_0 o1_3_0 o1_2_0 gn1 gn1 sg13_lv_nmos w=0.74u l=0.13u
CL1_3_0 o1_3_0 gn1 2f
XP1_3_1 o1_3_1 o1_2_1 ph1 ph1 sg13_lv_pmos w=1.12u l=0.13u
XN1_3_1 o1_3_1 o1_2_1 gn1 gn1 sg13_lv_nmos w=0.74u l=0.13u
CL1_3_1 o1_3_1 gn1 2f
XP1_3_2 o1_3_2 o1_2_2 ph1 ph1 sg13_lv_pmos w=1.12u l=0.13u
XN1_3_2 o1_3_2 o1_2_2 gn1 gn1 sg13_lv_nmos w=0.74u l=0.13u
CL1_3_2 o1_3_2 gn1 2f
XP1_3_3 o1_3_3 o1_2_3 ph1 ph1 sg13_lv_pmos w=1.12u l=0.13u
XN1_3_3 o1_3_3 o1_2_3 gn1 gn1 sg13_lv_nmos w=0.74u l=0.13u
CL1_3_3 o1_3_3 gn1 2f
XP1_3_4 o1_3_4 o1_2_4 ph1 ph1 sg13_lv_pmos w=1.12u l=0.13u
XN1_3_4 o1_3_4 o1_2_4 gn1 gn1 sg13_lv_nmos w=0.74u l=0.13u
CL1_3_4 o1_3_4 gn1 2f
XP1_3_5 o1_3_5 o1_2_5 ph1 ph1 sg13_lv_pmos w=1.12u l=0.13u
XN1_3_5 o1_3_5 o1_2_5 gn1 gn1 sg13_lv_nmos w=0.74u l=0.13u
CL1_3_5 o1_3_5 gn1 2f
XP1_3_6 o1_3_6 o1_2_6 ph1 ph1 sg13_lv_pmos w=1.12u l=0.13u
XN1_3_6 o1_3_6 o1_2_6 gn1 gn1 sg13_lv_nmos w=0.74u l=0.13u
CL1_3_6 o1_3_6 gn1 2f
XP1_3_7 o1_3_7 o1_2_7 ph1 ph1 sg13_lv_pmos w=1.12u l=0.13u
XN1_3_7 o1_3_7 o1_2_7 gn1 gn1 sg13_lv_nmos w=0.74u l=0.13u
CL1_3_7 o1_3_7 gn1 2f
VMG2 gn2 0 0
XP2_1_0 o2_1_0 o1_3_0 ph2 ph2 sg13_lv_pmos w=1.12u l=0.13u
XN2_1_0 o2_1_0 o1_3_0 gn2 gn2 sg13_lv_nmos w=0.74u l=0.13u
CL2_1_0 o2_1_0 gn2 2f
XP2_1_1 o2_1_1 o1_3_1 ph2 ph2 sg13_lv_pmos w=1.12u l=0.13u
XN2_1_1 o2_1_1 o1_3_1 gn2 gn2 sg13_lv_nmos w=0.74u l=0.13u
CL2_1_1 o2_1_1 gn2 2f
XP2_1_2 o2_1_2 o1_3_2 ph2 ph2 sg13_lv_pmos w=1.12u l=0.13u
XN2_1_2 o2_1_2 o1_3_2 gn2 gn2 sg13_lv_nmos w=0.74u l=0.13u
CL2_1_2 o2_1_2 gn2 2f
XP2_1_3 o2_1_3 o1_3_3 ph2 ph2 sg13_lv_pmos w=1.12u l=0.13u
XN2_1_3 o2_1_3 o1_3_3 gn2 gn2 sg13_lv_nmos w=0.74u l=0.13u
CL2_1_3 o2_1_3 gn2 2f
XP2_1_4 o2_1_4 o1_3_4 ph2 ph2 sg13_lv_pmos w=1.12u l=0.13u
XN2_1_4 o2_1_4 o1_3_4 gn2 gn2 sg13_lv_nmos w=0.74u l=0.13u
CL2_1_4 o2_1_4 gn2 2f
XP2_1_5 o2_1_5 o1_3_5 ph2 ph2 sg13_lv_pmos w=1.12u l=0.13u
XN2_1_5 o2_1_5 o1_3_5 gn2 gn2 sg13_lv_nmos w=0.74u l=0.13u
CL2_1_5 o2_1_5 gn2 2f
XP2_1_6 o2_1_6 o1_3_6 ph2 ph2 sg13_lv_pmos w=1.12u l=0.13u
XN2_1_6 o2_1_6 o1_3_6 gn2 gn2 sg13_lv_nmos w=0.74u l=0.13u
CL2_1_6 o2_1_6 gn2 2f
XP2_1_7 o2_1_7 o1_3_7 ph2 ph2 sg13_lv_pmos w=1.12u l=0.13u
XN2_1_7 o2_1_7 o1_3_7 gn2 gn2 sg13_lv_nmos w=0.74u l=0.13u
CL2_1_7 o2_1_7 gn2 2f
XP2_2_0 o2_2_0 o2_1_0 ph2 ph2 sg13_lv_pmos w=1.12u l=0.13u
XN2_2_0 o2_2_0 o2_1_0 gn2 gn2 sg13_lv_nmos w=0.74u l=0.13u
CL2_2_0 o2_2_0 gn2 2f
XP2_2_1 o2_2_1 o2_1_1 ph2 ph2 sg13_lv_pmos w=1.12u l=0.13u
XN2_2_1 o2_2_1 o2_1_1 gn2 gn2 sg13_lv_nmos w=0.74u l=0.13u
CL2_2_1 o2_2_1 gn2 2f
XP2_2_2 o2_2_2 o2_1_2 ph2 ph2 sg13_lv_pmos w=1.12u l=0.13u
XN2_2_2 o2_2_2 o2_1_2 gn2 gn2 sg13_lv_nmos w=0.74u l=0.13u
CL2_2_2 o2_2_2 gn2 2f
XP2_2_3 o2_2_3 o2_1_3 ph2 ph2 sg13_lv_pmos w=1.12u l=0.13u
XN2_2_3 o2_2_3 o2_1_3 gn2 gn2 sg13_lv_nmos w=0.74u l=0.13u
CL2_2_3 o2_2_3 gn2 2f
XP2_2_4 o2_2_4 o2_1_4 ph2 ph2 sg13_lv_pmos w=1.12u l=0.13u
XN2_2_4 o2_2_4 o2_1_4 gn2 gn2 sg13_lv_nmos w=0.74u l=0.13u
CL2_2_4 o2_2_4 gn2 2f
XP2_2_5 o2_2_5 o2_1_5 ph2 ph2 sg13_lv_pmos w=1.12u l=0.13u
XN2_2_5 o2_2_5 o2_1_5 gn2 gn2 sg13_lv_nmos w=0.74u l=0.13u
CL2_2_5 o2_2_5 gn2 2f
XP2_2_6 o2_2_6 o2_1_6 ph2 ph2 sg13_lv_pmos w=1.12u l=0.13u
XN2_2_6 o2_2_6 o2_1_6 gn2 gn2 sg13_lv_nmos w=0.74u l=0.13u
CL2_2_6 o2_2_6 gn2 2f
XP2_2_7 o2_2_7 o2_1_7 ph2 ph2 sg13_lv_pmos w=1.12u l=0.13u
XN2_2_7 o2_2_7 o2_1_7 gn2 gn2 sg13_lv_nmos w=0.74u l=0.13u
CL2_2_7 o2_2_7 gn2 2f
XP2_3_0 o2_3_0 o2_2_0 ph2 ph2 sg13_lv_pmos w=1.12u l=0.13u
XN2_3_0 o2_3_0 o2_2_0 gn2 gn2 sg13_lv_nmos w=0.74u l=0.13u
CL2_3_0 o2_3_0 gn2 2f
XP2_3_1 o2_3_1 o2_2_1 ph2 ph2 sg13_lv_pmos w=1.12u l=0.13u
XN2_3_1 o2_3_1 o2_2_1 gn2 gn2 sg13_lv_nmos w=0.74u l=0.13u
CL2_3_1 o2_3_1 gn2 2f
XP2_3_2 o2_3_2 o2_2_2 ph2 ph2 sg13_lv_pmos w=1.12u l=0.13u
XN2_3_2 o2_3_2 o2_2_2 gn2 gn2 sg13_lv_nmos w=0.74u l=0.13u
CL2_3_2 o2_3_2 gn2 2f
XP2_3_3 o2_3_3 o2_2_3 ph2 ph2 sg13_lv_pmos w=1.12u l=0.13u
XN2_3_3 o2_3_3 o2_2_3 gn2 gn2 sg13_lv_nmos w=0.74u l=0.13u
CL2_3_3 o2_3_3 gn2 2f
XP2_3_4 o2_3_4 o2_2_4 ph2 ph2 sg13_lv_pmos w=1.12u l=0.13u
XN2_3_4 o2_3_4 o2_2_4 gn2 gn2 sg13_lv_nmos w=0.74u l=0.13u
CL2_3_4 o2_3_4 gn2 2f
XP2_3_5 o2_3_5 o2_2_5 ph2 ph2 sg13_lv_pmos w=1.12u l=0.13u
XN2_3_5 o2_3_5 o2_2_5 gn2 gn2 sg13_lv_nmos w=0.74u l=0.13u
CL2_3_5 o2_3_5 gn2 2f
XP2_3_6 o2_3_6 o2_2_6 ph2 ph2 sg13_lv_pmos w=1.12u l=0.13u
XN2_3_6 o2_3_6 o2_2_6 gn2 gn2 sg13_lv_nmos w=0.74u l=0.13u
CL2_3_6 o2_3_6 gn2 2f
XP2_3_7 o2_3_7 o2_2_7 ph2 ph2 sg13_lv_pmos w=1.12u l=0.13u
XN2_3_7 o2_3_7 o2_2_7 gn2 gn2 sg13_lv_nmos w=0.74u l=0.13u
CL2_3_7 o2_3_7 gn2 2f
VMG3 gn3 0 0
XP3_1_0 o3_1_0 o2_3_0 ph3 ph3 sg13_lv_pmos w=1.12u l=0.13u
XN3_1_0 o3_1_0 o2_3_0 gn3 gn3 sg13_lv_nmos w=0.74u l=0.13u
CL3_1_0 o3_1_0 gn3 2f
XP3_1_1 o3_1_1 o2_3_1 ph3 ph3 sg13_lv_pmos w=1.12u l=0.13u
XN3_1_1 o3_1_1 o2_3_1 gn3 gn3 sg13_lv_nmos w=0.74u l=0.13u
CL3_1_1 o3_1_1 gn3 2f
XP3_1_2 o3_1_2 o2_3_2 ph3 ph3 sg13_lv_pmos w=1.12u l=0.13u
XN3_1_2 o3_1_2 o2_3_2 gn3 gn3 sg13_lv_nmos w=0.74u l=0.13u
CL3_1_2 o3_1_2 gn3 2f
XP3_1_3 o3_1_3 o2_3_3 ph3 ph3 sg13_lv_pmos w=1.12u l=0.13u
XN3_1_3 o3_1_3 o2_3_3 gn3 gn3 sg13_lv_nmos w=0.74u l=0.13u
CL3_1_3 o3_1_3 gn3 2f
XP3_1_4 o3_1_4 o2_3_4 ph3 ph3 sg13_lv_pmos w=1.12u l=0.13u
XN3_1_4 o3_1_4 o2_3_4 gn3 gn3 sg13_lv_nmos w=0.74u l=0.13u
CL3_1_4 o3_1_4 gn3 2f
XP3_1_5 o3_1_5 o2_3_5 ph3 ph3 sg13_lv_pmos w=1.12u l=0.13u
XN3_1_5 o3_1_5 o2_3_5 gn3 gn3 sg13_lv_nmos w=0.74u l=0.13u
CL3_1_5 o3_1_5 gn3 2f
XP3_1_6 o3_1_6 o2_3_6 ph3 ph3 sg13_lv_pmos w=1.12u l=0.13u
XN3_1_6 o3_1_6 o2_3_6 gn3 gn3 sg13_lv_nmos w=0.74u l=0.13u
CL3_1_6 o3_1_6 gn3 2f
XP3_1_7 o3_1_7 o2_3_7 ph3 ph3 sg13_lv_pmos w=1.12u l=0.13u
XN3_1_7 o3_1_7 o2_3_7 gn3 gn3 sg13_lv_nmos w=0.74u l=0.13u
CL3_1_7 o3_1_7 gn3 2f
XP3_2_0 o3_2_0 o3_1_0 ph3 ph3 sg13_lv_pmos w=1.12u l=0.13u
XN3_2_0 o3_2_0 o3_1_0 gn3 gn3 sg13_lv_nmos w=0.74u l=0.13u
CL3_2_0 o3_2_0 gn3 2f
XP3_2_1 o3_2_1 o3_1_1 ph3 ph3 sg13_lv_pmos w=1.12u l=0.13u
XN3_2_1 o3_2_1 o3_1_1 gn3 gn3 sg13_lv_nmos w=0.74u l=0.13u
CL3_2_1 o3_2_1 gn3 2f
XP3_2_2 o3_2_2 o3_1_2 ph3 ph3 sg13_lv_pmos w=1.12u l=0.13u
XN3_2_2 o3_2_2 o3_1_2 gn3 gn3 sg13_lv_nmos w=0.74u l=0.13u
CL3_2_2 o3_2_2 gn3 2f
XP3_2_3 o3_2_3 o3_1_3 ph3 ph3 sg13_lv_pmos w=1.12u l=0.13u
XN3_2_3 o3_2_3 o3_1_3 gn3 gn3 sg13_lv_nmos w=0.74u l=0.13u
CL3_2_3 o3_2_3 gn3 2f
XP3_2_4 o3_2_4 o3_1_4 ph3 ph3 sg13_lv_pmos w=1.12u l=0.13u
XN3_2_4 o3_2_4 o3_1_4 gn3 gn3 sg13_lv_nmos w=0.74u l=0.13u
CL3_2_4 o3_2_4 gn3 2f
XP3_2_5 o3_2_5 o3_1_5 ph3 ph3 sg13_lv_pmos w=1.12u l=0.13u
XN3_2_5 o3_2_5 o3_1_5 gn3 gn3 sg13_lv_nmos w=0.74u l=0.13u
CL3_2_5 o3_2_5 gn3 2f
XP3_2_6 o3_2_6 o3_1_6 ph3 ph3 sg13_lv_pmos w=1.12u l=0.13u
XN3_2_6 o3_2_6 o3_1_6 gn3 gn3 sg13_lv_nmos w=0.74u l=0.13u
CL3_2_6 o3_2_6 gn3 2f
XP3_2_7 o3_2_7 o3_1_7 ph3 ph3 sg13_lv_pmos w=1.12u l=0.13u
XN3_2_7 o3_2_7 o3_1_7 gn3 gn3 sg13_lv_nmos w=0.74u l=0.13u
CL3_2_7 o3_2_7 gn3 2f
XP3_3_0 o3_3_0 o3_2_0 ph3 ph3 sg13_lv_pmos w=1.12u l=0.13u
XN3_3_0 o3_3_0 o3_2_0 gn3 gn3 sg13_lv_nmos w=0.74u l=0.13u
CL3_3_0 o3_3_0 gn3 2f
XP3_3_1 o3_3_1 o3_2_1 ph3 ph3 sg13_lv_pmos w=1.12u l=0.13u
XN3_3_1 o3_3_1 o3_2_1 gn3 gn3 sg13_lv_nmos w=0.74u l=0.13u
CL3_3_1 o3_3_1 gn3 2f
XP3_3_2 o3_3_2 o3_2_2 ph3 ph3 sg13_lv_pmos w=1.12u l=0.13u
XN3_3_2 o3_3_2 o3_2_2 gn3 gn3 sg13_lv_nmos w=0.74u l=0.13u
CL3_3_2 o3_3_2 gn3 2f
XP3_3_3 o3_3_3 o3_2_3 ph3 ph3 sg13_lv_pmos w=1.12u l=0.13u
XN3_3_3 o3_3_3 o3_2_3 gn3 gn3 sg13_lv_nmos w=0.74u l=0.13u
CL3_3_3 o3_3_3 gn3 2f
XP3_3_4 o3_3_4 o3_2_4 ph3 ph3 sg13_lv_pmos w=1.12u l=0.13u
XN3_3_4 o3_3_4 o3_2_4 gn3 gn3 sg13_lv_nmos w=0.74u l=0.13u
CL3_3_4 o3_3_4 gn3 2f
XP3_3_5 o3_3_5 o3_2_5 ph3 ph3 sg13_lv_pmos w=1.12u l=0.13u
XN3_3_5 o3_3_5 o3_2_5 gn3 gn3 sg13_lv_nmos w=0.74u l=0.13u
CL3_3_5 o3_3_5 gn3 2f
XP3_3_6 o3_3_6 o3_2_6 ph3 ph3 sg13_lv_pmos w=1.12u l=0.13u
XN3_3_6 o3_3_6 o3_2_6 gn3 gn3 sg13_lv_nmos w=0.74u l=0.13u
CL3_3_6 o3_3_6 gn3 2f
XP3_3_7 o3_3_7 o3_2_7 ph3 ph3 sg13_lv_pmos w=1.12u l=0.13u
XN3_3_7 o3_3_7 o3_2_7 gn3 gn3 sg13_lv_nmos w=0.74u l=0.13u
CL3_3_7 o3_3_7 gn3 2f
VMG4 gn4 0 0
XP4_1_0 o4_1_0 o3_3_0 ph4 ph4 sg13_lv_pmos w=1.12u l=0.13u
XN4_1_0 o4_1_0 o3_3_0 gn4 gn4 sg13_lv_nmos w=0.74u l=0.13u
CL4_1_0 o4_1_0 gn4 2f
XP4_1_1 o4_1_1 o3_3_1 ph4 ph4 sg13_lv_pmos w=1.12u l=0.13u
XN4_1_1 o4_1_1 o3_3_1 gn4 gn4 sg13_lv_nmos w=0.74u l=0.13u
CL4_1_1 o4_1_1 gn4 2f
XP4_1_2 o4_1_2 o3_3_2 ph4 ph4 sg13_lv_pmos w=1.12u l=0.13u
XN4_1_2 o4_1_2 o3_3_2 gn4 gn4 sg13_lv_nmos w=0.74u l=0.13u
CL4_1_2 o4_1_2 gn4 2f
XP4_1_3 o4_1_3 o3_3_3 ph4 ph4 sg13_lv_pmos w=1.12u l=0.13u
XN4_1_3 o4_1_3 o3_3_3 gn4 gn4 sg13_lv_nmos w=0.74u l=0.13u
CL4_1_3 o4_1_3 gn4 2f
XP4_1_4 o4_1_4 o3_3_4 ph4 ph4 sg13_lv_pmos w=1.12u l=0.13u
XN4_1_4 o4_1_4 o3_3_4 gn4 gn4 sg13_lv_nmos w=0.74u l=0.13u
CL4_1_4 o4_1_4 gn4 2f
XP4_1_5 o4_1_5 o3_3_5 ph4 ph4 sg13_lv_pmos w=1.12u l=0.13u
XN4_1_5 o4_1_5 o3_3_5 gn4 gn4 sg13_lv_nmos w=0.74u l=0.13u
CL4_1_5 o4_1_5 gn4 2f
XP4_1_6 o4_1_6 o3_3_6 ph4 ph4 sg13_lv_pmos w=1.12u l=0.13u
XN4_1_6 o4_1_6 o3_3_6 gn4 gn4 sg13_lv_nmos w=0.74u l=0.13u
CL4_1_6 o4_1_6 gn4 2f
XP4_1_7 o4_1_7 o3_3_7 ph4 ph4 sg13_lv_pmos w=1.12u l=0.13u
XN4_1_7 o4_1_7 o3_3_7 gn4 gn4 sg13_lv_nmos w=0.74u l=0.13u
CL4_1_7 o4_1_7 gn4 2f
XP4_2_0 o4_2_0 o4_1_0 ph4 ph4 sg13_lv_pmos w=1.12u l=0.13u
XN4_2_0 o4_2_0 o4_1_0 gn4 gn4 sg13_lv_nmos w=0.74u l=0.13u
CL4_2_0 o4_2_0 gn4 2f
XP4_2_1 o4_2_1 o4_1_1 ph4 ph4 sg13_lv_pmos w=1.12u l=0.13u
XN4_2_1 o4_2_1 o4_1_1 gn4 gn4 sg13_lv_nmos w=0.74u l=0.13u
CL4_2_1 o4_2_1 gn4 2f
XP4_2_2 o4_2_2 o4_1_2 ph4 ph4 sg13_lv_pmos w=1.12u l=0.13u
XN4_2_2 o4_2_2 o4_1_2 gn4 gn4 sg13_lv_nmos w=0.74u l=0.13u
CL4_2_2 o4_2_2 gn4 2f
XP4_2_3 o4_2_3 o4_1_3 ph4 ph4 sg13_lv_pmos w=1.12u l=0.13u
XN4_2_3 o4_2_3 o4_1_3 gn4 gn4 sg13_lv_nmos w=0.74u l=0.13u
CL4_2_3 o4_2_3 gn4 2f
XP4_2_4 o4_2_4 o4_1_4 ph4 ph4 sg13_lv_pmos w=1.12u l=0.13u
XN4_2_4 o4_2_4 o4_1_4 gn4 gn4 sg13_lv_nmos w=0.74u l=0.13u
CL4_2_4 o4_2_4 gn4 2f
XP4_2_5 o4_2_5 o4_1_5 ph4 ph4 sg13_lv_pmos w=1.12u l=0.13u
XN4_2_5 o4_2_5 o4_1_5 gn4 gn4 sg13_lv_nmos w=0.74u l=0.13u
CL4_2_5 o4_2_5 gn4 2f
XP4_2_6 o4_2_6 o4_1_6 ph4 ph4 sg13_lv_pmos w=1.12u l=0.13u
XN4_2_6 o4_2_6 o4_1_6 gn4 gn4 sg13_lv_nmos w=0.74u l=0.13u
CL4_2_6 o4_2_6 gn4 2f
XP4_2_7 o4_2_7 o4_1_7 ph4 ph4 sg13_lv_pmos w=1.12u l=0.13u
XN4_2_7 o4_2_7 o4_1_7 gn4 gn4 sg13_lv_nmos w=0.74u l=0.13u
CL4_2_7 o4_2_7 gn4 2f
XP4_3_0 o4_3_0 o4_2_0 ph4 ph4 sg13_lv_pmos w=1.12u l=0.13u
XN4_3_0 o4_3_0 o4_2_0 gn4 gn4 sg13_lv_nmos w=0.74u l=0.13u
CL4_3_0 o4_3_0 gn4 2f
XP4_3_1 o4_3_1 o4_2_1 ph4 ph4 sg13_lv_pmos w=1.12u l=0.13u
XN4_3_1 o4_3_1 o4_2_1 gn4 gn4 sg13_lv_nmos w=0.74u l=0.13u
CL4_3_1 o4_3_1 gn4 2f
XP4_3_2 o4_3_2 o4_2_2 ph4 ph4 sg13_lv_pmos w=1.12u l=0.13u
XN4_3_2 o4_3_2 o4_2_2 gn4 gn4 sg13_lv_nmos w=0.74u l=0.13u
CL4_3_2 o4_3_2 gn4 2f
XP4_3_3 o4_3_3 o4_2_3 ph4 ph4 sg13_lv_pmos w=1.12u l=0.13u
XN4_3_3 o4_3_3 o4_2_3 gn4 gn4 sg13_lv_nmos w=0.74u l=0.13u
CL4_3_3 o4_3_3 gn4 2f
XP4_3_4 o4_3_4 o4_2_4 ph4 ph4 sg13_lv_pmos w=1.12u l=0.13u
XN4_3_4 o4_3_4 o4_2_4 gn4 gn4 sg13_lv_nmos w=0.74u l=0.13u
CL4_3_4 o4_3_4 gn4 2f
XP4_3_5 o4_3_5 o4_2_5 ph4 ph4 sg13_lv_pmos w=1.12u l=0.13u
XN4_3_5 o4_3_5 o4_2_5 gn4 gn4 sg13_lv_nmos w=0.74u l=0.13u
CL4_3_5 o4_3_5 gn4 2f
XP4_3_6 o4_3_6 o4_2_6 ph4 ph4 sg13_lv_pmos w=1.12u l=0.13u
XN4_3_6 o4_3_6 o4_2_6 gn4 gn4 sg13_lv_nmos w=0.74u l=0.13u
CL4_3_6 o4_3_6 gn4 2f
XP4_3_7 o4_3_7 o4_2_7 ph4 ph4 sg13_lv_pmos w=1.12u l=0.13u
XN4_3_7 o4_3_7 o4_2_7 gn4 gn4 sg13_lv_nmos w=0.74u l=0.13u
CL4_3_7 o4_3_7 gn4 2f
VMG5 gn5 0 0
XP5_1_0 o5_1_0 o4_3_0 ph5 ph5 sg13_lv_pmos w=1.12u l=0.13u
XN5_1_0 o5_1_0 o4_3_0 gn5 gn5 sg13_lv_nmos w=0.74u l=0.13u
CL5_1_0 o5_1_0 gn5 2f
XP5_1_1 o5_1_1 o4_3_1 ph5 ph5 sg13_lv_pmos w=1.12u l=0.13u
XN5_1_1 o5_1_1 o4_3_1 gn5 gn5 sg13_lv_nmos w=0.74u l=0.13u
CL5_1_1 o5_1_1 gn5 2f
XP5_1_2 o5_1_2 o4_3_2 ph5 ph5 sg13_lv_pmos w=1.12u l=0.13u
XN5_1_2 o5_1_2 o4_3_2 gn5 gn5 sg13_lv_nmos w=0.74u l=0.13u
CL5_1_2 o5_1_2 gn5 2f
XP5_1_3 o5_1_3 o4_3_3 ph5 ph5 sg13_lv_pmos w=1.12u l=0.13u
XN5_1_3 o5_1_3 o4_3_3 gn5 gn5 sg13_lv_nmos w=0.74u l=0.13u
CL5_1_3 o5_1_3 gn5 2f
XP5_1_4 o5_1_4 o4_3_4 ph5 ph5 sg13_lv_pmos w=1.12u l=0.13u
XN5_1_4 o5_1_4 o4_3_4 gn5 gn5 sg13_lv_nmos w=0.74u l=0.13u
CL5_1_4 o5_1_4 gn5 2f
XP5_1_5 o5_1_5 o4_3_5 ph5 ph5 sg13_lv_pmos w=1.12u l=0.13u
XN5_1_5 o5_1_5 o4_3_5 gn5 gn5 sg13_lv_nmos w=0.74u l=0.13u
CL5_1_5 o5_1_5 gn5 2f
XP5_1_6 o5_1_6 o4_3_6 ph5 ph5 sg13_lv_pmos w=1.12u l=0.13u
XN5_1_6 o5_1_6 o4_3_6 gn5 gn5 sg13_lv_nmos w=0.74u l=0.13u
CL5_1_6 o5_1_6 gn5 2f
XP5_1_7 o5_1_7 o4_3_7 ph5 ph5 sg13_lv_pmos w=1.12u l=0.13u
XN5_1_7 o5_1_7 o4_3_7 gn5 gn5 sg13_lv_nmos w=0.74u l=0.13u
CL5_1_7 o5_1_7 gn5 2f
XP5_2_0 o5_2_0 o5_1_0 ph5 ph5 sg13_lv_pmos w=1.12u l=0.13u
XN5_2_0 o5_2_0 o5_1_0 gn5 gn5 sg13_lv_nmos w=0.74u l=0.13u
CL5_2_0 o5_2_0 gn5 2f
XP5_2_1 o5_2_1 o5_1_1 ph5 ph5 sg13_lv_pmos w=1.12u l=0.13u
XN5_2_1 o5_2_1 o5_1_1 gn5 gn5 sg13_lv_nmos w=0.74u l=0.13u
CL5_2_1 o5_2_1 gn5 2f
XP5_2_2 o5_2_2 o5_1_2 ph5 ph5 sg13_lv_pmos w=1.12u l=0.13u
XN5_2_2 o5_2_2 o5_1_2 gn5 gn5 sg13_lv_nmos w=0.74u l=0.13u
CL5_2_2 o5_2_2 gn5 2f
XP5_2_3 o5_2_3 o5_1_3 ph5 ph5 sg13_lv_pmos w=1.12u l=0.13u
XN5_2_3 o5_2_3 o5_1_3 gn5 gn5 sg13_lv_nmos w=0.74u l=0.13u
CL5_2_3 o5_2_3 gn5 2f
XP5_2_4 o5_2_4 o5_1_4 ph5 ph5 sg13_lv_pmos w=1.12u l=0.13u
XN5_2_4 o5_2_4 o5_1_4 gn5 gn5 sg13_lv_nmos w=0.74u l=0.13u
CL5_2_4 o5_2_4 gn5 2f
XP5_2_5 o5_2_5 o5_1_5 ph5 ph5 sg13_lv_pmos w=1.12u l=0.13u
XN5_2_5 o5_2_5 o5_1_5 gn5 gn5 sg13_lv_nmos w=0.74u l=0.13u
CL5_2_5 o5_2_5 gn5 2f
XP5_2_6 o5_2_6 o5_1_6 ph5 ph5 sg13_lv_pmos w=1.12u l=0.13u
XN5_2_6 o5_2_6 o5_1_6 gn5 gn5 sg13_lv_nmos w=0.74u l=0.13u
CL5_2_6 o5_2_6 gn5 2f
XP5_2_7 o5_2_7 o5_1_7 ph5 ph5 sg13_lv_pmos w=1.12u l=0.13u
XN5_2_7 o5_2_7 o5_1_7 gn5 gn5 sg13_lv_nmos w=0.74u l=0.13u
CL5_2_7 o5_2_7 gn5 2f
XP5_3_0 o5_3_0 o5_2_0 ph5 ph5 sg13_lv_pmos w=1.12u l=0.13u
XN5_3_0 o5_3_0 o5_2_0 gn5 gn5 sg13_lv_nmos w=0.74u l=0.13u
CL5_3_0 o5_3_0 gn5 2f
XP5_3_1 o5_3_1 o5_2_1 ph5 ph5 sg13_lv_pmos w=1.12u l=0.13u
XN5_3_1 o5_3_1 o5_2_1 gn5 gn5 sg13_lv_nmos w=0.74u l=0.13u
CL5_3_1 o5_3_1 gn5 2f
XP5_3_2 o5_3_2 o5_2_2 ph5 ph5 sg13_lv_pmos w=1.12u l=0.13u
XN5_3_2 o5_3_2 o5_2_2 gn5 gn5 sg13_lv_nmos w=0.74u l=0.13u
CL5_3_2 o5_3_2 gn5 2f
XP5_3_3 o5_3_3 o5_2_3 ph5 ph5 sg13_lv_pmos w=1.12u l=0.13u
XN5_3_3 o5_3_3 o5_2_3 gn5 gn5 sg13_lv_nmos w=0.74u l=0.13u
CL5_3_3 o5_3_3 gn5 2f
XP5_3_4 o5_3_4 o5_2_4 ph5 ph5 sg13_lv_pmos w=1.12u l=0.13u
XN5_3_4 o5_3_4 o5_2_4 gn5 gn5 sg13_lv_nmos w=0.74u l=0.13u
CL5_3_4 o5_3_4 gn5 2f
XP5_3_5 o5_3_5 o5_2_5 ph5 ph5 sg13_lv_pmos w=1.12u l=0.13u
XN5_3_5 o5_3_5 o5_2_5 gn5 gn5 sg13_lv_nmos w=0.74u l=0.13u
CL5_3_5 o5_3_5 gn5 2f
XP5_3_6 o5_3_6 o5_2_6 ph5 ph5 sg13_lv_pmos w=1.12u l=0.13u
XN5_3_6 o5_3_6 o5_2_6 gn5 gn5 sg13_lv_nmos w=0.74u l=0.13u
CL5_3_6 o5_3_6 gn5 2f
XP5_3_7 o5_3_7 o5_2_7 ph5 ph5 sg13_lv_pmos w=1.12u l=0.13u
XN5_3_7 o5_3_7 o5_2_7 gn5 gn5 sg13_lv_nmos w=0.74u l=0.13u
CL5_3_7 o5_3_7 gn5 2f
VMG6 gn6 0 0
XP6_1_0 o6_1_0 o5_3_0 ph6 ph6 sg13_lv_pmos w=1.12u l=0.13u
XN6_1_0 o6_1_0 o5_3_0 gn6 gn6 sg13_lv_nmos w=0.74u l=0.13u
CL6_1_0 o6_1_0 gn6 2f
XP6_1_1 o6_1_1 o5_3_1 ph6 ph6 sg13_lv_pmos w=1.12u l=0.13u
XN6_1_1 o6_1_1 o5_3_1 gn6 gn6 sg13_lv_nmos w=0.74u l=0.13u
CL6_1_1 o6_1_1 gn6 2f
XP6_1_2 o6_1_2 o5_3_2 ph6 ph6 sg13_lv_pmos w=1.12u l=0.13u
XN6_1_2 o6_1_2 o5_3_2 gn6 gn6 sg13_lv_nmos w=0.74u l=0.13u
CL6_1_2 o6_1_2 gn6 2f
XP6_1_3 o6_1_3 o5_3_3 ph6 ph6 sg13_lv_pmos w=1.12u l=0.13u
XN6_1_3 o6_1_3 o5_3_3 gn6 gn6 sg13_lv_nmos w=0.74u l=0.13u
CL6_1_3 o6_1_3 gn6 2f
XP6_1_4 o6_1_4 o5_3_4 ph6 ph6 sg13_lv_pmos w=1.12u l=0.13u
XN6_1_4 o6_1_4 o5_3_4 gn6 gn6 sg13_lv_nmos w=0.74u l=0.13u
CL6_1_4 o6_1_4 gn6 2f
XP6_1_5 o6_1_5 o5_3_5 ph6 ph6 sg13_lv_pmos w=1.12u l=0.13u
XN6_1_5 o6_1_5 o5_3_5 gn6 gn6 sg13_lv_nmos w=0.74u l=0.13u
CL6_1_5 o6_1_5 gn6 2f
XP6_1_6 o6_1_6 o5_3_6 ph6 ph6 sg13_lv_pmos w=1.12u l=0.13u
XN6_1_6 o6_1_6 o5_3_6 gn6 gn6 sg13_lv_nmos w=0.74u l=0.13u
CL6_1_6 o6_1_6 gn6 2f
XP6_1_7 o6_1_7 o5_3_7 ph6 ph6 sg13_lv_pmos w=1.12u l=0.13u
XN6_1_7 o6_1_7 o5_3_7 gn6 gn6 sg13_lv_nmos w=0.74u l=0.13u
CL6_1_7 o6_1_7 gn6 2f
XP6_2_0 o6_2_0 o6_1_0 ph6 ph6 sg13_lv_pmos w=1.12u l=0.13u
XN6_2_0 o6_2_0 o6_1_0 gn6 gn6 sg13_lv_nmos w=0.74u l=0.13u
CL6_2_0 o6_2_0 gn6 2f
XP6_2_1 o6_2_1 o6_1_1 ph6 ph6 sg13_lv_pmos w=1.12u l=0.13u
XN6_2_1 o6_2_1 o6_1_1 gn6 gn6 sg13_lv_nmos w=0.74u l=0.13u
CL6_2_1 o6_2_1 gn6 2f
XP6_2_2 o6_2_2 o6_1_2 ph6 ph6 sg13_lv_pmos w=1.12u l=0.13u
XN6_2_2 o6_2_2 o6_1_2 gn6 gn6 sg13_lv_nmos w=0.74u l=0.13u
CL6_2_2 o6_2_2 gn6 2f
XP6_2_3 o6_2_3 o6_1_3 ph6 ph6 sg13_lv_pmos w=1.12u l=0.13u
XN6_2_3 o6_2_3 o6_1_3 gn6 gn6 sg13_lv_nmos w=0.74u l=0.13u
CL6_2_3 o6_2_3 gn6 2f
XP6_2_4 o6_2_4 o6_1_4 ph6 ph6 sg13_lv_pmos w=1.12u l=0.13u
XN6_2_4 o6_2_4 o6_1_4 gn6 gn6 sg13_lv_nmos w=0.74u l=0.13u
CL6_2_4 o6_2_4 gn6 2f
XP6_2_5 o6_2_5 o6_1_5 ph6 ph6 sg13_lv_pmos w=1.12u l=0.13u
XN6_2_5 o6_2_5 o6_1_5 gn6 gn6 sg13_lv_nmos w=0.74u l=0.13u
CL6_2_5 o6_2_5 gn6 2f
XP6_2_6 o6_2_6 o6_1_6 ph6 ph6 sg13_lv_pmos w=1.12u l=0.13u
XN6_2_6 o6_2_6 o6_1_6 gn6 gn6 sg13_lv_nmos w=0.74u l=0.13u
CL6_2_6 o6_2_6 gn6 2f
XP6_2_7 o6_2_7 o6_1_7 ph6 ph6 sg13_lv_pmos w=1.12u l=0.13u
XN6_2_7 o6_2_7 o6_1_7 gn6 gn6 sg13_lv_nmos w=0.74u l=0.13u
CL6_2_7 o6_2_7 gn6 2f
XP6_3_0 o6_3_0 o6_2_0 ph6 ph6 sg13_lv_pmos w=1.12u l=0.13u
XN6_3_0 o6_3_0 o6_2_0 gn6 gn6 sg13_lv_nmos w=0.74u l=0.13u
CL6_3_0 o6_3_0 gn6 2f
XP6_3_1 o6_3_1 o6_2_1 ph6 ph6 sg13_lv_pmos w=1.12u l=0.13u
XN6_3_1 o6_3_1 o6_2_1 gn6 gn6 sg13_lv_nmos w=0.74u l=0.13u
CL6_3_1 o6_3_1 gn6 2f
XP6_3_2 o6_3_2 o6_2_2 ph6 ph6 sg13_lv_pmos w=1.12u l=0.13u
XN6_3_2 o6_3_2 o6_2_2 gn6 gn6 sg13_lv_nmos w=0.74u l=0.13u
CL6_3_2 o6_3_2 gn6 2f
XP6_3_3 o6_3_3 o6_2_3 ph6 ph6 sg13_lv_pmos w=1.12u l=0.13u
XN6_3_3 o6_3_3 o6_2_3 gn6 gn6 sg13_lv_nmos w=0.74u l=0.13u
CL6_3_3 o6_3_3 gn6 2f
XP6_3_4 o6_3_4 o6_2_4 ph6 ph6 sg13_lv_pmos w=1.12u l=0.13u
XN6_3_4 o6_3_4 o6_2_4 gn6 gn6 sg13_lv_nmos w=0.74u l=0.13u
CL6_3_4 o6_3_4 gn6 2f
XP6_3_5 o6_3_5 o6_2_5 ph6 ph6 sg13_lv_pmos w=1.12u l=0.13u
XN6_3_5 o6_3_5 o6_2_5 gn6 gn6 sg13_lv_nmos w=0.74u l=0.13u
CL6_3_5 o6_3_5 gn6 2f
XP6_3_6 o6_3_6 o6_2_6 ph6 ph6 sg13_lv_pmos w=1.12u l=0.13u
XN6_3_6 o6_3_6 o6_2_6 gn6 gn6 sg13_lv_nmos w=0.74u l=0.13u
CL6_3_6 o6_3_6 gn6 2f
XP6_3_7 o6_3_7 o6_2_7 ph6 ph6 sg13_lv_pmos w=1.12u l=0.13u
XN6_3_7 o6_3_7 o6_2_7 gn6 gn6 sg13_lv_nmos w=0.74u l=0.13u
CL6_3_7 o6_3_7 gn6 2f
CXqph1 xqph1 0 1
BXqph1 0 xqph1 I={ -I(VPH1) }
RXqph1 xqph1 0 0.01
CXeph1 xeph1 0 1
BXeph1 0 xeph1 I={ -V(ph1)*I(VPH1) }
RXeph1 xeph1 0 0.01
CXqg1 xqg1 0 1
BXqg1 0 xqg1 I={ I(VMG1) }
RXqg1 xqg1 0 0.01
CXqph2 xqph2 0 1
BXqph2 0 xqph2 I={ -I(VPH2) }
RXqph2 xqph2 0 0.01
CXeph2 xeph2 0 1
BXeph2 0 xeph2 I={ -V(ph2)*I(VPH2) }
RXeph2 xeph2 0 0.01
CXqg2 xqg2 0 1
BXqg2 0 xqg2 I={ I(VMG2) }
RXqg2 xqg2 0 0.01
CXqph3 xqph3 0 1
BXqph3 0 xqph3 I={ -I(VPH3) }
RXqph3 xqph3 0 0.01
CXeph3 xeph3 0 1
BXeph3 0 xeph3 I={ -V(ph3)*I(VPH3) }
RXeph3 xeph3 0 0.01
CXqg3 xqg3 0 1
BXqg3 0 xqg3 I={ I(VMG3) }
RXqg3 xqg3 0 0.01
CXqph4 xqph4 0 1
BXqph4 0 xqph4 I={ -I(VPH4) }
RXqph4 xqph4 0 0.01
CXeph4 xeph4 0 1
BXeph4 0 xeph4 I={ -V(ph4)*I(VPH4) }
RXeph4 xeph4 0 0.01
CXqg4 xqg4 0 1
BXqg4 0 xqg4 I={ I(VMG4) }
RXqg4 xqg4 0 0.01
CXqph5 xqph5 0 1
BXqph5 0 xqph5 I={ -I(VPH5) }
RXqph5 xqph5 0 0.01
CXeph5 xeph5 0 1
BXeph5 0 xeph5 I={ -V(ph5)*I(VPH5) }
RXeph5 xeph5 0 0.01
CXqg5 xqg5 0 1
BXqg5 0 xqg5 I={ I(VMG5) }
RXqg5 xqg5 0 0.01
CXqph6 xqph6 0 1
BXqph6 0 xqph6 I={ -I(VPH6) }
RXqph6 xqph6 0 0.01
CXeph6 xeph6 0 1
BXeph6 0 xeph6 I={ -V(ph6)*I(VPH6) }
RXeph6 xeph6 0 0.01
CXqg6 xqg6 0 1
BXqg6 0 xqg6 I={ I(VMG6) }
RXqg6 xqg6 0 0.01
VMID4 vm4 0 DC 0.825
LH4 vm4 swn4 11n IC=0
XSSN4 swn4 ncss4 drv4 0 sg13_lv_nmos w=8u l=0.13u
XSSP4 swn4 pcss4 drv4 vh4 sg13_lv_pmos w=16u l=0.13u
XPK4 swn4 nccl4 vm4 0 sg13_lv_nmos w=0.5u l=0.13u
VNCSS4 ncss4 0 PWL(0 1.65 91.5p 1.65 92.5p 0 184.5p 0 185.5p 1.65 367.5p 1.65 368.5p 0 460.5p 0 461.5p 1.65 643.5p 1.65 644.5p 0 736.5p 0 737.5p 1.65 919.5p 1.65 920.5p 0 1012.5p 0 1013.5p 1.65 1195.5p 1.65 1196.5p 0 1288.5p 0 1289.5p 1.65 1471.5p 1.65 1472.5p 0 1564.5p 0 1565.5p 1.65 1747.5p 1.65 1748.5p 0 1840.5p 0 1841.5p 1.65 2023.5p 1.65 2024.5p 0 2116.5p 0 2117.5p 1.65)
VPCSS4 pcss4 0 PWL(0 0 91.5p 0 92.5p 1.65 184.5p 1.65 185.5p 0 367.5p 0 368.5p 1.65 460.5p 1.65 461.5p 0 643.5p 0 644.5p 1.65 736.5p 1.65 737.5p 0 919.5p 0 920.5p 1.65 1012.5p 1.65 1013.5p 0 1195.5p 0 1196.5p 1.65 1288.5p 1.65 1289.5p 0 1471.5p 0 1472.5p 1.65 1564.5p 1.65 1565.5p 0 1747.5p 0 1748.5p 1.65 1840.5p 1.65 1841.5p 0 2023.5p 0 2024.5p 1.65 2116.5p 1.65 2117.5p 0)
VHSRC4 vh4 0 DC 1.65
XCLP4 drv4 pccl4 vh4 vh4 sg13_lv_pmos w=16u l=0.13u
XCLN4 vh4 nccl4 drv4 0 sg13_lv_nmos w=8u l=0.13u
VNCCL4 nccl4 0 PWL(0 0 93.5p 0 94.5p 1.65 182.5p 1.65 183.5p 0 369.5p 0 370.5p 1.65 458.5p 1.65 459.5p 0 645.5p 0 646.5p 1.65 734.5p 1.65 735.5p 0 921.5p 0 922.5p 1.65 1010.5p 1.65 1011.5p 0 1197.5p 0 1198.5p 1.65 1286.5p 1.65 1287.5p 0 1473.5p 0 1474.5p 1.65 1562.5p 1.65 1563.5p 0 1749.5p 0 1750.5p 1.65 1838.5p 1.65 1839.5p 0 2025.5p 0 2026.5p 1.65 2114.5p 1.65 2115.5p 0)
VPCCL4 pccl4 0 PWL(0 1.65 93.5p 1.65 94.5p 0 182.5p 0 183.5p 1.65 369.5p 1.65 370.5p 0 458.5p 0 459.5p 1.65 645.5p 1.65 646.5p 0 734.5p 0 735.5p 1.65 921.5p 1.65 922.5p 0 1010.5p 0 1011.5p 1.65 1197.5p 1.65 1198.5p 0 1286.5p 0 1287.5p 1.65 1473.5p 1.65 1474.5p 0 1562.5p 0 1563.5p 1.65 1749.5p 1.65 1750.5p 0 1838.5p 0 1839.5p 1.65 2025.5p 1.65 2026.5p 0 2114.5p 0 2115.5p 1.65)
CXqvh4 xqvh4 0 1
BXqvh4 0 xqvh4 I={ -I(VHSRC4) }
RXqvh4 xqvh4 0 0.01
CXevh4 xevh4 0 1
BXevh4 0 xevh4 I={ -V(vh4)*I(VHSRC4) }
RXevh4 xevh4 0 0.01
CXqgncl4 xqgncl4 0 1
BXqgncl4 0 xqgncl4 I={ -I(VNCCL4) }
RXqgncl4 xqgncl4 0 0.01
CXqgpcl4 xqgpcl4 0 1
BXqgpcl4 0 xqgpcl4 I={ -I(VPCCL4) }
RXqgpcl4 xqgpcl4 0 0.01
CXqvm4 xqvm4 0 1
BXqvm4 0 xqvm4 I={ -I(VMID4) }
RXqvm4 xqvm4 0 0.01
CXevm4 xevm4 0 1
BXevm4 0 xevm4 I={ -V(vm4)*I(VMID4) }
RXevm4 xevm4 0 0.01
CXqgnss4 xqgnss4 0 1
BXqgnss4 0 xqgnss4 I={ -I(VNCSS4) }
RXqgnss4 xqgnss4 0 0.01
CXqgpss4 xqgpss4 0 1
BXqgpss4 0 xqgpss4 I={ -I(VPCSS4) }
RXqgpss4 xqgpss4 0 0.01
.ic V(drv4)=0 V(swn4)=0
.tran 0.1p 1932p 0 0.25p
.measure tran VRK1W2 FIND V(ph1) AT=691.000000p
.measure tran VK1_1_0W2 FIND V(o1_1_0) AT=691.000000p
.measure tran VK1_1_1W2 FIND V(o1_1_1) AT=691.000000p
.measure tran VK1_1_2W2 FIND V(o1_1_2) AT=691.000000p
.measure tran VK1_1_3W2 FIND V(o1_1_3) AT=691.000000p
.measure tran VK1_1_4W2 FIND V(o1_1_4) AT=691.000000p
.measure tran VK1_1_5W2 FIND V(o1_1_5) AT=691.000000p
.measure tran VK1_1_6W2 FIND V(o1_1_6) AT=691.000000p
.measure tran VK1_1_7W2 FIND V(o1_1_7) AT=691.000000p
.measure tran VK1_2_0W2 FIND V(o1_2_0) AT=691.000000p
.measure tran VK1_2_1W2 FIND V(o1_2_1) AT=691.000000p
.measure tran VK1_2_2W2 FIND V(o1_2_2) AT=691.000000p
.measure tran VK1_2_3W2 FIND V(o1_2_3) AT=691.000000p
.measure tran VK1_2_4W2 FIND V(o1_2_4) AT=691.000000p
.measure tran VK1_2_5W2 FIND V(o1_2_5) AT=691.000000p
.measure tran VK1_2_6W2 FIND V(o1_2_6) AT=691.000000p
.measure tran VK1_2_7W2 FIND V(o1_2_7) AT=691.000000p
.measure tran VK1_3_0W2 FIND V(o1_3_0) AT=691.000000p
.measure tran VK1_3_1W2 FIND V(o1_3_1) AT=691.000000p
.measure tran VK1_3_2W2 FIND V(o1_3_2) AT=691.000000p
.measure tran VK1_3_3W2 FIND V(o1_3_3) AT=691.000000p
.measure tran VK1_3_4W2 FIND V(o1_3_4) AT=691.000000p
.measure tran VK1_3_5W2 FIND V(o1_3_5) AT=691.000000p
.measure tran VK1_3_6W2 FIND V(o1_3_6) AT=691.000000p
.measure tran VK1_3_7W2 FIND V(o1_3_7) AT=691.000000p
.measure tran VRK2W2 FIND V(ph2) AT=783.000000p
.measure tran VK2_1_0W2 FIND V(o2_1_0) AT=783.000000p
.measure tran VK2_1_1W2 FIND V(o2_1_1) AT=783.000000p
.measure tran VK2_1_2W2 FIND V(o2_1_2) AT=783.000000p
.measure tran VK2_1_3W2 FIND V(o2_1_3) AT=783.000000p
.measure tran VK2_1_4W2 FIND V(o2_1_4) AT=783.000000p
.measure tran VK2_1_5W2 FIND V(o2_1_5) AT=783.000000p
.measure tran VK2_1_6W2 FIND V(o2_1_6) AT=783.000000p
.measure tran VK2_1_7W2 FIND V(o2_1_7) AT=783.000000p
.measure tran VK2_2_0W2 FIND V(o2_2_0) AT=783.000000p
.measure tran VK2_2_1W2 FIND V(o2_2_1) AT=783.000000p
.measure tran VK2_2_2W2 FIND V(o2_2_2) AT=783.000000p
.measure tran VK2_2_3W2 FIND V(o2_2_3) AT=783.000000p
.measure tran VK2_2_4W2 FIND V(o2_2_4) AT=783.000000p
.measure tran VK2_2_5W2 FIND V(o2_2_5) AT=783.000000p
.measure tran VK2_2_6W2 FIND V(o2_2_6) AT=783.000000p
.measure tran VK2_2_7W2 FIND V(o2_2_7) AT=783.000000p
.measure tran VK2_3_0W2 FIND V(o2_3_0) AT=783.000000p
.measure tran VK2_3_1W2 FIND V(o2_3_1) AT=783.000000p
.measure tran VK2_3_2W2 FIND V(o2_3_2) AT=783.000000p
.measure tran VK2_3_3W2 FIND V(o2_3_3) AT=783.000000p
.measure tran VK2_3_4W2 FIND V(o2_3_4) AT=783.000000p
.measure tran VK2_3_5W2 FIND V(o2_3_5) AT=783.000000p
.measure tran VK2_3_6W2 FIND V(o2_3_6) AT=783.000000p
.measure tran VK2_3_7W2 FIND V(o2_3_7) AT=783.000000p
.measure tran VRK3W2 FIND V(ph3) AT=875.000000p
.measure tran VK3_1_0W2 FIND V(o3_1_0) AT=875.000000p
.measure tran VK3_1_1W2 FIND V(o3_1_1) AT=875.000000p
.measure tran VK3_1_2W2 FIND V(o3_1_2) AT=875.000000p
.measure tran VK3_1_3W2 FIND V(o3_1_3) AT=875.000000p
.measure tran VK3_1_4W2 FIND V(o3_1_4) AT=875.000000p
.measure tran VK3_1_5W2 FIND V(o3_1_5) AT=875.000000p
.measure tran VK3_1_6W2 FIND V(o3_1_6) AT=875.000000p
.measure tran VK3_1_7W2 FIND V(o3_1_7) AT=875.000000p
.measure tran VK3_2_0W2 FIND V(o3_2_0) AT=875.000000p
.measure tran VK3_2_1W2 FIND V(o3_2_1) AT=875.000000p
.measure tran VK3_2_2W2 FIND V(o3_2_2) AT=875.000000p
.measure tran VK3_2_3W2 FIND V(o3_2_3) AT=875.000000p
.measure tran VK3_2_4W2 FIND V(o3_2_4) AT=875.000000p
.measure tran VK3_2_5W2 FIND V(o3_2_5) AT=875.000000p
.measure tran VK3_2_6W2 FIND V(o3_2_6) AT=875.000000p
.measure tran VK3_2_7W2 FIND V(o3_2_7) AT=875.000000p
.measure tran VK3_3_0W2 FIND V(o3_3_0) AT=875.000000p
.measure tran VK3_3_1W2 FIND V(o3_3_1) AT=875.000000p
.measure tran VK3_3_2W2 FIND V(o3_3_2) AT=875.000000p
.measure tran VK3_3_3W2 FIND V(o3_3_3) AT=875.000000p
.measure tran VK3_3_4W2 FIND V(o3_3_4) AT=875.000000p
.measure tran VK3_3_5W2 FIND V(o3_3_5) AT=875.000000p
.measure tran VK3_3_6W2 FIND V(o3_3_6) AT=875.000000p
.measure tran VK3_3_7W2 FIND V(o3_3_7) AT=875.000000p
.measure tran VRK4W2 FIND V(ph4) AT=967.000000p
.measure tran VK4_1_0W2 FIND V(o4_1_0) AT=967.000000p
.measure tran VK4_1_1W2 FIND V(o4_1_1) AT=967.000000p
.measure tran VK4_1_2W2 FIND V(o4_1_2) AT=967.000000p
.measure tran VK4_1_3W2 FIND V(o4_1_3) AT=967.000000p
.measure tran VK4_1_4W2 FIND V(o4_1_4) AT=967.000000p
.measure tran VK4_1_5W2 FIND V(o4_1_5) AT=967.000000p
.measure tran VK4_1_6W2 FIND V(o4_1_6) AT=967.000000p
.measure tran VK4_1_7W2 FIND V(o4_1_7) AT=967.000000p
.measure tran VK4_2_0W2 FIND V(o4_2_0) AT=967.000000p
.measure tran VK4_2_1W2 FIND V(o4_2_1) AT=967.000000p
.measure tran VK4_2_2W2 FIND V(o4_2_2) AT=967.000000p
.measure tran VK4_2_3W2 FIND V(o4_2_3) AT=967.000000p
.measure tran VK4_2_4W2 FIND V(o4_2_4) AT=967.000000p
.measure tran VK4_2_5W2 FIND V(o4_2_5) AT=967.000000p
.measure tran VK4_2_6W2 FIND V(o4_2_6) AT=967.000000p
.measure tran VK4_2_7W2 FIND V(o4_2_7) AT=967.000000p
.measure tran VK4_3_0W2 FIND V(o4_3_0) AT=967.000000p
.measure tran VK4_3_1W2 FIND V(o4_3_1) AT=967.000000p
.measure tran VK4_3_2W2 FIND V(o4_3_2) AT=967.000000p
.measure tran VK4_3_3W2 FIND V(o4_3_3) AT=967.000000p
.measure tran VK4_3_4W2 FIND V(o4_3_4) AT=967.000000p
.measure tran VK4_3_5W2 FIND V(o4_3_5) AT=967.000000p
.measure tran VK4_3_6W2 FIND V(o4_3_6) AT=967.000000p
.measure tran VK4_3_7W2 FIND V(o4_3_7) AT=967.000000p
.measure tran VRK5W2 FIND V(ph5) AT=1059.000000p
.measure tran VK5_1_0W2 FIND V(o5_1_0) AT=1059.000000p
.measure tran VK5_1_1W2 FIND V(o5_1_1) AT=1059.000000p
.measure tran VK5_1_2W2 FIND V(o5_1_2) AT=1059.000000p
.measure tran VK5_1_3W2 FIND V(o5_1_3) AT=1059.000000p
.measure tran VK5_1_4W2 FIND V(o5_1_4) AT=1059.000000p
.measure tran VK5_1_5W2 FIND V(o5_1_5) AT=1059.000000p
.measure tran VK5_1_6W2 FIND V(o5_1_6) AT=1059.000000p
.measure tran VK5_1_7W2 FIND V(o5_1_7) AT=1059.000000p
.measure tran VK5_2_0W2 FIND V(o5_2_0) AT=1059.000000p
.measure tran VK5_2_1W2 FIND V(o5_2_1) AT=1059.000000p
.measure tran VK5_2_2W2 FIND V(o5_2_2) AT=1059.000000p
.measure tran VK5_2_3W2 FIND V(o5_2_3) AT=1059.000000p
.measure tran VK5_2_4W2 FIND V(o5_2_4) AT=1059.000000p
.measure tran VK5_2_5W2 FIND V(o5_2_5) AT=1059.000000p
.measure tran VK5_2_6W2 FIND V(o5_2_6) AT=1059.000000p
.measure tran VK5_2_7W2 FIND V(o5_2_7) AT=1059.000000p
.measure tran VK5_3_0W2 FIND V(o5_3_0) AT=1059.000000p
.measure tran VK5_3_1W2 FIND V(o5_3_1) AT=1059.000000p
.measure tran VK5_3_2W2 FIND V(o5_3_2) AT=1059.000000p
.measure tran VK5_3_3W2 FIND V(o5_3_3) AT=1059.000000p
.measure tran VK5_3_4W2 FIND V(o5_3_4) AT=1059.000000p
.measure tran VK5_3_5W2 FIND V(o5_3_5) AT=1059.000000p
.measure tran VK5_3_6W2 FIND V(o5_3_6) AT=1059.000000p
.measure tran VK5_3_7W2 FIND V(o5_3_7) AT=1059.000000p
.measure tran VRK6W2 FIND V(ph6) AT=1151.000000p
.measure tran VK6_1_0W2 FIND V(o6_1_0) AT=1151.000000p
.measure tran VK6_1_1W2 FIND V(o6_1_1) AT=1151.000000p
.measure tran VK6_1_2W2 FIND V(o6_1_2) AT=1151.000000p
.measure tran VK6_1_3W2 FIND V(o6_1_3) AT=1151.000000p
.measure tran VK6_1_4W2 FIND V(o6_1_4) AT=1151.000000p
.measure tran VK6_1_5W2 FIND V(o6_1_5) AT=1151.000000p
.measure tran VK6_1_6W2 FIND V(o6_1_6) AT=1151.000000p
.measure tran VK6_1_7W2 FIND V(o6_1_7) AT=1151.000000p
.measure tran VK6_2_0W2 FIND V(o6_2_0) AT=1151.000000p
.measure tran VK6_2_1W2 FIND V(o6_2_1) AT=1151.000000p
.measure tran VK6_2_2W2 FIND V(o6_2_2) AT=1151.000000p
.measure tran VK6_2_3W2 FIND V(o6_2_3) AT=1151.000000p
.measure tran VK6_2_4W2 FIND V(o6_2_4) AT=1151.000000p
.measure tran VK6_2_5W2 FIND V(o6_2_5) AT=1151.000000p
.measure tran VK6_2_6W2 FIND V(o6_2_6) AT=1151.000000p
.measure tran VK6_2_7W2 FIND V(o6_2_7) AT=1151.000000p
.measure tran VK6_3_0W2 FIND V(o6_3_0) AT=1151.000000p
.measure tran VK6_3_1W2 FIND V(o6_3_1) AT=1151.000000p
.measure tran VK6_3_2W2 FIND V(o6_3_2) AT=1151.000000p
.measure tran VK6_3_3W2 FIND V(o6_3_3) AT=1151.000000p
.measure tran VK6_3_4W2 FIND V(o6_3_4) AT=1151.000000p
.measure tran VK6_3_5W2 FIND V(o6_3_5) AT=1151.000000p
.measure tran VK6_3_6W2 FIND V(o6_3_6) AT=1151.000000p
.measure tran VK6_3_7W2 FIND V(o6_3_7) AT=1151.000000p
.measure tran VRK1W3 FIND V(ph1) AT=967.000000p
.measure tran VK1_1_0W3 FIND V(o1_1_0) AT=967.000000p
.measure tran VK1_1_1W3 FIND V(o1_1_1) AT=967.000000p
.measure tran VK1_1_2W3 FIND V(o1_1_2) AT=967.000000p
.measure tran VK1_1_3W3 FIND V(o1_1_3) AT=967.000000p
.measure tran VK1_1_4W3 FIND V(o1_1_4) AT=967.000000p
.measure tran VK1_1_5W3 FIND V(o1_1_5) AT=967.000000p
.measure tran VK1_1_6W3 FIND V(o1_1_6) AT=967.000000p
.measure tran VK1_1_7W3 FIND V(o1_1_7) AT=967.000000p
.measure tran VK1_2_0W3 FIND V(o1_2_0) AT=967.000000p
.measure tran VK1_2_1W3 FIND V(o1_2_1) AT=967.000000p
.measure tran VK1_2_2W3 FIND V(o1_2_2) AT=967.000000p
.measure tran VK1_2_3W3 FIND V(o1_2_3) AT=967.000000p
.measure tran VK1_2_4W3 FIND V(o1_2_4) AT=967.000000p
.measure tran VK1_2_5W3 FIND V(o1_2_5) AT=967.000000p
.measure tran VK1_2_6W3 FIND V(o1_2_6) AT=967.000000p
.measure tran VK1_2_7W3 FIND V(o1_2_7) AT=967.000000p
.measure tran VK1_3_0W3 FIND V(o1_3_0) AT=967.000000p
.measure tran VK1_3_1W3 FIND V(o1_3_1) AT=967.000000p
.measure tran VK1_3_2W3 FIND V(o1_3_2) AT=967.000000p
.measure tran VK1_3_3W3 FIND V(o1_3_3) AT=967.000000p
.measure tran VK1_3_4W3 FIND V(o1_3_4) AT=967.000000p
.measure tran VK1_3_5W3 FIND V(o1_3_5) AT=967.000000p
.measure tran VK1_3_6W3 FIND V(o1_3_6) AT=967.000000p
.measure tran VK1_3_7W3 FIND V(o1_3_7) AT=967.000000p
.measure tran VRK2W3 FIND V(ph2) AT=1059.000000p
.measure tran VK2_1_0W3 FIND V(o2_1_0) AT=1059.000000p
.measure tran VK2_1_1W3 FIND V(o2_1_1) AT=1059.000000p
.measure tran VK2_1_2W3 FIND V(o2_1_2) AT=1059.000000p
.measure tran VK2_1_3W3 FIND V(o2_1_3) AT=1059.000000p
.measure tran VK2_1_4W3 FIND V(o2_1_4) AT=1059.000000p
.measure tran VK2_1_5W3 FIND V(o2_1_5) AT=1059.000000p
.measure tran VK2_1_6W3 FIND V(o2_1_6) AT=1059.000000p
.measure tran VK2_1_7W3 FIND V(o2_1_7) AT=1059.000000p
.measure tran VK2_2_0W3 FIND V(o2_2_0) AT=1059.000000p
.measure tran VK2_2_1W3 FIND V(o2_2_1) AT=1059.000000p
.measure tran VK2_2_2W3 FIND V(o2_2_2) AT=1059.000000p
.measure tran VK2_2_3W3 FIND V(o2_2_3) AT=1059.000000p
.measure tran VK2_2_4W3 FIND V(o2_2_4) AT=1059.000000p
.measure tran VK2_2_5W3 FIND V(o2_2_5) AT=1059.000000p
.measure tran VK2_2_6W3 FIND V(o2_2_6) AT=1059.000000p
.measure tran VK2_2_7W3 FIND V(o2_2_7) AT=1059.000000p
.measure tran VK2_3_0W3 FIND V(o2_3_0) AT=1059.000000p
.measure tran VK2_3_1W3 FIND V(o2_3_1) AT=1059.000000p
.measure tran VK2_3_2W3 FIND V(o2_3_2) AT=1059.000000p
.measure tran VK2_3_3W3 FIND V(o2_3_3) AT=1059.000000p
.measure tran VK2_3_4W3 FIND V(o2_3_4) AT=1059.000000p
.measure tran VK2_3_5W3 FIND V(o2_3_5) AT=1059.000000p
.measure tran VK2_3_6W3 FIND V(o2_3_6) AT=1059.000000p
.measure tran VK2_3_7W3 FIND V(o2_3_7) AT=1059.000000p
.measure tran VRK3W3 FIND V(ph3) AT=1151.000000p
.measure tran VK3_1_0W3 FIND V(o3_1_0) AT=1151.000000p
.measure tran VK3_1_1W3 FIND V(o3_1_1) AT=1151.000000p
.measure tran VK3_1_2W3 FIND V(o3_1_2) AT=1151.000000p
.measure tran VK3_1_3W3 FIND V(o3_1_3) AT=1151.000000p
.measure tran VK3_1_4W3 FIND V(o3_1_4) AT=1151.000000p
.measure tran VK3_1_5W3 FIND V(o3_1_5) AT=1151.000000p
.measure tran VK3_1_6W3 FIND V(o3_1_6) AT=1151.000000p
.measure tran VK3_1_7W3 FIND V(o3_1_7) AT=1151.000000p
.measure tran VK3_2_0W3 FIND V(o3_2_0) AT=1151.000000p
.measure tran VK3_2_1W3 FIND V(o3_2_1) AT=1151.000000p
.measure tran VK3_2_2W3 FIND V(o3_2_2) AT=1151.000000p
.measure tran VK3_2_3W3 FIND V(o3_2_3) AT=1151.000000p
.measure tran VK3_2_4W3 FIND V(o3_2_4) AT=1151.000000p
.measure tran VK3_2_5W3 FIND V(o3_2_5) AT=1151.000000p
.measure tran VK3_2_6W3 FIND V(o3_2_6) AT=1151.000000p
.measure tran VK3_2_7W3 FIND V(o3_2_7) AT=1151.000000p
.measure tran VK3_3_0W3 FIND V(o3_3_0) AT=1151.000000p
.measure tran VK3_3_1W3 FIND V(o3_3_1) AT=1151.000000p
.measure tran VK3_3_2W3 FIND V(o3_3_2) AT=1151.000000p
.measure tran VK3_3_3W3 FIND V(o3_3_3) AT=1151.000000p
.measure tran VK3_3_4W3 FIND V(o3_3_4) AT=1151.000000p
.measure tran VK3_3_5W3 FIND V(o3_3_5) AT=1151.000000p
.measure tran VK3_3_6W3 FIND V(o3_3_6) AT=1151.000000p
.measure tran VK3_3_7W3 FIND V(o3_3_7) AT=1151.000000p
.measure tran VRK4W3 FIND V(ph4) AT=1243.000000p
.measure tran VK4_1_0W3 FIND V(o4_1_0) AT=1243.000000p
.measure tran VK4_1_1W3 FIND V(o4_1_1) AT=1243.000000p
.measure tran VK4_1_2W3 FIND V(o4_1_2) AT=1243.000000p
.measure tran VK4_1_3W3 FIND V(o4_1_3) AT=1243.000000p
.measure tran VK4_1_4W3 FIND V(o4_1_4) AT=1243.000000p
.measure tran VK4_1_5W3 FIND V(o4_1_5) AT=1243.000000p
.measure tran VK4_1_6W3 FIND V(o4_1_6) AT=1243.000000p
.measure tran VK4_1_7W3 FIND V(o4_1_7) AT=1243.000000p
.measure tran VK4_2_0W3 FIND V(o4_2_0) AT=1243.000000p
.measure tran VK4_2_1W3 FIND V(o4_2_1) AT=1243.000000p
.measure tran VK4_2_2W3 FIND V(o4_2_2) AT=1243.000000p
.measure tran VK4_2_3W3 FIND V(o4_2_3) AT=1243.000000p
.measure tran VK4_2_4W3 FIND V(o4_2_4) AT=1243.000000p
.measure tran VK4_2_5W3 FIND V(o4_2_5) AT=1243.000000p
.measure tran VK4_2_6W3 FIND V(o4_2_6) AT=1243.000000p
.measure tran VK4_2_7W3 FIND V(o4_2_7) AT=1243.000000p
.measure tran VK4_3_0W3 FIND V(o4_3_0) AT=1243.000000p
.measure tran VK4_3_1W3 FIND V(o4_3_1) AT=1243.000000p
.measure tran VK4_3_2W3 FIND V(o4_3_2) AT=1243.000000p
.measure tran VK4_3_3W3 FIND V(o4_3_3) AT=1243.000000p
.measure tran VK4_3_4W3 FIND V(o4_3_4) AT=1243.000000p
.measure tran VK4_3_5W3 FIND V(o4_3_5) AT=1243.000000p
.measure tran VK4_3_6W3 FIND V(o4_3_6) AT=1243.000000p
.measure tran VK4_3_7W3 FIND V(o4_3_7) AT=1243.000000p
.measure tran VRK5W3 FIND V(ph5) AT=1335.000000p
.measure tran VK5_1_0W3 FIND V(o5_1_0) AT=1335.000000p
.measure tran VK5_1_1W3 FIND V(o5_1_1) AT=1335.000000p
.measure tran VK5_1_2W3 FIND V(o5_1_2) AT=1335.000000p
.measure tran VK5_1_3W3 FIND V(o5_1_3) AT=1335.000000p
.measure tran VK5_1_4W3 FIND V(o5_1_4) AT=1335.000000p
.measure tran VK5_1_5W3 FIND V(o5_1_5) AT=1335.000000p
.measure tran VK5_1_6W3 FIND V(o5_1_6) AT=1335.000000p
.measure tran VK5_1_7W3 FIND V(o5_1_7) AT=1335.000000p
.measure tran VK5_2_0W3 FIND V(o5_2_0) AT=1335.000000p
.measure tran VK5_2_1W3 FIND V(o5_2_1) AT=1335.000000p
.measure tran VK5_2_2W3 FIND V(o5_2_2) AT=1335.000000p
.measure tran VK5_2_3W3 FIND V(o5_2_3) AT=1335.000000p
.measure tran VK5_2_4W3 FIND V(o5_2_4) AT=1335.000000p
.measure tran VK5_2_5W3 FIND V(o5_2_5) AT=1335.000000p
.measure tran VK5_2_6W3 FIND V(o5_2_6) AT=1335.000000p
.measure tran VK5_2_7W3 FIND V(o5_2_7) AT=1335.000000p
.measure tran VK5_3_0W3 FIND V(o5_3_0) AT=1335.000000p
.measure tran VK5_3_1W3 FIND V(o5_3_1) AT=1335.000000p
.measure tran VK5_3_2W3 FIND V(o5_3_2) AT=1335.000000p
.measure tran VK5_3_3W3 FIND V(o5_3_3) AT=1335.000000p
.measure tran VK5_3_4W3 FIND V(o5_3_4) AT=1335.000000p
.measure tran VK5_3_5W3 FIND V(o5_3_5) AT=1335.000000p
.measure tran VK5_3_6W3 FIND V(o5_3_6) AT=1335.000000p
.measure tran VK5_3_7W3 FIND V(o5_3_7) AT=1335.000000p
.measure tran VRK6W3 FIND V(ph6) AT=1427.000000p
.measure tran VK6_1_0W3 FIND V(o6_1_0) AT=1427.000000p
.measure tran VK6_1_1W3 FIND V(o6_1_1) AT=1427.000000p
.measure tran VK6_1_2W3 FIND V(o6_1_2) AT=1427.000000p
.measure tran VK6_1_3W3 FIND V(o6_1_3) AT=1427.000000p
.measure tran VK6_1_4W3 FIND V(o6_1_4) AT=1427.000000p
.measure tran VK6_1_5W3 FIND V(o6_1_5) AT=1427.000000p
.measure tran VK6_1_6W3 FIND V(o6_1_6) AT=1427.000000p
.measure tran VK6_1_7W3 FIND V(o6_1_7) AT=1427.000000p
.measure tran VK6_2_0W3 FIND V(o6_2_0) AT=1427.000000p
.measure tran VK6_2_1W3 FIND V(o6_2_1) AT=1427.000000p
.measure tran VK6_2_2W3 FIND V(o6_2_2) AT=1427.000000p
.measure tran VK6_2_3W3 FIND V(o6_2_3) AT=1427.000000p
.measure tran VK6_2_4W3 FIND V(o6_2_4) AT=1427.000000p
.measure tran VK6_2_5W3 FIND V(o6_2_5) AT=1427.000000p
.measure tran VK6_2_6W3 FIND V(o6_2_6) AT=1427.000000p
.measure tran VK6_2_7W3 FIND V(o6_2_7) AT=1427.000000p
.measure tran VK6_3_0W3 FIND V(o6_3_0) AT=1427.000000p
.measure tran VK6_3_1W3 FIND V(o6_3_1) AT=1427.000000p
.measure tran VK6_3_2W3 FIND V(o6_3_2) AT=1427.000000p
.measure tran VK6_3_3W3 FIND V(o6_3_3) AT=1427.000000p
.measure tran VK6_3_4W3 FIND V(o6_3_4) AT=1427.000000p
.measure tran VK6_3_5W3 FIND V(o6_3_5) AT=1427.000000p
.measure tran VK6_3_6W3 FIND V(o6_3_6) AT=1427.000000p
.measure tran VK6_3_7W3 FIND V(o6_3_7) AT=1427.000000p
.measure tran VRK1W4 FIND V(ph1) AT=1243.000000p
.measure tran VK1_1_0W4 FIND V(o1_1_0) AT=1243.000000p
.measure tran VK1_1_1W4 FIND V(o1_1_1) AT=1243.000000p
.measure tran VK1_1_2W4 FIND V(o1_1_2) AT=1243.000000p
.measure tran VK1_1_3W4 FIND V(o1_1_3) AT=1243.000000p
.measure tran VK1_1_4W4 FIND V(o1_1_4) AT=1243.000000p
.measure tran VK1_1_5W4 FIND V(o1_1_5) AT=1243.000000p
.measure tran VK1_1_6W4 FIND V(o1_1_6) AT=1243.000000p
.measure tran VK1_1_7W4 FIND V(o1_1_7) AT=1243.000000p
.measure tran VK1_2_0W4 FIND V(o1_2_0) AT=1243.000000p
.measure tran VK1_2_1W4 FIND V(o1_2_1) AT=1243.000000p
.measure tran VK1_2_2W4 FIND V(o1_2_2) AT=1243.000000p
.measure tran VK1_2_3W4 FIND V(o1_2_3) AT=1243.000000p
.measure tran VK1_2_4W4 FIND V(o1_2_4) AT=1243.000000p
.measure tran VK1_2_5W4 FIND V(o1_2_5) AT=1243.000000p
.measure tran VK1_2_6W4 FIND V(o1_2_6) AT=1243.000000p
.measure tran VK1_2_7W4 FIND V(o1_2_7) AT=1243.000000p
.measure tran VK1_3_0W4 FIND V(o1_3_0) AT=1243.000000p
.measure tran VK1_3_1W4 FIND V(o1_3_1) AT=1243.000000p
.measure tran VK1_3_2W4 FIND V(o1_3_2) AT=1243.000000p
.measure tran VK1_3_3W4 FIND V(o1_3_3) AT=1243.000000p
.measure tran VK1_3_4W4 FIND V(o1_3_4) AT=1243.000000p
.measure tran VK1_3_5W4 FIND V(o1_3_5) AT=1243.000000p
.measure tran VK1_3_6W4 FIND V(o1_3_6) AT=1243.000000p
.measure tran VK1_3_7W4 FIND V(o1_3_7) AT=1243.000000p
.measure tran VRK2W4 FIND V(ph2) AT=1335.000000p
.measure tran VK2_1_0W4 FIND V(o2_1_0) AT=1335.000000p
.measure tran VK2_1_1W4 FIND V(o2_1_1) AT=1335.000000p
.measure tran VK2_1_2W4 FIND V(o2_1_2) AT=1335.000000p
.measure tran VK2_1_3W4 FIND V(o2_1_3) AT=1335.000000p
.measure tran VK2_1_4W4 FIND V(o2_1_4) AT=1335.000000p
.measure tran VK2_1_5W4 FIND V(o2_1_5) AT=1335.000000p
.measure tran VK2_1_6W4 FIND V(o2_1_6) AT=1335.000000p
.measure tran VK2_1_7W4 FIND V(o2_1_7) AT=1335.000000p
.measure tran VK2_2_0W4 FIND V(o2_2_0) AT=1335.000000p
.measure tran VK2_2_1W4 FIND V(o2_2_1) AT=1335.000000p
.measure tran VK2_2_2W4 FIND V(o2_2_2) AT=1335.000000p
.measure tran VK2_2_3W4 FIND V(o2_2_3) AT=1335.000000p
.measure tran VK2_2_4W4 FIND V(o2_2_4) AT=1335.000000p
.measure tran VK2_2_5W4 FIND V(o2_2_5) AT=1335.000000p
.measure tran VK2_2_6W4 FIND V(o2_2_6) AT=1335.000000p
.measure tran VK2_2_7W4 FIND V(o2_2_7) AT=1335.000000p
.measure tran VK2_3_0W4 FIND V(o2_3_0) AT=1335.000000p
.measure tran VK2_3_1W4 FIND V(o2_3_1) AT=1335.000000p
.measure tran VK2_3_2W4 FIND V(o2_3_2) AT=1335.000000p
.measure tran VK2_3_3W4 FIND V(o2_3_3) AT=1335.000000p
.measure tran VK2_3_4W4 FIND V(o2_3_4) AT=1335.000000p
.measure tran VK2_3_5W4 FIND V(o2_3_5) AT=1335.000000p
.measure tran VK2_3_6W4 FIND V(o2_3_6) AT=1335.000000p
.measure tran VK2_3_7W4 FIND V(o2_3_7) AT=1335.000000p
.measure tran VRK3W4 FIND V(ph3) AT=1427.000000p
.measure tran VK3_1_0W4 FIND V(o3_1_0) AT=1427.000000p
.measure tran VK3_1_1W4 FIND V(o3_1_1) AT=1427.000000p
.measure tran VK3_1_2W4 FIND V(o3_1_2) AT=1427.000000p
.measure tran VK3_1_3W4 FIND V(o3_1_3) AT=1427.000000p
.measure tran VK3_1_4W4 FIND V(o3_1_4) AT=1427.000000p
.measure tran VK3_1_5W4 FIND V(o3_1_5) AT=1427.000000p
.measure tran VK3_1_6W4 FIND V(o3_1_6) AT=1427.000000p
.measure tran VK3_1_7W4 FIND V(o3_1_7) AT=1427.000000p
.measure tran VK3_2_0W4 FIND V(o3_2_0) AT=1427.000000p
.measure tran VK3_2_1W4 FIND V(o3_2_1) AT=1427.000000p
.measure tran VK3_2_2W4 FIND V(o3_2_2) AT=1427.000000p
.measure tran VK3_2_3W4 FIND V(o3_2_3) AT=1427.000000p
.measure tran VK3_2_4W4 FIND V(o3_2_4) AT=1427.000000p
.measure tran VK3_2_5W4 FIND V(o3_2_5) AT=1427.000000p
.measure tran VK3_2_6W4 FIND V(o3_2_6) AT=1427.000000p
.measure tran VK3_2_7W4 FIND V(o3_2_7) AT=1427.000000p
.measure tran VK3_3_0W4 FIND V(o3_3_0) AT=1427.000000p
.measure tran VK3_3_1W4 FIND V(o3_3_1) AT=1427.000000p
.measure tran VK3_3_2W4 FIND V(o3_3_2) AT=1427.000000p
.measure tran VK3_3_3W4 FIND V(o3_3_3) AT=1427.000000p
.measure tran VK3_3_4W4 FIND V(o3_3_4) AT=1427.000000p
.measure tran VK3_3_5W4 FIND V(o3_3_5) AT=1427.000000p
.measure tran VK3_3_6W4 FIND V(o3_3_6) AT=1427.000000p
.measure tran VK3_3_7W4 FIND V(o3_3_7) AT=1427.000000p
.measure tran VRK4W4 FIND V(ph4) AT=1519.000000p
.measure tran VK4_1_0W4 FIND V(o4_1_0) AT=1519.000000p
.measure tran VK4_1_1W4 FIND V(o4_1_1) AT=1519.000000p
.measure tran VK4_1_2W4 FIND V(o4_1_2) AT=1519.000000p
.measure tran VK4_1_3W4 FIND V(o4_1_3) AT=1519.000000p
.measure tran VK4_1_4W4 FIND V(o4_1_4) AT=1519.000000p
.measure tran VK4_1_5W4 FIND V(o4_1_5) AT=1519.000000p
.measure tran VK4_1_6W4 FIND V(o4_1_6) AT=1519.000000p
.measure tran VK4_1_7W4 FIND V(o4_1_7) AT=1519.000000p
.measure tran VK4_2_0W4 FIND V(o4_2_0) AT=1519.000000p
.measure tran VK4_2_1W4 FIND V(o4_2_1) AT=1519.000000p
.measure tran VK4_2_2W4 FIND V(o4_2_2) AT=1519.000000p
.measure tran VK4_2_3W4 FIND V(o4_2_3) AT=1519.000000p
.measure tran VK4_2_4W4 FIND V(o4_2_4) AT=1519.000000p
.measure tran VK4_2_5W4 FIND V(o4_2_5) AT=1519.000000p
.measure tran VK4_2_6W4 FIND V(o4_2_6) AT=1519.000000p
.measure tran VK4_2_7W4 FIND V(o4_2_7) AT=1519.000000p
.measure tran VK4_3_0W4 FIND V(o4_3_0) AT=1519.000000p
.measure tran VK4_3_1W4 FIND V(o4_3_1) AT=1519.000000p
.measure tran VK4_3_2W4 FIND V(o4_3_2) AT=1519.000000p
.measure tran VK4_3_3W4 FIND V(o4_3_3) AT=1519.000000p
.measure tran VK4_3_4W4 FIND V(o4_3_4) AT=1519.000000p
.measure tran VK4_3_5W4 FIND V(o4_3_5) AT=1519.000000p
.measure tran VK4_3_6W4 FIND V(o4_3_6) AT=1519.000000p
.measure tran VK4_3_7W4 FIND V(o4_3_7) AT=1519.000000p
.measure tran VRK5W4 FIND V(ph5) AT=1611.000000p
.measure tran VK5_1_0W4 FIND V(o5_1_0) AT=1611.000000p
.measure tran VK5_1_1W4 FIND V(o5_1_1) AT=1611.000000p
.measure tran VK5_1_2W4 FIND V(o5_1_2) AT=1611.000000p
.measure tran VK5_1_3W4 FIND V(o5_1_3) AT=1611.000000p
.measure tran VK5_1_4W4 FIND V(o5_1_4) AT=1611.000000p
.measure tran VK5_1_5W4 FIND V(o5_1_5) AT=1611.000000p
.measure tran VK5_1_6W4 FIND V(o5_1_6) AT=1611.000000p
.measure tran VK5_1_7W4 FIND V(o5_1_7) AT=1611.000000p
.measure tran VK5_2_0W4 FIND V(o5_2_0) AT=1611.000000p
.measure tran VK5_2_1W4 FIND V(o5_2_1) AT=1611.000000p
.measure tran VK5_2_2W4 FIND V(o5_2_2) AT=1611.000000p
.measure tran VK5_2_3W4 FIND V(o5_2_3) AT=1611.000000p
.measure tran VK5_2_4W4 FIND V(o5_2_4) AT=1611.000000p
.measure tran VK5_2_5W4 FIND V(o5_2_5) AT=1611.000000p
.measure tran VK5_2_6W4 FIND V(o5_2_6) AT=1611.000000p
.measure tran VK5_2_7W4 FIND V(o5_2_7) AT=1611.000000p
.measure tran VK5_3_0W4 FIND V(o5_3_0) AT=1611.000000p
.measure tran VK5_3_1W4 FIND V(o5_3_1) AT=1611.000000p
.measure tran VK5_3_2W4 FIND V(o5_3_2) AT=1611.000000p
.measure tran VK5_3_3W4 FIND V(o5_3_3) AT=1611.000000p
.measure tran VK5_3_4W4 FIND V(o5_3_4) AT=1611.000000p
.measure tran VK5_3_5W4 FIND V(o5_3_5) AT=1611.000000p
.measure tran VK5_3_6W4 FIND V(o5_3_6) AT=1611.000000p
.measure tran VK5_3_7W4 FIND V(o5_3_7) AT=1611.000000p
.measure tran VRK6W4 FIND V(ph6) AT=1703.000000p
.measure tran VK6_1_0W4 FIND V(o6_1_0) AT=1703.000000p
.measure tran VK6_1_1W4 FIND V(o6_1_1) AT=1703.000000p
.measure tran VK6_1_2W4 FIND V(o6_1_2) AT=1703.000000p
.measure tran VK6_1_3W4 FIND V(o6_1_3) AT=1703.000000p
.measure tran VK6_1_4W4 FIND V(o6_1_4) AT=1703.000000p
.measure tran VK6_1_5W4 FIND V(o6_1_5) AT=1703.000000p
.measure tran VK6_1_6W4 FIND V(o6_1_6) AT=1703.000000p
.measure tran VK6_1_7W4 FIND V(o6_1_7) AT=1703.000000p
.measure tran VK6_2_0W4 FIND V(o6_2_0) AT=1703.000000p
.measure tran VK6_2_1W4 FIND V(o6_2_1) AT=1703.000000p
.measure tran VK6_2_2W4 FIND V(o6_2_2) AT=1703.000000p
.measure tran VK6_2_3W4 FIND V(o6_2_3) AT=1703.000000p
.measure tran VK6_2_4W4 FIND V(o6_2_4) AT=1703.000000p
.measure tran VK6_2_5W4 FIND V(o6_2_5) AT=1703.000000p
.measure tran VK6_2_6W4 FIND V(o6_2_6) AT=1703.000000p
.measure tran VK6_2_7W4 FIND V(o6_2_7) AT=1703.000000p
.measure tran VK6_3_0W4 FIND V(o6_3_0) AT=1703.000000p
.measure tran VK6_3_1W4 FIND V(o6_3_1) AT=1703.000000p
.measure tran VK6_3_2W4 FIND V(o6_3_2) AT=1703.000000p
.measure tran VK6_3_3W4 FIND V(o6_3_3) AT=1703.000000p
.measure tran VK6_3_4W4 FIND V(o6_3_4) AT=1703.000000p
.measure tran VK6_3_5W4 FIND V(o6_3_5) AT=1703.000000p
.measure tran VK6_3_6W4 FIND V(o6_3_6) AT=1703.000000p
.measure tran VK6_3_7W4 FIND V(o6_3_7) AT=1703.000000p
.measure tran QPH1T2 FIND V(xqph1) AT=553.000000p
.measure tran EPH1T2 FIND V(xeph1) AT=553.000000p
.measure tran QPH1R2 FIND V(xqph1) AT=645.000000p
.measure tran EPH1R2 FIND V(xeph1) AT=645.000000p
.measure tran QPH1H2 FIND V(xqph1) AT=737.000000p
.measure tran EPH1H2 FIND V(xeph1) AT=737.000000p
.measure tran QPH1T3 FIND V(xqph1) AT=829.000000p
.measure tran EPH1T3 FIND V(xeph1) AT=829.000000p
.measure tran QPH1R3 FIND V(xqph1) AT=921.000000p
.measure tran EPH1R3 FIND V(xeph1) AT=921.000000p
.measure tran QPH1H3 FIND V(xqph1) AT=1013.000000p
.measure tran EPH1H3 FIND V(xeph1) AT=1013.000000p
.measure tran QPH1T4 FIND V(xqph1) AT=1105.000000p
.measure tran EPH1T4 FIND V(xeph1) AT=1105.000000p
.measure tran QPH1R4 FIND V(xqph1) AT=1197.000000p
.measure tran EPH1R4 FIND V(xeph1) AT=1197.000000p
.measure tran QPH1H4 FIND V(xqph1) AT=1289.000000p
.measure tran EPH1H4 FIND V(xeph1) AT=1289.000000p
.measure tran QPH1T5 FIND V(xqph1) AT=1381.000000p
.measure tran EPH1T5 FIND V(xeph1) AT=1381.000000p
.measure tran QPH2T2 FIND V(xqph2) AT=645.000000p
.measure tran EPH2T2 FIND V(xeph2) AT=645.000000p
.measure tran QPH2R2 FIND V(xqph2) AT=737.000000p
.measure tran EPH2R2 FIND V(xeph2) AT=737.000000p
.measure tran QPH2H2 FIND V(xqph2) AT=829.000000p
.measure tran EPH2H2 FIND V(xeph2) AT=829.000000p
.measure tran QPH2T3 FIND V(xqph2) AT=921.000000p
.measure tran EPH2T3 FIND V(xeph2) AT=921.000000p
.measure tran QPH2R3 FIND V(xqph2) AT=1013.000000p
.measure tran EPH2R3 FIND V(xeph2) AT=1013.000000p
.measure tran QPH2H3 FIND V(xqph2) AT=1105.000000p
.measure tran EPH2H3 FIND V(xeph2) AT=1105.000000p
.measure tran QPH2T4 FIND V(xqph2) AT=1197.000000p
.measure tran EPH2T4 FIND V(xeph2) AT=1197.000000p
.measure tran QPH2R4 FIND V(xqph2) AT=1289.000000p
.measure tran EPH2R4 FIND V(xeph2) AT=1289.000000p
.measure tran QPH2H4 FIND V(xqph2) AT=1381.000000p
.measure tran EPH2H4 FIND V(xeph2) AT=1381.000000p
.measure tran QPH2T5 FIND V(xqph2) AT=1473.000000p
.measure tran EPH2T5 FIND V(xeph2) AT=1473.000000p
.measure tran QPH3T2 FIND V(xqph3) AT=737.000000p
.measure tran EPH3T2 FIND V(xeph3) AT=737.000000p
.measure tran QPH3R2 FIND V(xqph3) AT=829.000000p
.measure tran EPH3R2 FIND V(xeph3) AT=829.000000p
.measure tran QPH3H2 FIND V(xqph3) AT=921.000000p
.measure tran EPH3H2 FIND V(xeph3) AT=921.000000p
.measure tran QPH3T3 FIND V(xqph3) AT=1013.000000p
.measure tran EPH3T3 FIND V(xeph3) AT=1013.000000p
.measure tran QPH3R3 FIND V(xqph3) AT=1105.000000p
.measure tran EPH3R3 FIND V(xeph3) AT=1105.000000p
.measure tran QPH3H3 FIND V(xqph3) AT=1197.000000p
.measure tran EPH3H3 FIND V(xeph3) AT=1197.000000p
.measure tran QPH3T4 FIND V(xqph3) AT=1289.000000p
.measure tran EPH3T4 FIND V(xeph3) AT=1289.000000p
.measure tran QPH3R4 FIND V(xqph3) AT=1381.000000p
.measure tran EPH3R4 FIND V(xeph3) AT=1381.000000p
.measure tran QPH3H4 FIND V(xqph3) AT=1473.000000p
.measure tran EPH3H4 FIND V(xeph3) AT=1473.000000p
.measure tran QPH3T5 FIND V(xqph3) AT=1565.000000p
.measure tran EPH3T5 FIND V(xeph3) AT=1565.000000p
.measure tran QPH4T2 FIND V(xqph4) AT=829.000000p
.measure tran EPH4T2 FIND V(xeph4) AT=829.000000p
.measure tran QPH4R2 FIND V(xqph4) AT=921.000000p
.measure tran EPH4R2 FIND V(xeph4) AT=921.000000p
.measure tran QPH4H2 FIND V(xqph4) AT=1013.000000p
.measure tran EPH4H2 FIND V(xeph4) AT=1013.000000p
.measure tran QPH4T3 FIND V(xqph4) AT=1105.000000p
.measure tran EPH4T3 FIND V(xeph4) AT=1105.000000p
.measure tran QPH4R3 FIND V(xqph4) AT=1197.000000p
.measure tran EPH4R3 FIND V(xeph4) AT=1197.000000p
.measure tran QPH4H3 FIND V(xqph4) AT=1289.000000p
.measure tran EPH4H3 FIND V(xeph4) AT=1289.000000p
.measure tran QPH4T4 FIND V(xqph4) AT=1381.000000p
.measure tran EPH4T4 FIND V(xeph4) AT=1381.000000p
.measure tran QPH4R4 FIND V(xqph4) AT=1473.000000p
.measure tran EPH4R4 FIND V(xeph4) AT=1473.000000p
.measure tran QPH4H4 FIND V(xqph4) AT=1565.000000p
.measure tran EPH4H4 FIND V(xeph4) AT=1565.000000p
.measure tran QPH4T5 FIND V(xqph4) AT=1657.000000p
.measure tran EPH4T5 FIND V(xeph4) AT=1657.000000p
.measure tran QPH5T2 FIND V(xqph5) AT=921.000000p
.measure tran EPH5T2 FIND V(xeph5) AT=921.000000p
.measure tran QPH5R2 FIND V(xqph5) AT=1013.000000p
.measure tran EPH5R2 FIND V(xeph5) AT=1013.000000p
.measure tran QPH5H2 FIND V(xqph5) AT=1105.000000p
.measure tran EPH5H2 FIND V(xeph5) AT=1105.000000p
.measure tran QPH5T3 FIND V(xqph5) AT=1197.000000p
.measure tran EPH5T3 FIND V(xeph5) AT=1197.000000p
.measure tran QPH5R3 FIND V(xqph5) AT=1289.000000p
.measure tran EPH5R3 FIND V(xeph5) AT=1289.000000p
.measure tran QPH5H3 FIND V(xqph5) AT=1381.000000p
.measure tran EPH5H3 FIND V(xeph5) AT=1381.000000p
.measure tran QPH5T4 FIND V(xqph5) AT=1473.000000p
.measure tran EPH5T4 FIND V(xeph5) AT=1473.000000p
.measure tran QPH5R4 FIND V(xqph5) AT=1565.000000p
.measure tran EPH5R4 FIND V(xeph5) AT=1565.000000p
.measure tran QPH5H4 FIND V(xqph5) AT=1657.000000p
.measure tran EPH5H4 FIND V(xeph5) AT=1657.000000p
.measure tran QPH5T5 FIND V(xqph5) AT=1749.000000p
.measure tran EPH5T5 FIND V(xeph5) AT=1749.000000p
.measure tran QPH6T2 FIND V(xqph6) AT=1013.000000p
.measure tran EPH6T2 FIND V(xeph6) AT=1013.000000p
.measure tran QPH6R2 FIND V(xqph6) AT=1105.000000p
.measure tran EPH6R2 FIND V(xeph6) AT=1105.000000p
.measure tran QPH6H2 FIND V(xqph6) AT=1197.000000p
.measure tran EPH6H2 FIND V(xeph6) AT=1197.000000p
.measure tran QPH6T3 FIND V(xqph6) AT=1289.000000p
.measure tran EPH6T3 FIND V(xeph6) AT=1289.000000p
.measure tran QPH6R3 FIND V(xqph6) AT=1381.000000p
.measure tran EPH6R3 FIND V(xeph6) AT=1381.000000p
.measure tran QPH6H3 FIND V(xqph6) AT=1473.000000p
.measure tran EPH6H3 FIND V(xeph6) AT=1473.000000p
.measure tran QPH6T4 FIND V(xqph6) AT=1565.000000p
.measure tran EPH6T4 FIND V(xeph6) AT=1565.000000p
.measure tran QPH6R4 FIND V(xqph6) AT=1657.000000p
.measure tran EPH6R4 FIND V(xeph6) AT=1657.000000p
.measure tran QPH6H4 FIND V(xqph6) AT=1749.000000p
.measure tran EPH6H4 FIND V(xeph6) AT=1749.000000p
.measure tran QPH6T5 FIND V(xqph6) AT=1841.000000p
.measure tran EPH6T5 FIND V(xeph6) AT=1841.000000p
.measure tran DRV_QVM4_W2 FIND V(xqvm4) AT=553.000000p
.measure tran DRV_QVM4_W3 FIND V(xqvm4) AT=829.000000p
.measure tran DRV_QVM4_W4 FIND V(xqvm4) AT=1105.000000p
.measure tran DRV_QVM4_W5 FIND V(xqvm4) AT=1381.000000p
.measure tran DRV_EVM4_W2 FIND V(xevm4) AT=553.000000p
.measure tran DRV_EVM4_W3 FIND V(xevm4) AT=829.000000p
.measure tran DRV_EVM4_W4 FIND V(xevm4) AT=1105.000000p
.measure tran DRV_EVM4_W5 FIND V(xevm4) AT=1381.000000p
.measure tran DRV_QGNSS4_W2 FIND V(xqgnss4) AT=553.000000p
.measure tran DRV_QGNSS4_W3 FIND V(xqgnss4) AT=829.000000p
.measure tran DRV_QGNSS4_W4 FIND V(xqgnss4) AT=1105.000000p
.measure tran DRV_QGNSS4_W5 FIND V(xqgnss4) AT=1381.000000p
.measure tran DRV_QGPSS4_W2 FIND V(xqgpss4) AT=553.000000p
.measure tran DRV_QGPSS4_W3 FIND V(xqgpss4) AT=829.000000p
.measure tran DRV_QGPSS4_W4 FIND V(xqgpss4) AT=1105.000000p
.measure tran DRV_QGPSS4_W5 FIND V(xqgpss4) AT=1381.000000p
.measure tran DRV_QVH4_W2 FIND V(xqvh4) AT=553.000000p
.measure tran DRV_QVH4_W3 FIND V(xqvh4) AT=829.000000p
.measure tran DRV_QVH4_W4 FIND V(xqvh4) AT=1105.000000p
.measure tran DRV_QVH4_W5 FIND V(xqvh4) AT=1381.000000p
.measure tran DRV_EVH4_W2 FIND V(xevh4) AT=553.000000p
.measure tran DRV_EVH4_W3 FIND V(xevh4) AT=829.000000p
.measure tran DRV_EVH4_W4 FIND V(xevh4) AT=1105.000000p
.measure tran DRV_EVH4_W5 FIND V(xevh4) AT=1381.000000p
.measure tran DRV_QGNCL4_W2 FIND V(xqgncl4) AT=553.000000p
.measure tran DRV_QGNCL4_W3 FIND V(xqgncl4) AT=829.000000p
.measure tran DRV_QGNCL4_W4 FIND V(xqgncl4) AT=1105.000000p
.measure tran DRV_QGNCL4_W5 FIND V(xqgncl4) AT=1381.000000p
.measure tran DRV_QGPCL4_W2 FIND V(xqgpcl4) AT=553.000000p
.measure tran DRV_QGPCL4_W3 FIND V(xqgpcl4) AT=829.000000p
.measure tran DRV_QGPCL4_W4 FIND V(xqgpcl4) AT=1105.000000p
.measure tran DRV_QGPCL4_W5 FIND V(xqgpcl4) AT=1381.000000p
.measure tran GE_QGNSS4_SSPUP_A FIND V(xqgnss4) AT=918.000000p
.measure tran GE_QGNSS4_SSPUP_B FIND V(xqgnss4) AT=927.000000p
.measure tran GE_QGPSS4_SSPUP_A FIND V(xqgpss4) AT=918.000000p
.measure tran GE_QGPSS4_SSPUP_B FIND V(xqgpss4) AT=927.000000p
.measure tran GE_QGNCL4_SSPUP_A FIND V(xqgncl4) AT=918.000000p
.measure tran GE_QGNCL4_SSPUP_B FIND V(xqgncl4) AT=927.000000p
.measure tran GE_QGPCL4_SSPUP_A FIND V(xqgpcl4) AT=918.000000p
.measure tran GE_QGPCL4_SSPUP_B FIND V(xqgpcl4) AT=927.000000p
.measure tran GE_QGNSS4_SSNUP_A FIND V(xqgnss4) AT=1011.000000p
.measure tran GE_QGNSS4_SSNUP_B FIND V(xqgnss4) AT=1020.000000p
.measure tran GE_QGPSS4_SSNUP_A FIND V(xqgpss4) AT=1011.000000p
.measure tran GE_QGPSS4_SSNUP_B FIND V(xqgpss4) AT=1020.000000p
.measure tran GE_QGNCL4_SSNUP_A FIND V(xqgncl4) AT=1011.000000p
.measure tran GE_QGNCL4_SSNUP_B FIND V(xqgncl4) AT=1020.000000p
.measure tran GE_QGPCL4_SSNUP_A FIND V(xqgpcl4) AT=1011.000000p
.measure tran GE_QGPCL4_SSNUP_B FIND V(xqgpcl4) AT=1020.000000p
.measure tran GE_QGNSS4_CLNUP_A FIND V(xqgnss4) AT=920.000000p
.measure tran GE_QGNSS4_CLNUP_B FIND V(xqgnss4) AT=929.000000p
.measure tran GE_QGPSS4_CLNUP_A FIND V(xqgpss4) AT=920.000000p
.measure tran GE_QGPSS4_CLNUP_B FIND V(xqgpss4) AT=929.000000p
.measure tran GE_QGNCL4_CLNUP_A FIND V(xqgncl4) AT=920.000000p
.measure tran GE_QGNCL4_CLNUP_B FIND V(xqgncl4) AT=929.000000p
.measure tran GE_QGPCL4_CLNUP_A FIND V(xqgpcl4) AT=920.000000p
.measure tran GE_QGPCL4_CLNUP_B FIND V(xqgpcl4) AT=929.000000p
.measure tran GE_QGNSS4_CLPUP_A FIND V(xqgnss4) AT=1009.000000p
.measure tran GE_QGNSS4_CLPUP_B FIND V(xqgnss4) AT=1018.000000p
.measure tran GE_QGPSS4_CLPUP_A FIND V(xqgpss4) AT=1009.000000p
.measure tran GE_QGPSS4_CLPUP_B FIND V(xqgpss4) AT=1018.000000p
.measure tran GE_QGNCL4_CLPUP_A FIND V(xqgncl4) AT=1009.000000p
.measure tran GE_QGNCL4_CLPUP_B FIND V(xqgncl4) AT=1018.000000p
.measure tran GE_QGPCL4_CLPUP_A FIND V(xqgpcl4) AT=1009.000000p
.measure tran GE_QGPCL4_CLPUP_B FIND V(xqgpcl4) AT=1018.000000p
.print tran V(ph1) V(ph2) V(ph3) V(ph4) V(ph5) V(ph6) V(o1_1_0) V(o1_1_1) V(o1_1_2) V(o1_1_3) V(o1_1_4) V(o1_1_5) V(o1_1_6) V(o1_1_7) V(o1_2_0) V(o1_2_1) V(o1_2_2) V(o1_2_3) V(o1_2_4) V(o1_2_5) V(o1_2_6) V(o1_2_7) V(o1_3_0) V(o1_3_1) V(o1_3_2) V(o1_3_3) V(o1_3_4) V(o1_3_5) V(o1_3_6) V(o1_3_7) V(o2_1_0) V(o2_1_1) V(o2_1_2) V(o2_1_3) V(o2_1_4) V(o2_1_5) V(o2_1_6) V(o2_1_7) V(o2_2_0) V(o2_2_1) V(o2_2_2) V(o2_2_3) V(o2_2_4) V(o2_2_5) V(o2_2_6) V(o2_2_7) V(o2_3_0) V(o2_3_1) V(o2_3_2) V(o2_3_3) V(o2_3_4) V(o2_3_5) V(o2_3_6) V(o2_3_7) V(o3_1_0) V(o3_1_1) V(o3_1_2) V(o3_1_3) V(o3_1_4) V(o3_1_5) V(o3_1_6) V(o3_1_7) V(o3_2_0) V(o3_2_1) V(o3_2_2) V(o3_2_3) V(o3_2_4) V(o3_2_5) V(o3_2_6) V(o3_2_7) V(o3_3_0) V(o3_3_1) V(o3_3_2) V(o3_3_3) V(o3_3_4) V(o3_3_5) V(o3_3_6) V(o3_3_7) V(o4_1_0) V(o4_1_1) V(o4_1_2) V(o4_1_3) V(o4_1_4) V(o4_1_5) V(o4_1_6) V(o4_1_7) V(o4_2_0) V(o4_2_1) V(o4_2_2) V(o4_2_3) V(o4_2_4) V(o4_2_5) V(o4_2_6) V(o4_2_7) V(o4_3_0) V(o4_3_1) V(o4_3_2) V(o4_3_3) V(o4_3_4) V(o4_3_5) V(o4_3_6) V(o4_3_7) V(o5_1_0) V(o5_1_1) V(o5_1_2) V(o5_1_3) V(o5_1_4) V(o5_1_5) V(o5_1_6) V(o5_1_7) V(o5_2_0) V(o5_2_1) V(o5_2_2) V(o5_2_3) V(o5_2_4) V(o5_2_5) V(o5_2_6) V(o5_2_7) V(o5_3_0) V(o5_3_1) V(o5_3_2) V(o5_3_3) V(o5_3_4) V(o5_3_5) V(o5_3_6) V(o5_3_7) V(o6_1_0) V(o6_1_1) V(o6_1_2) V(o6_1_3) V(o6_1_4) V(o6_1_5) V(o6_1_6) V(o6_1_7) V(o6_2_0) V(o6_2_1) V(o6_2_2) V(o6_2_3) V(o6_2_4) V(o6_2_5) V(o6_2_6) V(o6_2_7) V(o6_3_0) V(o6_3_1) V(o6_3_2) V(o6_3_3) V(o6_3_4) V(o6_3_5) V(o6_3_6) V(o6_3_7) I(VPH1) I(VPH2) I(VPH3) I(VPH4) I(VPH5) I(VPH6) I(VMG1) I(VMG2) I(VMG3) I(VMG4) I(VMG5) I(VMG6) V(DRV4) V(SWN4) I(LH4) I(VHSRC4) I(VMID4)
.end
