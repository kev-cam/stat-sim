* QAL C5 CLOSED-LOOP steady-state rail-draw deck (generated by gen_c5loop.py)
* dV=0.6 Thop=100ps Tperiod=400ps nper=16 nwarm=10 window 4000p..6400p (12 ops)
* CB=80f CFLY=15f CS=2p LAB=25n LT=80n RRC=1k RTL=10k
* WSW=4u WDRV=2u/1u WGATE=1u  driver supply rp..rn swing 3V  pattern=d0  lane=YES
.hdl "/usr/local/share/xyce/verilog-a/psp103/psp103.va"
.include "/usr/local/src/kestrel/sim/models/sg13g2_psp103_tt.lib"
.include "/usr/local/src/stat-sim/qal/sg13lv_compat.sp"
.OPTIONS TIMEINT METHOD=GEAR RELTOL=1e-5 ABSTOL=1e-14
.param dV=0.6 CS=2p CB=80f CFLY=15f CPAR=2f CLOAD=10f
.param LAB=25n RAB=10 LT=80n RT=10 RRC=1k
.param RTL=10k RSER=5 RBL=10meg VCKH=3 CCP=2.4f RDC=1meg

.subckt INVQ vdd vss vin vout bp bn wp=1u wn=0.5u
XP vout vin vdd bp sg13_lv_pmos w={wp} l=0.13u
XN vout vin vss bn sg13_lv_nmos w={wn} l=0.13u
.ends

* ============ THE ONLY TWO ENERGY SOURCES IN THE DECK ============
VRP rp 0 1.5
VRN rn 0 -1.5
RSERI rp s5 {RSER}
* hard-wired 5-tier stack: the recharge path is DC interconnect. No switch.
CS5 s4 s5 {CS}
CS4 s3 s4 {CS}
CS3 s2 s3 {CS}
CS2 s1 s2 {CS}
CS1 rn s1 {CS}
* stand-in lanes: one resistor per tier, identical on all five.
RTL1 s1 rn {RTL}
RTL2 s2 s1 {RTL}
RTL3 s3 s2 {RTL}
RTL4 s4 s3 {RTL}
RTL5 s5 s4 {RTL}

* ============ TIER 3: THE ONE REAL QAL LANE ============
* ---- bank A: cap + a REAL settling inverter powered bank->lg ----
CBA ba s2 {CB}
RBLA ba s2 {RBL}
VMGAD ba gav 0
VMGAB s3 gabp 0
XGA gav s2 s2 oa gabp s2 INVQ wp=1u wn=1u
COA oa s2 {CLOAD}
* ---- bank B ----
CBB bb s2 {CB}
RBLB bb s2 {RBL}
VMGBD bb gbv 0
VMGBB s3 gbbp 0
XGB gbv s2 s2 ob gbbp s2 INVQ wp=1u wn=1u
COB ob s2 {CLOAD}

* ---- inter-bank inductive recycle, bidirectional, opens at ZCS ----
LAB ba xab {LAB}
RABS xab mab {RAB}
CMAB mab s2 {CPAR}
* NOTE the node names are d_/g_/s_ prefixed: Xyce is CASE-INSENSITIVE, so a
* gate node spelled gSAB would collide with the driver output gsab and make the
* ammeter a 0 V source with both ends on ONE node -> singular matrix.
VMSABD mab d_SAB 0
VMSABG gsab g_SAB 0
VMSABS s_SAB bb 0
XSAB d_SAB g_SAB s_SAB s2 sg13_lv_nmos w=4u l=0.13u

* ---- flycap A: PERMANENTLY connected to tier rail ls through RRC ----
CFA fa s2 {CFLY}
RRCA s3 fa {RRC}
LTA fa xta {LT}
RTAS xta mta {RT}
CMTA mta s2 {CPAR}
* NOTE the node names are d_/g_/s_ prefixed: Xyce is CASE-INSENSITIVE, so a
* gate node spelled gSTA would collide with the driver output gsta and make the
* ammeter a 0 V source with both ends on ONE node -> singular matrix.
VMSTAD mta d_STA 0
VMSTAG gsta g_STA 0
VMSTAS s_STA ba 0
XSTA d_STA g_STA s_STA s2 sg13_lv_nmos w=4u l=0.13u
* ---- flycap B ----
CFB fb s2 {CFLY}
RRCB s3 fb {RRC}
LTB fb xtb {LT}
RTBS xtb mtb {RT}
CMTB mtb s2 {CPAR}
* NOTE the node names are d_/g_/s_ prefixed: Xyce is CASE-INSENSITIVE, so a
* gate node spelled gSTB would collide with the driver output gstb and make the
* ammeter a 0 V source with both ends on ONE node -> singular matrix.
VMSTBD mtb d_STB 0
VMSTBG gstb g_STB 0
VMSTBS s_STB bb 0
XSTB d_STB g_STB s_STB s2 sg13_lv_nmos w=4u l=0.13u

* ---- REAL gate drivers, supply rp..rn ----
* MEASURED STRUCTURAL CONSTRAINT: a 0.6 V tier cannot drive its own switch
* gates (an nMOS passing up to the tier top needs V_top + Vt), so the gate
* drive has to reach outside the tier.  DRVTOP/DRVBOT expose that choice:
*   s4..s2 = 1.2 V, two tiers -> within the 1.2 V SG13G2 oxide rating, but
*            it is a DC bypass current around the tier caps it skips.
*   rp..rn = 3.0 V, full span -> passes through NO tier cap so it cannot
*            unbalance the stack, but it is 2.5x the oxide rating.
* Both are measured rather than assumed. See the report.
VMDRV rp drvp 0
VMDRVN drvn rn 0
XDAB drvp drvn ckab dvab drvp drvn INVQ wp=2u wn=1u
XDTA drvp drvn ckta dvta drvp drvn INVQ wp=2u wn=1u
XDTB drvp drvn cktb dvtb drvp drvn INVQ wp=2u wn=1u

* ---- CAPACITIVE GATE ATTENUATOR (the escape from the 3.0 V dilemma) ----
* MEASURED DILEMMA: on a 5-tier stack at dV=0.6 V, a supply is BALANCED only
* if it spans all five tiers, i.e. 3.0 V -- 2.5x the SG13G2 oxide rating. Any
* narrower span is a DC bypass around the tier caps it skips and the stack
* drifts (measured: tiers 3,4 fell 0.600->0.436 V while 1,2,5 rose to 0.702).
* ESCAPE: keep the BALANCED full-span driver, then AC-couple its output to
* the switch gate through CCP and DC-restore the gate through RDC to a
* tier-local reference. The gate then swings 3.0*CCP/(CCP+Cg) -- back inside
* rating -- while the only DC current in the restore path is leakage, so the
* tier balance is preserved. Gate swing is MEASURED (VGABPK/VGABMN), not assumed.
RVMA s3 vmid 1meg
RVMB vmid s4 1meg
CCP_gsab dvab gsab {CCP}
RDC_gsab gsab vmid {RDC}
CCP_gsta dvta gsta {CCP}
RDC_gsta gsta vmid {RDC}
CCP_gstb dvtb gstb {CCP}
RDC_gstb gstb vmid {RDC}

* ---- phase clocks: they drive ONLY the driver input gates. ----
* Active LOW into an inverting driver, so a switch gate is HIGH when ON.
* SWAB conducts on BOTH hops, so its period is HALF the loop period.
* Hop occupies the first 100ps of each 200ps half-period.
VCKAB ckab drvn PULSE({VCKH} 0 0 10p 10p 90p 200p)
VCKTA ckta drvn PULSE({VCKH} 0 200p 10p 10p 90p 400p)
VCKTB cktb drvn PULSE({VCKH} 0 0 10p 10p 90p 400p)

.tran 0.5p 6400p 0 0.5p

* ==================== METERS ====================
* headline: energy and charge drawn from the two rails
.measure tran ERAIL INTEGRAL {-V(rp)*I(VRP)-V(rn)*I(VRN)} FROM=4000p TO=6400p
.measure tran QRAIL INTEGRAL {-I(VRP)} FROM=4000p TO=6400p
.measure tran ERAILW INTEGRAL {-V(rp)*I(VRP)-V(rn)*I(VRN)} FROM=0 TO=4000p
.measure tran ERP INTEGRAL {-V(rp)*I(VRP)} FROM=4000p TO=6400p
.measure tran ERN INTEGRAL {-V(rn)*I(VRN)} FROM=4000p TO=6400p
* not-the-lane: stand-in lanes, stack series R
.measure tran ETL INTEGRAL {{RTL}*(I(RTL1)*I(RTL1)+I(RTL2)*I(RTL2)+I(RTL3)*I(RTL3)+I(RTL4)*I(RTL4)+I(RTL5)*I(RTL5))} FROM=4000p TO=6400p
.measure tran ERSER INTEGRAL {{RSER}*I(RSERI)*I(RSERI)} FROM=4000p TO=6400p
* gate-driver supply (the switch gate drive)
* Driver-domain input power. NOTE it must use BOTH supply leads separately:
* (V(drvp)-V(drvn))*I(VMDRV) is only valid if the two leads carry equal and
* opposite current, and they do NOT -- the gate coupling caps are a third path
* out of the driver domain into the tier. Using the two-terminal form left a
* 9.19%% hole in the energy balance; this form closes it.
.measure tran EDRV INTEGRAL {V(drvp)*I(VMDRV)-V(drvn)*I(VMDRVN)} FROM=4000p TO=6400p
.measure tran EDRV2T INTEGRAL {(V(drvp)-V(drvn))*I(VMDRV)} FROM=4000p TO=6400p
* phase-clock PWL sources: energy they inject (declared line item)
.measure tran ECK INTEGRAL {-(V(ckab)-V(drvn))*I(VCKAB)-(V(ckta)-V(drvn))*I(VCKTA)-(V(cktb)-V(drvn))*I(VCKTB)} FROM=4000p TO=6400p
* inductor series-R loss (exact I^2R, no window guessing)
.measure tran ELAB INTEGRAL {{RAB}*I(LAB)*I(LAB)} FROM=4000p TO=6400p
.measure tran ELTA INTEGRAL {{RT}*I(LTA)*I(LTA)} FROM=4000p TO=6400p
.measure tran ELTB INTEGRAL {{RT}*I(LTB)*I(LTB)} FROM=4000p TO=6400p
* flycap RECHARGE loss -- the term that was never simulated before
.measure tran ERCA INTEGRAL {{RRC}*I(RRCA)*I(RRCA)} FROM=4000p TO=6400p
.measure tran ERCB INTEGRAL {{RRC}*I(RRCB)*I(RRCB)} FROM=4000p TO=6400p
* bank DC bleeds (metering artefact, must be negligible)
.measure tran EBLD INTEGRAL {{RBL}*(I(RBLA)*I(RBLA)+I(RBLB)*I(RBLB))} FROM=4000p TO=6400p
* TOTAL power into each switch, all terminals, s2 as common reference
.measure tran ESWAB INTEGRAL {(V(d_SAB)-V(s2))*I(VMSABD)+(V(g_SAB)-V(s2))*I(VMSABG)-(V(s_SAB)-V(s2))*I(VMSABS)} FROM=4000p TO=6400p
.measure tran ESWTA INTEGRAL {(V(d_STA)-V(s2))*I(VMSTAD)+(V(g_STA)-V(s2))*I(VMSTAG)-(V(s_STA)-V(s2))*I(VMSTAS)} FROM=4000p TO=6400p
.measure tran ESWTB INTEGRAL {(V(d_STB)-V(s2))*I(VMSTBD)+(V(g_STB)-V(s2))*I(VMSTBG)-(V(s_STB)-V(s2))*I(VMSTBS)} FROM=4000p TO=6400p
* TOTAL power into each SETTLING GATE (the adiabatic settle loss)
.measure tran EGA INTEGRAL {(V(gav)-V(s2))*I(VMGAD)+(V(gabp)-V(s2))*I(VMGAB)} FROM=4000p TO=6400p
.measure tran EGB INTEGRAL {(V(gbv)-V(s2))*I(VMGBD)+(V(gbbp)-V(s2))*I(VMGBB)} FROM=4000p TO=6400p
* 0 V ammeters must inject exactly zero -- they are ammeters, not sources
.measure tran EAMM INTEGRAL {-(V(rp)-V(drvp))*I(VMDRV)-(V(drvn)-V(rn))*I(VMDRVN)-(V(ba)-V(gav))*I(VMGAD)-(V(bb)-V(gbv))*I(VMGBD)-(V(s3)-V(gabp))*I(VMGAB)-(V(s3)-V(gbbp))*I(VMGBB)-(V(mab)-V(d_SAB))*I(VMSABD)-(V(gsab)-V(g_SAB))*I(VMSABG)-(V(s_SAB)-V(bb))*I(VMSABS)-(V(mta)-V(d_STA))*I(VMSTAD)-(V(gsta)-V(g_STA))*I(VMSTAG)-(V(s_STA)-V(ba))*I(VMSTAS)-(V(mtb)-V(d_STB))*I(VMSTBD)-(V(gstb)-V(g_STB))*I(VMSTBG)-(V(s_STB)-V(bb))*I(VMSTBS)} FROM=4000p TO=6400p

* ============ stored energy / state vector at both window bounds ============
.measure tran VS1A FIND V(s1) AT=4000p
.measure tran VS2A FIND V(s2) AT=4000p
.measure tran VS3A FIND V(s3) AT=4000p
.measure tran VS4A FIND V(s4) AT=4000p
.measure tran VS5A FIND V(s5) AT=4000p
.measure tran VRPA FIND V(rp) AT=4000p
.measure tran VRNA FIND V(rn) AT=4000p
.measure tran VDRVPA FIND V(drvp) AT=4000p
.measure tran VDRVNA FIND V(drvn) AT=4000p
.measure tran VGSABA FIND V(gsab) AT=4000p
.measure tran VGSTAA FIND V(gsta) AT=4000p
.measure tran VGSTBA FIND V(gstb) AT=4000p
.measure tran VBAA FIND V(ba) AT=4000p
.measure tran VBBA FIND V(bb) AT=4000p
.measure tran VFAA FIND V(fa) AT=4000p
.measure tran VFBA FIND V(fb) AT=4000p
.measure tran VOAA FIND V(oa) AT=4000p
.measure tran VOBA FIND V(ob) AT=4000p
.measure tran VMABA FIND V(mab) AT=4000p
.measure tran VMTAA FIND V(mta) AT=4000p
.measure tran VMTBA FIND V(mtb) AT=4000p
.measure tran VS_SABA FIND V(s_sab) AT=4000p
.measure tran VS_STAA FIND V(s_sta) AT=4000p
.measure tran VS_STBA FIND V(s_stb) AT=4000p
.measure tran VDVABA FIND V(dvab) AT=4000p
.measure tran VDVTAA FIND V(dvta) AT=4000p
.measure tran VDVTBA FIND V(dvtb) AT=4000p
.measure tran VVMIDA FIND V(vmid) AT=4000p
.measure tran ILABA FIND I(LAB) AT=4000p
.measure tran ILTAA FIND I(LTA) AT=4000p
.measure tran ILTBA FIND I(LTB) AT=4000p
.measure tran VS1B FIND V(s1) AT=6400p
.measure tran VS2B FIND V(s2) AT=6400p
.measure tran VS3B FIND V(s3) AT=6400p
.measure tran VS4B FIND V(s4) AT=6400p
.measure tran VS5B FIND V(s5) AT=6400p
.measure tran VRPB FIND V(rp) AT=6400p
.measure tran VRNB FIND V(rn) AT=6400p
.measure tran VDRVPB FIND V(drvp) AT=6400p
.measure tran VDRVNB FIND V(drvn) AT=6400p
.measure tran VGSABB FIND V(gsab) AT=6400p
.measure tran VGSTAB FIND V(gsta) AT=6400p
.measure tran VGSTBB FIND V(gstb) AT=6400p
.measure tran VBAB FIND V(ba) AT=6400p
.measure tran VBBB FIND V(bb) AT=6400p
.measure tran VFAB FIND V(fa) AT=6400p
.measure tran VFBB FIND V(fb) AT=6400p
.measure tran VOAB FIND V(oa) AT=6400p
.measure tran VOBB FIND V(ob) AT=6400p
.measure tran VMABB FIND V(mab) AT=6400p
.measure tran VMTAB FIND V(mta) AT=6400p
.measure tran VMTBB FIND V(mtb) AT=6400p
.measure tran VS_SABB FIND V(s_sab) AT=6400p
.measure tran VS_STAB FIND V(s_sta) AT=6400p
.measure tran VS_STBB FIND V(s_stb) AT=6400p
.measure tran VDVABB FIND V(dvab) AT=6400p
.measure tran VDVTAB FIND V(dvta) AT=6400p
.measure tran VDVTBB FIND V(dvtb) AT=6400p
.measure tran VVMIDB FIND V(vmid) AT=6400p
.measure tran ILABB FIND I(LAB) AT=6400p
.measure tran ILTAB FIND I(LTA) AT=6400p
.measure tran ILTBB FIND I(LTB) AT=6400p

* ============ G6: per-op rail draw, op by op ============
.measure tran EOP20 INTEGRAL {-V(rp)*I(VRP)-V(rn)*I(VRN)} FROM=4000p TO=4200p
.measure tran EOP21 INTEGRAL {-V(rp)*I(VRP)-V(rn)*I(VRN)} FROM=4200p TO=4400p
.measure tran EOP22 INTEGRAL {-V(rp)*I(VRP)-V(rn)*I(VRN)} FROM=4400p TO=4600p
.measure tran EOP23 INTEGRAL {-V(rp)*I(VRP)-V(rn)*I(VRN)} FROM=4600p TO=4800p
.measure tran EOP24 INTEGRAL {-V(rp)*I(VRP)-V(rn)*I(VRN)} FROM=4800p TO=5000p
.measure tran EOP25 INTEGRAL {-V(rp)*I(VRP)-V(rn)*I(VRN)} FROM=5000p TO=5200p
.measure tran EOP26 INTEGRAL {-V(rp)*I(VRP)-V(rn)*I(VRN)} FROM=5200p TO=5400p
.measure tran EOP27 INTEGRAL {-V(rp)*I(VRP)-V(rn)*I(VRN)} FROM=5400p TO=5600p
.measure tran EOP28 INTEGRAL {-V(rp)*I(VRP)-V(rn)*I(VRN)} FROM=5600p TO=5800p
.measure tran EOP29 INTEGRAL {-V(rp)*I(VRP)-V(rn)*I(VRN)} FROM=5800p TO=6000p
.measure tran EOP30 INTEGRAL {-V(rp)*I(VRP)-V(rn)*I(VRN)} FROM=6000p TO=6200p
.measure tran EOP31 INTEGRAL {-V(rp)*I(VRP)-V(rn)*I(VRN)} FROM=6200p TO=6400p
.measure tran TOP20 INTEGRAL {{RTL}*(I(RTL1)*I(RTL1)+I(RTL2)*I(RTL2)+I(RTL3)*I(RTL3)+I(RTL4)*I(RTL4)+I(RTL5)*I(RTL5))} FROM=4000p TO=4200p
.measure tran TOP21 INTEGRAL {{RTL}*(I(RTL1)*I(RTL1)+I(RTL2)*I(RTL2)+I(RTL3)*I(RTL3)+I(RTL4)*I(RTL4)+I(RTL5)*I(RTL5))} FROM=4200p TO=4400p
.measure tran TOP22 INTEGRAL {{RTL}*(I(RTL1)*I(RTL1)+I(RTL2)*I(RTL2)+I(RTL3)*I(RTL3)+I(RTL4)*I(RTL4)+I(RTL5)*I(RTL5))} FROM=4400p TO=4600p
.measure tran TOP23 INTEGRAL {{RTL}*(I(RTL1)*I(RTL1)+I(RTL2)*I(RTL2)+I(RTL3)*I(RTL3)+I(RTL4)*I(RTL4)+I(RTL5)*I(RTL5))} FROM=4600p TO=4800p
.measure tran TOP24 INTEGRAL {{RTL}*(I(RTL1)*I(RTL1)+I(RTL2)*I(RTL2)+I(RTL3)*I(RTL3)+I(RTL4)*I(RTL4)+I(RTL5)*I(RTL5))} FROM=4800p TO=5000p
.measure tran TOP25 INTEGRAL {{RTL}*(I(RTL1)*I(RTL1)+I(RTL2)*I(RTL2)+I(RTL3)*I(RTL3)+I(RTL4)*I(RTL4)+I(RTL5)*I(RTL5))} FROM=5000p TO=5200p
.measure tran TOP26 INTEGRAL {{RTL}*(I(RTL1)*I(RTL1)+I(RTL2)*I(RTL2)+I(RTL3)*I(RTL3)+I(RTL4)*I(RTL4)+I(RTL5)*I(RTL5))} FROM=5200p TO=5400p
.measure tran TOP27 INTEGRAL {{RTL}*(I(RTL1)*I(RTL1)+I(RTL2)*I(RTL2)+I(RTL3)*I(RTL3)+I(RTL4)*I(RTL4)+I(RTL5)*I(RTL5))} FROM=5400p TO=5600p
.measure tran TOP28 INTEGRAL {{RTL}*(I(RTL1)*I(RTL1)+I(RTL2)*I(RTL2)+I(RTL3)*I(RTL3)+I(RTL4)*I(RTL4)+I(RTL5)*I(RTL5))} FROM=5600p TO=5800p
.measure tran TOP29 INTEGRAL {{RTL}*(I(RTL1)*I(RTL1)+I(RTL2)*I(RTL2)+I(RTL3)*I(RTL3)+I(RTL4)*I(RTL4)+I(RTL5)*I(RTL5))} FROM=5800p TO=6000p
.measure tran TOP30 INTEGRAL {{RTL}*(I(RTL1)*I(RTL1)+I(RTL2)*I(RTL2)+I(RTL3)*I(RTL3)+I(RTL4)*I(RTL4)+I(RTL5)*I(RTL5))} FROM=6000p TO=6200p
.measure tran TOP31 INTEGRAL {{RTL}*(I(RTL1)*I(RTL1)+I(RTL2)*I(RTL2)+I(RTL3)*I(RTL3)+I(RTL4)*I(RTL4)+I(RTL5)*I(RTL5))} FROM=6200p TO=6400p
* switch-gate swing actually achieved (oxide-rating check) + attenuator loss
.measure tran VGABPK MAX {V(gsab)-V(s2)} FROM=4000p TO=6400p
.measure tran VGABMN MIN {V(gsab)-V(s2)} FROM=4000p TO=6400p
.measure tran EVMID INTEGRAL {(V(s3)-V(vmid))*I(RVMA)+(V(vmid)-V(s4))*I(RVMB)+{RDC}*(I(RDC_gsab)*I(RDC_gsab)+I(RDC_gsta)*I(RDC_gsta)+I(RDC_gstb)*I(RDC_gstb))} FROM=4000p TO=6400p
* tier voltages: do they stay near dV and never go negative?
.measure tran TVMIN1 MIN {V(s1)-V(rn)} FROM=4000p TO=6400p
.measure tran TVMAX1 MAX {V(s1)-V(rn)} FROM=4000p TO=6400p
.measure tran TVMIN2 MIN {V(s2)-V(s1)} FROM=4000p TO=6400p
.measure tran TVMAX2 MAX {V(s2)-V(s1)} FROM=4000p TO=6400p
.measure tran TVMIN3 MIN {V(s3)-V(s2)} FROM=4000p TO=6400p
.measure tran TVMAX3 MAX {V(s3)-V(s2)} FROM=4000p TO=6400p
.measure tran TVMIN4 MIN {V(s4)-V(s3)} FROM=4000p TO=6400p
.measure tran TVMAX4 MAX {V(s4)-V(s3)} FROM=4000p TO=6400p
.measure tran TVMIN5 MIN {V(s5)-V(s4)} FROM=4000p TO=6400p
.measure tran TVMAX5 MAX {V(s5)-V(s4)} FROM=4000p TO=6400p
* bank swing in the last period: is the wave sustaining at dV?
.measure tran VBAPK MAX {V(ba)-V(s2)} FROM=6000p TO=6400p
.measure tran VBBPK MAX {V(bb)-V(s2)} FROM=6000p TO=6400p
.measure tran VBAMN MIN {V(ba)-V(s2)} FROM=6000p TO=6400p
.measure tran VBBMN MIN {V(bb)-V(s2)} FROM=6000p TO=6400p
.measure tran VFAMN MIN {V(fa)-V(s2)} FROM=6000p TO=6400p
.measure tran VFBMN MIN {V(fb)-V(s2)} FROM=6000p TO=6400p
.measure tran VOAPK MAX {V(oa)-V(s2)} FROM=6000p TO=6400p

.print tran format=csv V(rp) V(rn) V(s1) V(s2) V(s3) V(s4) V(s5) V(gsab) I(VRP) I(VRN) V(ba) V(bb) V(fa) V(fb) V(oa) V(ob) I(LAB) I(LTA) I(LTB)
.end
