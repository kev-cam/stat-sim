* QAL C5 CLOSED-LOOP steady-state rail-draw deck  (generated by gen_c5loop.py)
* dV=0.6 Thop=100ps Tperiod=400ps nper=16 nwarm=8  CB=80f CFLY=15f LAB=25n LT=80n
* switch w=10u  driver w=2u  settling gate w=1u  RRC=1k  data pattern=d0
.hdl "/usr/local/share/xyce/verilog-a/psp103/psp103.va"
.include "/usr/local/src/kestrel/sim/models/sg13g2_psp103_tt.lib"
.include "/usr/local/src/stat-sim/qal/sg13lv_compat.sp"
.OPTIONS TIMEINT METHOD=GEAR RELTOL=1e-5 ABSTOL=1e-14
.param dV=0.6 CS=2p CB=80f CFLY=15f RRC=1k RB=10meg
.param LAB=25n RAB=10 LT=80n RT=10 CPAR=2f
.param RTL=50k RSER=5 VCKH=3

* ---------------- real inverter (used as settling gate AND as gate driver) ----
.subckt INVQ vdd vss vin vout bp bn wp=1u wn=0.5u
XP vout vin vdd bp sg13_lv_pmos w={wp} l=0.13u
XN vout vin vss bn sg13_lv_nmos w={wn} l=0.13u
.ends

* ================= THE ONLY TWO ENERGY SOURCES =================
VRP rp 0 1.5
VRN rn 0 -1.5
RSERI rp s5 {RSER}
* hard-wired 5-tier stack: the recharge path is DC interconnect, no switch
CS5 s4 s5 {CS}
CS4 s3 s4 {CS}
CS3 s2 s3 {CS}
CS2 s1 s2 {CS}
CS1 rn s1 {CS}
* weak bias divider: pins the DC operating point; current 3.0/(5*RB), metered
RB5 s4 s5 {RB}
RB4 s3 s4 {RB}
RB3 s2 s3 {RB}
RB2 s1 s2 {RB}
RB1 rn s1 {RB}
* Replica lane loads: ONE resistor per tier, representing the OTHER lanes that
* share that tier in a real chip.  Resistive (not an ideal current sink) so that
* (a) it can only ABSORB -- it can never act as a source, and (b) it self-
* regulates, which is what keeps the series stack balanced.  Every tier carries
* an IDENTICAL one; tier 3 additionally carries the ONE REAL QAL lane.
RTL1 s1 rn {RTL}
RTL2 s2 s1 {RTL}
RTL3 s3 s2 {RTL}
RTL4 s4 s3 {RTL}
RTL5 s5 s4 {RTL}

* ================= TIER 3: THE REAL QAL LOOP =================
* tier-local ground lg = s2 (-0.3 V), tier-local supply ls = s3 (+0.3 V)
* ---- bank A ----
CBA ba s2 {CB}
RBLA ba s2 {RB}
VMGA ba gav 0
XGA gav s2 s2 oa s3 s2 INVQ wp=1u wn=1u
COA oa s2 10f
* ---- bank B ----
CBB bb s2 {CB}
RBLB bb s2 {RB}
VMGB bb gbv 0
XGB gbv s2 s2 ob s3 s2 INVQ wp=1u wn=1u
COB ob s2 10f

* ---- inter-bank inductive recycle (bidirectional, ZCS) ----
LAB ba xab {LAB}
RABS xab mab {RAB}
CMAB mab s2 {CPAR}
VMSAB mab dab 0
XSWAB dab gsab bb s2 sg13_lv_nmos w=10u l=0.13u

* ---- flycap A: PERMANENTLY connected to the tier rail ls through RRC ----
CFA fa s2 {CFLY}
RRCA s3 fa {RRC}
LTA fa xta {LT}
RTAS xta mta {RT}
CMTA mta s2 {CPAR}
VMSTA mta dta 0
XSWTA dta gsta ba s2 sg13_lv_nmos w=10u l=0.13u
* ---- flycap B ----
CFB fb s2 {CFLY}
RRCB s3 fb {RRC}
LTB fb xtb {LT}
RTBS xtb mtb {RT}
CMTB mtb s2 {CPAR}
VMSTB mtb dtb 0
XSWTB dtb gstb bb s2 sg13_lv_nmos w=10u l=0.13u

* ---- REAL gate drivers, powered rp..rn ----
* MEASURED STRUCTURAL CONSTRAINT (see c5_smoke.cir): a 0.6 V tier CANNOT drive
* its own switch gates -- an nMOS passing up to the tier top needs V_top+Vt --
* so the gate drive must reach outside the tier.  A supply spanning only SOME
* tiers is a DC bypass current around the tier caps it skips, which no resistive
* balancer can hold (measured: the stack ran away, s3 -> +4.3 V).  A supply
* spanning the WHOLE string (rp..rn) passes through NO tier cap, so it cannot
* unbalance any internal node -- that is why DRVTOP/DRVBOT default to rp/rn.
* The price is a 3.0 V gate swing, which this deck MEASURES rather than assumes.
VMDRV rp drvp 0
VMDRVN drvn rn 0
XDAB drvp drvn ckab gsab drvp drvn INVQ wp=2u wn=1u
XDTA drvp drvn ckta gsta drvp drvn INVQ wp=2u wn=1u
XDTB drvp drvn cktb gstb drvp drvn INVQ wp=2u wn=1u

* ---- phase clocks: drive ONLY the driver input gates (metered line item) ----
* active-LOW into an inverting driver, so the switch gate is HIGH when ON.
* SW_AB conducts on BOTH hops -> its period is HALF the loop period.
* hop occupies the first Thop=100ps of each 200ps half-period.
VCKAB ckab drvn PULSE({VCKH} 0 0 10p 10p 90p 200p)
VCKTA ckta drvn PULSE({VCKH} 0 200p 10p 10p 90p 400p)
VCKTB cktb drvn PULSE({VCKH} 0 0 10p 10p 90p 400p)

.tran 0.5p 6400p 0 0.5p

* ================= METERS =================
* --- headline: energy and charge drawn from the two rails ---
.measure tran ERAIL INTEGRAL {-V(rp)*I(VRP)-V(rn)*I(VRN)} FROM=3200p TO=6400p
.measure tran QRAIL INTEGRAL {-I(VRP)} FROM=3200p TO=6400p
.measure tran ERAILW INTEGRAL {-V(rp)*I(VRP)-V(rn)*I(VRN)} FROM=0 TO=3200p
* --- G3 re-check on this very run: constant rails => E/Q must be 3.0 V ---
.measure tran ERP INTEGRAL {-V(rp)*I(VRP)} FROM=3200p TO=6400p
.measure tran ERN INTEGRAL {-V(rn)*I(VRN)} FROM=3200p TO=6400p
* --- dissipation breakdown ---
.measure tran ERSER INTEGRAL {{RSER}*I(RSERI)*I(RSERI)} FROM=3200p TO=6400p
.measure tran EDIV INTEGRAL {{RB}*(I(RB1)*I(RB1)+I(RB2)*I(RB2)+I(RB3)*I(RB3)+I(RB4)*I(RB4)+I(RB5)*I(RB5))} FROM=3200p TO=6400p
.measure tran ELAB INTEGRAL {{RAB}*I(LAB)*I(LAB)} FROM=3200p TO=6400p
.measure tran ELTA INTEGRAL {{RT}*I(LTA)*I(LTA)} FROM=3200p TO=6400p
.measure tran ELTB INTEGRAL {{RT}*I(LTB)*I(LTB)} FROM=3200p TO=6400p
.measure tran ESWAB INTEGRAL {(V(dab)-V(bb))*I(VMSAB)} FROM=3200p TO=6400p
.measure tran ESWTA INTEGRAL {(V(dta)-V(ba))*I(VMSTA)} FROM=3200p TO=6400p
.measure tran ESWTB INTEGRAL {(V(dtb)-V(bb))*I(VMSTB)} FROM=3200p TO=6400p
.measure tran EGA INTEGRAL {(V(gav)-V(s2))*I(VMGA)} FROM=3200p TO=6400p
.measure tran EGB INTEGRAL {(V(gbv)-V(s2))*I(VMGB)} FROM=3200p TO=6400p
.measure tran EDRV INTEGRAL {(V(drvp)-V(drvn))*I(VMDRV)} FROM=3200p TO=6400p
.measure tran ERCA INTEGRAL {{RRC}*I(RRCA)*I(RRCA)} FROM=3200p TO=6400p
.measure tran ERCB INTEGRAL {{RRC}*I(RRCB)*I(RRCB)} FROM=3200p TO=6400p
.measure tran EBLD INTEGRAL {{RB}*(I(RBLA)*I(RBLA)+I(RBLB)*I(RBLB))} FROM=3200p TO=6400p
* --- replica tier loads: energy they ABSORB (must be > 0 = they are loads) ---
.measure tran ETL INTEGRAL {{RTL}*(I(RTL1)*I(RTL1)+I(RTL2)*I(RTL2)+I(RTL3)*I(RTL3)+I(RTL4)*I(RTL4)+I(RTL5)*I(RTL5))} FROM=3200p TO=6400p
.measure tran TVMIN1 MIN {V(s1)-V(rn)} FROM=3200p TO=6400p
.measure tran TVMIN2 MIN {V(s2)-V(s1)} FROM=3200p TO=6400p
.measure tran TVMIN3 MIN {V(s3)-V(s2)} FROM=3200p TO=6400p
.measure tran TVMIN4 MIN {V(s4)-V(s3)} FROM=3200p TO=6400p
.measure tran TVMIN5 MIN {V(s5)-V(s4)} FROM=3200p TO=6400p
* --- phase-clock PWL sources: energy they inject (declared line item) ---
.measure tran ECK INTEGRAL {-(V(ckab)-V(drvn))*I(VCKAB)-(V(ckta)-V(drvn))*I(VCKTA)-(V(cktb)-V(drvn))*I(VCKTB)} FROM=3200p TO=6400p
* --- 0 V ammeters must inject exactly zero (they are ammeters, not sources) ---
.measure tran EAMM INTEGRAL {-(V(rp)-V(drvp))*I(VMDRV)-(V(drvn)-V(rn))*I(VMDRVN)-(V(ba)-V(gav))*I(VMGA)-(V(bb)-V(gbv))*I(VMGB)-(V(mab)-V(dab))*I(VMSAB)-(V(mta)-V(dta))*I(VMSTA)-(V(mtb)-V(dtb))*I(VMSTB)} FROM=3200p TO=6400p

* ================= STORED ENERGY at the two window bounds =================
.measure tran VS1A FIND V(s1) AT=3200p
.measure tran VS2A FIND V(s2) AT=3200p
.measure tran VS3A FIND V(s3) AT=3200p
.measure tran VS4A FIND V(s4) AT=3200p
.measure tran VS5A FIND V(s5) AT=3200p
.measure tran VGSABA FIND V(gsab) AT=3200p
.measure tran VGSTAA FIND V(gsta) AT=3200p
.measure tran VGSTBA FIND V(gstb) AT=3200p
.measure tran VRPA FIND V(rp) AT=3200p
.measure tran VRNA FIND V(rn) AT=3200p
.measure tran VDRVPA FIND V(drvp) AT=3200p
.measure tran VDRVNA FIND V(drvn) AT=3200p
.measure tran VBAA FIND V(ba) AT=3200p
.measure tran VBBA FIND V(bb) AT=3200p
.measure tran VFAA FIND V(fa) AT=3200p
.measure tran VFBA FIND V(fb) AT=3200p
.measure tran VOAA FIND V(oa) AT=3200p
.measure tran VOBA FIND V(ob) AT=3200p
.measure tran VMABA FIND V(mab) AT=3200p
.measure tran VMTAA FIND V(mta) AT=3200p
.measure tran VMTBA FIND V(mtb) AT=3200p
.measure tran ILABA FIND I(LAB) AT=3200p
.measure tran ILTAA FIND I(LTA) AT=3200p
.measure tran ILTBA FIND I(LTB) AT=3200p
.measure tran VS1B FIND V(s1) AT=6400p
.measure tran VS2B FIND V(s2) AT=6400p
.measure tran VS3B FIND V(s3) AT=6400p
.measure tran VS4B FIND V(s4) AT=6400p
.measure tran VS5B FIND V(s5) AT=6400p
.measure tran VGSABB FIND V(gsab) AT=6400p
.measure tran VGSTAB FIND V(gsta) AT=6400p
.measure tran VGSTBB FIND V(gstb) AT=6400p
.measure tran VRPB FIND V(rp) AT=6400p
.measure tran VRNB FIND V(rn) AT=6400p
.measure tran VDRVPB FIND V(drvp) AT=6400p
.measure tran VDRVNB FIND V(drvn) AT=6400p
.measure tran VBAB FIND V(ba) AT=6400p
.measure tran VBBB FIND V(bb) AT=6400p
.measure tran VFAB FIND V(fa) AT=6400p
.measure tran VFBB FIND V(fb) AT=6400p
.measure tran VOAB FIND V(oa) AT=6400p
.measure tran VOBB FIND V(ob) AT=6400p
.measure tran VMABB FIND V(mab) AT=6400p
.measure tran VMTAB FIND V(mta) AT=6400p
.measure tran VMTBB FIND V(mtb) AT=6400p
.measure tran ILABB FIND I(LAB) AT=6400p
.measure tran ILTAB FIND I(LTA) AT=6400p
.measure tran ILTBB FIND I(LTB) AT=6400p

* ================= G6: per-op rail draw, op by op =================
.measure tran EOP16 INTEGRAL {-V(rp)*I(VRP)-V(rn)*I(VRN)} FROM=3200p TO=3400p
.measure tran EOP17 INTEGRAL {-V(rp)*I(VRP)-V(rn)*I(VRN)} FROM=3400p TO=3600p
.measure tran EOP18 INTEGRAL {-V(rp)*I(VRP)-V(rn)*I(VRN)} FROM=3600p TO=3800p
.measure tran EOP19 INTEGRAL {-V(rp)*I(VRP)-V(rn)*I(VRN)} FROM=3800p TO=4000p
.measure tran EOP20 INTEGRAL {-V(rp)*I(VRP)-V(rn)*I(VRN)} FROM=4000p TO=4200p
.measure tran EOP21 INTEGRAL {-V(rp)*I(VRP)-V(rn)*I(VRN)} FROM=4200p TO=4400p
.measure tran EOP22 INTEGRAL {-V(rp)*I(VRP)-V(rn)*I(VRN)} FROM=4400p TO=4600p
.measure tran EOP23 INTEGRAL {-V(rp)*I(VRP)-V(rn)*I(VRN)} FROM=4600p TO=4800p
.measure tran EOP24 INTEGRAL {-V(rp)*I(VRP)-V(rn)*I(VRN)} FROM=4800p TO=5000p
.measure tran EOP25 INTEGRAL {-V(rp)*I(VRP)-V(rn)*I(VRN)} FROM=5000p TO=5200p
.measure tran EOP26 INTEGRAL {-V(rp)*I(VRP)-V(rn)*I(VRN)} FROM=5200p TO=5400p
.measure tran EOP27 INTEGRAL {-V(rp)*I(VRP)-V(rn)*I(VRN)} FROM=5400p TO=5600p
.measure tran EOP28 INTEGRAL {-V(rp)*I(VRP)-V(rn)*I(VRN)} FROM=5600p TO=5800p
.measure tran EOP29 INTEGRAL {-V(rp)*I(VRP)-V(rn)*I(VRN)} FROM=5800p TO=6000p
.measure tran EOP30 INTEGRAL {-V(rp)*I(VRP)-V(rn)*I(VRN)} FROM=6000p TO=6200p
.measure tran EOP31 INTEGRAL {-V(rp)*I(VRP)-V(rn)*I(VRN)} FROM=6200p TO=6400p
* peak bank amplitudes in the last period (is the wave sustaining at dV?)
.measure tran VBAPK MAX {V(ba)-V(s2)} FROM=6000p TO=6400p
.measure tran VBBPK MAX {V(bb)-V(s2)} FROM=6000p TO=6400p
.measure tran VBAMN MIN {V(ba)-V(s2)} FROM=6000p TO=6400p
.measure tran VBBMN MIN {V(bb)-V(s2)} FROM=6000p TO=6400p
.measure tran VFAMN MIN {V(fa)-V(s2)} FROM=6000p TO=6400p
.measure tran VFBMN MIN {V(fb)-V(s2)} FROM=6000p TO=6400p

.print tran format=csv V(rp) V(rn) V(s1) V(s2) V(s3) V(s4) V(s5) V(gsab) I(VRP) I(VRN) V(ba) V(bb) V(fa) V(fb) V(oa) V(ob) I(LAB) I(LTA) I(LTB)
.end
