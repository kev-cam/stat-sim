* QAL C5 CLOSED-LOOP steady-state rail-draw deck  (generated by gen_c5loop.py)
* dV=0.6 Thop=100ps Tperiod=400ps nper=4 nwarm=2  CB=80f CFLY=15f LAB=25n LT=80n
* switch w=10u  driver w=2u  settling gate w=1u  RRC=1k  data pattern=d0
.hdl "/usr/local/share/xyce/verilog-a/psp103/psp103.va"
.include "/usr/local/src/kestrel/sim/models/sg13g2_psp103_tt.lib"
.include "/usr/local/src/stat-sim/qal/sg13lv_compat.sp"
.OPTIONS TIMEINT METHOD=GEAR RELTOL=1e-5 ABSTOL=1e-14
.param dV=0.6 CS=300f CB=80f CFLY=15f RRC=1k RB=10meg
.param LAB=25n RAB=10 LT=80n RT=10 CPAR=2f
.param ITL=10u RSER=5 VCKH=1.8

* ---------------- real inverter (used as settling gate AND as gate driver) ----
.subckt INVQ vdd vss vin vout bp bn wp=1u wn=0.5u
XP vout vin vdd bp sg13_lv_pmos w={wp} l=0.13u
XN vout vin vss bn sg13_lv_nmos w={wn} l=0.13u
.ends

* ================= THE ONLY TWO ENERGY SOURCES =================
VRP rp 0 1.5
VRN rn 0 -1.5
RSERI rp s5 {RSER}
* hard-wired 5-tier stack: the recharge path is DC interconnect, no switch
CS5 s4 s5 {CS}
CS4 s3 s4 {CS}
CS3 s2 s3 {CS}
CS2 s1 s2 {CS}
CS1 rn s1 {CS}
* weak bias divider: pins the DC operating point; current 3.0/(5*RB), metered
RB5 s4 s5 {RB}
RB4 s3 s4 {RB}
RB3 s2 s3 {RB}
RB2 s1 s2 {RB}
RB1 rn s1 {RB}
* replica tier loads (current SINKS -- absorb only, never sources)
IT1 s1 rn {ITL}
IT2 s2 s1 {ITL}
IT4 s4 s3 {ITL}
IT5 s5 s4 {ITL}

* ================= TIER 3: THE REAL QAL LOOP =================
* tier-local ground lg = s2 (-0.3 V), tier-local supply ls = s3 (+0.3 V)
* ---- bank A ----
CBA ba s2 {CB}
RBLA ba s2 {RB}
VMGA ba gav 0
XGA gav s2 s2 oa s3 s2 INVQ wp=1u wn=1u
COA oa s2 10f
* ---- bank B ----
CBB bb s2 {CB}
RBLB bb s2 {RB}
VMGB bb gbv 0
XGB gbv s2 s2 ob s3 s2 INVQ wp=1u wn=1u
COB ob s2 10f

* ---- inter-bank inductive recycle (bidirectional, ZCS) ----
LAB ba xab {LAB}
RABS xab mab {RAB}
CMAB mab s2 {CPAR}
VMSAB mab dab 0
XSWAB dab gsab bb s2 sg13_lv_nmos w=10u l=0.13u

* ---- flycap A: PERMANENTLY connected to the tier rail ls through RRC ----
CFA fa s2 {CFLY}
RRCA s3 fa {RRC}
LTA fa xta {LT}
RTAS xta mta {RT}
CMTA mta s2 {CPAR}
VMSTA mta dta 0
XSWTA dta gsta ba s2 sg13_lv_nmos w=10u l=0.13u
* ---- flycap B ----
CFB fb s2 {CFLY}
RRCB s3 fb {RRC}
LTB fb xtb {LT}
RTBS xtb mtb {RT}
CMTB mtb s2 {CPAR}
VMSTB mtb dtb 0
XSWTB dtb gstb bb s2 sg13_lv_nmos w=10u l=0.13u

* ---- REAL gate drivers, powered from stack nodes s5..s2 ----
* their supply current is drawn from the metered rails through the stack.
* NOTE this is a genuine architectural cost: a 0.6 V tier cannot drive its own
* switch gates (an nMOS passing up to the tier top needs V_top+Vt), so the gate
* drive MUST cross tiers. DRVTOP selects how far it reaches.
VMDRV s5 drvp 0
XDAB drvp s2 ckab gsab drvp s2 INVQ wp=2u wn=1u
XDTA drvp s2 ckta gsta drvp s2 INVQ wp=2u wn=1u
XDTB drvp s2 cktb gstb drvp s2 INVQ wp=2u wn=1u

* ---- phase clocks: drive ONLY the driver input gates (metered line item) ----
* active-LOW into an inverting driver, so the switch gate is HIGH when ON.
* SW_AB conducts on BOTH hops -> its period is HALF the loop period.
* hop occupies the first Thop=100ps of each 200ps half-period.
VCKAB ckab s2 PULSE({VCKH} 0 0 10p 10p 90p 200p)
VCKTA ckta s2 PULSE({VCKH} 0 200p 10p 10p 90p 400p)
VCKTB cktb s2 PULSE({VCKH} 0 0 10p 10p 90p 400p)

.tran 0.5p 1600p 0 0.5p

* ================= METERS =================
* --- headline: energy and charge drawn from the two rails ---
.measure tran ERAIL INTEGRAL {-V(rp)*I(VRP)-V(rn)*I(VRN)} FROM=800p TO=1600p
.measure tran QRAIL INTEGRAL {-I(VRP)} FROM=800p TO=1600p
.measure tran ERAILW INTEGRAL {-V(rp)*I(VRP)-V(rn)*I(VRN)} FROM=0 TO=800p
* --- G3 re-check on this very run: constant rails => E/Q must be 3.0 V ---
.measure tran ERP INTEGRAL {-V(rp)*I(VRP)} FROM=800p TO=1600p
.measure tran ERN INTEGRAL {-V(rn)*I(VRN)} FROM=800p TO=1600p
* --- dissipation breakdown ---
.measure tran ELAB INTEGRAL {{RAB}*I(LAB)*I(LAB)} FROM=800p TO=1600p
.measure tran ELTA INTEGRAL {{RT}*I(LTA)*I(LTA)} FROM=800p TO=1600p
.measure tran ELTB INTEGRAL {{RT}*I(LTB)*I(LTB)} FROM=800p TO=1600p
.measure tran ESWAB INTEGRAL {(V(dab)-V(bb))*I(VMSAB)} FROM=800p TO=1600p
.measure tran ESWTA INTEGRAL {(V(dta)-V(ba))*I(VMSTA)} FROM=800p TO=1600p
.measure tran ESWTB INTEGRAL {(V(dtb)-V(bb))*I(VMSTB)} FROM=800p TO=1600p
.measure tran EGA INTEGRAL {(V(gav)-V(s2))*I(VMGA)} FROM=800p TO=1600p
.measure tran EGB INTEGRAL {(V(gbv)-V(s2))*I(VMGB)} FROM=800p TO=1600p
.measure tran EDRV INTEGRAL {(V(drvp)-V(s2))*I(VMDRV)} FROM=800p TO=1600p
.measure tran ERCA INTEGRAL {{RRC}*I(RRCA)*I(RRCA)} FROM=800p TO=1600p
.measure tran ERCB INTEGRAL {{RRC}*I(RRCB)*I(RRCB)} FROM=800p TO=1600p
.measure tran ERSER INTEGRAL {{RSER}*I(RSERI)*I(RSERI)} FROM=800p TO=1600p
.measure tran EDIV INTEGRAL {{RB}*(I(RB1)*I(RB1)+I(RB2)*I(RB2)+I(RB3)*I(RB3)+I(RB4)*I(RB4)+I(RB5)*I(RB5))} FROM=800p TO=1600p
.measure tran EBLD INTEGRAL {{RB}*(I(RBLA)*I(RBLA)+I(RBLB)*I(RBLB))} FROM=800p TO=1600p
* --- replica tier loads: energy they ABSORB (must be > 0 = they are loads) ---
.measure tran ETL INTEGRAL {(V(s1)-V(rn))*{ITL}+(V(s2)-V(s1))*{ITL}+(V(s4)-V(s3))*{ITL}+(V(s5)-V(s4))*{ITL}} FROM=800p TO=1600p
.measure tran TVMIN1 MIN {V(s1)-V(rn)} FROM=800p TO=1600p
.measure tran TVMIN2 MIN {V(s2)-V(s1)} FROM=800p TO=1600p
.measure tran TVMIN3 MIN {V(s3)-V(s2)} FROM=800p TO=1600p
.measure tran TVMIN4 MIN {V(s4)-V(s3)} FROM=800p TO=1600p
.measure tran TVMIN5 MIN {V(s5)-V(s4)} FROM=800p TO=1600p
* --- phase-clock PWL sources: energy they inject (declared line item) ---
.measure tran ECK INTEGRAL {-(V(ckab)-V(s2))*I(VCKAB)-(V(ckta)-V(s2))*I(VCKTA)-(V(cktb)-V(s2))*I(VCKTB)} FROM=800p TO=1600p
* --- 0 V ammeters must inject exactly zero (they are ammeters, not sources) ---
.measure tran EAMM INTEGRAL {-(V(ba)-V(gav))*I(VMGA)-(V(bb)-V(gbv))*I(VMGB)-(V(mab)-V(dab))*I(VMSAB)-(V(mta)-V(dta))*I(VMSTA)-(V(mtb)-V(dtb))*I(VMSTB)-(V(s4)-V(drvp))*I(VMDRV)} FROM=800p TO=1600p

* ================= STORED ENERGY at the two window bounds =================
.measure tran VS1A FIND V(s1) AT=800p
.measure tran VS2A FIND V(s2) AT=800p
.measure tran VS3A FIND V(s3) AT=800p
.measure tran VS4A FIND V(s4) AT=800p
.measure tran VS5A FIND V(s5) AT=800p
.measure tran VBAA FIND V(ba) AT=800p
.measure tran VBBA FIND V(bb) AT=800p
.measure tran VFAA FIND V(fa) AT=800p
.measure tran VFBA FIND V(fb) AT=800p
.measure tran VOAA FIND V(oa) AT=800p
.measure tran VOBA FIND V(ob) AT=800p
.measure tran VMABA FIND V(mab) AT=800p
.measure tran VMTAA FIND V(mta) AT=800p
.measure tran VMTBA FIND V(mtb) AT=800p
.measure tran VGSABA FIND V(gsab) AT=800p
.measure tran VGSTAA FIND V(gsta) AT=800p
.measure tran VGSTBA FIND V(gstb) AT=800p
.measure tran VRPA FIND V(rp) AT=800p
.measure tran VRNA FIND V(rn) AT=800p
.measure tran ILABA FIND I(LAB) AT=800p
.measure tran ILTAA FIND I(LTA) AT=800p
.measure tran ILTBA FIND I(LTB) AT=800p
.measure tran VS1B FIND V(s1) AT=1600p
.measure tran VS2B FIND V(s2) AT=1600p
.measure tran VS3B FIND V(s3) AT=1600p
.measure tran VS4B FIND V(s4) AT=1600p
.measure tran VS5B FIND V(s5) AT=1600p
.measure tran VBAB FIND V(ba) AT=1600p
.measure tran VBBB FIND V(bb) AT=1600p
.measure tran VFAB FIND V(fa) AT=1600p
.measure tran VFBB FIND V(fb) AT=1600p
.measure tran VOAB FIND V(oa) AT=1600p
.measure tran VOBB FIND V(ob) AT=1600p
.measure tran VMABB FIND V(mab) AT=1600p
.measure tran VMTAB FIND V(mta) AT=1600p
.measure tran VMTBB FIND V(mtb) AT=1600p
.measure tran VGSABB FIND V(gsab) AT=1600p
.measure tran VGSTAB FIND V(gsta) AT=1600p
.measure tran VGSTBB FIND V(gstb) AT=1600p
.measure tran VRPB FIND V(rp) AT=1600p
.measure tran VRNB FIND V(rn) AT=1600p
.measure tran ILABB FIND I(LAB) AT=1600p
.measure tran ILTAB FIND I(LTA) AT=1600p
.measure tran ILTBB FIND I(LTB) AT=1600p

* ================= G6: per-op rail draw, op by op =================
.measure tran EOP4 INTEGRAL {-V(rp)*I(VRP)-V(rn)*I(VRN)} FROM=800p TO=1000p
.measure tran EOP5 INTEGRAL {-V(rp)*I(VRP)-V(rn)*I(VRN)} FROM=1000p TO=1200p
.measure tran EOP6 INTEGRAL {-V(rp)*I(VRP)-V(rn)*I(VRN)} FROM=1200p TO=1400p
.measure tran EOP7 INTEGRAL {-V(rp)*I(VRP)-V(rn)*I(VRN)} FROM=1400p TO=1600p
* peak bank amplitudes in the last period (is the wave sustaining at dV?)
.measure tran VBAPK MAX V(ba) FROM=1200p TO=1600p
.measure tran VBBPK MAX V(bb) FROM=1200p TO=1600p
.measure tran VBAMN MIN V(ba) FROM=1200p TO=1600p
.measure tran VBBMN MIN V(bb) FROM=1200p TO=1600p
.measure tran VFAMN MIN V(fa) FROM=1200p TO=1600p
.measure tran VFBMN MIN V(fb) FROM=1200p TO=1600p

.print tran format=csv V(rp) V(rn) V(s1) V(s2) V(s3) V(s4) V(s5) V(ba) V(bb)
+ V(fa) V(fb) V(oa) V(ob) V(gsab) V(gsta) V(gstb) I(LAB) I(LTA) I(LTB)
+ I(VRP) I(VRN)
.end
