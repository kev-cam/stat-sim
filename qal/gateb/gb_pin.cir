.hdl "/usr/local/share/xyce/verilog-a/psp103/psp103.va"
.include "/usr/local/src/kestrel/sim/models/sg13g2_psp103_tt.lib"
.include "/usr/local/src/stat-sim/qal/sg13lv_compat.sp"
.OPTIONS TIMEINT METHOD=GEAR RELTOL=1e-6 ABSTOL=1e-15 CHGTOL=1e-17
.param LT=277.8n RS=10 CA=35.979f
CA bka 0 {CA}
VHI vhi 0 1.5
VGT  gt  0 PWL(0 0 48p 0 50p 1.5 392p 1.5 394p 0)
VGTP gtp 0 PWL(0 1.5 48p 1.5 50p 0 392p 0 394p 1.5)
XSWN sw gt  bkb 0   sg13_lv_nmos w=20u l=0.13u
XSWP sw gtp bkb vhi sg13_lv_pmos w=40u l=0.13u
LT bka mid {LT}
RT mid sw {RS}
VMGH gnh 0 0
VMGL gnl 0 0
VPPH pinph 0 1.2
VPPL pinpl 0 1.2
VPNH pinnh 0 0
VPNL pinnl 0 0
XP0 o0 pinph bkb bkb sg13_lv_pmos w=1.12u l=0.13u
XN0 o0 pinnh gnh gnh sg13_lv_nmos w=0.74u l=0.13u
CL0 o0 gnh 2f
XP1 o1 pinpl bkb bkb sg13_lv_pmos w=1.12u l=0.13u
XN1 o1 pinnl gnl gnl sg13_lv_nmos w=0.74u l=0.13u
CL1 o1 gnl 2f
XP2 o2 pinph bkb bkb sg13_lv_pmos w=1.12u l=0.13u
XN2 o2 pinnh gnh gnh sg13_lv_nmos w=0.74u l=0.13u
CL2 o2 gnh 2f
XP3 o3 pinpl bkb bkb sg13_lv_pmos w=1.12u l=0.13u
XN3 o3 pinnl gnl gnl sg13_lv_nmos w=0.74u l=0.13u
CL3 o3 gnl 2f
XP4 o4 pinph bkb bkb sg13_lv_pmos w=1.12u l=0.13u
XN4 o4 pinnh gnh gnh sg13_lv_nmos w=0.74u l=0.13u
CL4 o4 gnh 2f
XP5 o5 pinpl bkb bkb sg13_lv_pmos w=1.12u l=0.13u
XN5 o5 pinnl gnl gnl sg13_lv_nmos w=0.74u l=0.13u
CL5 o5 gnl 2f
XP6 o6 pinph bkb bkb sg13_lv_pmos w=1.12u l=0.13u
XN6 o6 pinnh gnh gnh sg13_lv_nmos w=0.74u l=0.13u
CL6 o6 gnh 2f
XP7 o7 pinpl bkb bkb sg13_lv_pmos w=1.12u l=0.13u
XN7 o7 pinnl gnl gnl sg13_lv_nmos w=0.74u l=0.13u
CL7 o7 gnl 2f
CXqsh xqsh 0 1
BXqsh 0 xqsh I={ I(VMGH)+I(VPPH)+I(VPNH) }
RXqsh xqsh 0 0.01
CXqsl xqsl 0 1
BXqsl 0 xqsl I={ I(VMGL)+I(VPPL)+I(VPNL) }
RXqsl xqsl 0 0.01
CXesh xesh 0 1
BXesh 0 xesh I={ V(bkb)*(I(VMGH)+I(VPPH)+I(VPNH)) }
RXesh xesh 0 0.01
CXesl xesl 0 1
BXesl 0 xesl I={ V(bkb)*(I(VMGL)+I(VPPL)+I(VPNL)) }
RXesl xesl 0 0.01
CXqgh xqgh 0 1
BXqgh 0 xqgh I={ I(VMGH) }
RXqgh xqgh 0 0.01
CXqgl xqgl 0 1
BXqgl 0 xqgl I={ I(VMGL) }
RXqgl xqgl 0 0.01
CXqih xqih 0 1
BXqih 0 xqih I={ -(I(VPPH)+I(VPPL)) }
RXqih xqih 0 0.01
CXeih xeih 0 1
BXeih 0 xeih I={ -1.2*(I(VPPH)+I(VPPL)) }
RXeih xeih 0 0.01
CXqil xqil 0 1
BXqil 0 xqil I={ -(I(VPNH)+I(VPNL)) }
RXqil xqil 0 0.01
CXqlt xqlt 0 1
BXqlt 0 xqlt I={ I(LT) }
RXqlt xqlt 0 0.01
CXea xea 0 1
BXea 0 xea I={ V(bka)*I(LT) }
RXea xea 0 0.01
CXeb xeb 0 1
BXeb 0 xeb I={ V(bkb)*I(LT) }
RXeb xeb 0 0.01
CXqbk xqbk 0 1
BXqbk 0 xqbk I={ (I(VMGH)+I(VPPH)+I(VPNH))+(I(VMGL)+I(VPPL)+I(VPNL)) }
RXqbk xqbk 0 0.01
CXebk xebk 0 1
BXebk 0 xebk I={ V(bkb)*((I(VMGH)+I(VPPH)+I(VPNH))+(I(VMGL)+I(VPPL)+I(VPNL))) }
RXebk xebk 0 0.01
CXer xer 0 1
BXer 0 xer I={ I(LT)*I(LT)*10 }
RXer xer 0 0.01
CXesw xesw 0 1
BXesw 0 xesw I={ V(sw)*I(LT) }
RXesw xesw 0 0.01
CXqgt xqgt 0 1
BXqgt 0 xqgt I={ -I(VGT) }
RXqgt xqgt 0 0.01
CXqgtp xqgtp 0 1
BXqgtp 0 xqgtp I={ -I(VGTP) }
RXqgtp xqgtp 0 0.01
CXqhi xqhi 0 1
BXqhi 0 xqhi I={ -I(VHI) }
RXqhi xqhi 0 0.01
CXegt xegt 0 1
BXegt 0 xegt I={ -V(gt)*I(VGT)-V(gtp)*I(VGTP) }
RXegt xegt 0 0.01
CXehi xehi 0 1
BXehi 0 xehi I={ -1.5*I(VHI) }
RXehi xehi 0 0.01
Bpa pa 0 V={ V(bka)*I(LT) }
Bpb pb 0 V={ V(bkb)*I(LT) }
Bqt qt 0 V={ I(LT) }
.ic V(bka)=1 V(bkb)=0
.ic V(o0)=0 V(o1)=0 V(o2)=0 V(o3)=0 V(o4)=0 V(o5)=0 V(o6)=0 V(o7)=0
.tran 0.1p 892p 0 0.25p
.measure tran EOUTA INTEGRAL V(pa) FROM=0 TO=892p
.measure tran EINB  INTEGRAL V(pb) FROM=0 TO=892p
.measure tran QTR   INTEGRAL V(qt) FROM=0 TO=892p
.measure tran VBPK  MAX V(bkb) FROM=50p TO=892p
.measure tran VBEND FIND V(bkb) AT=887p
.measure tran VAEND FIND V(bka) AT=887p
.measure tran IPK   MAX I(LT) FROM=0 TO=892p
.measure tran IZ    FIND I(LT) AT=392p
.measure tran QSH_Z FIND V(xqsh) AT=0.5p
.measure tran QSH_A FIND V(xqsh) AT=55p
.measure tran QSH_B FIND V(xqsh) AT=392p
.measure tran QSH_C FIND V(xqsh) AT=399p
.measure tran QSH_D FIND V(xqsh) AT=887p
.measure tran QSL_Z FIND V(xqsl) AT=0.5p
.measure tran QSL_A FIND V(xqsl) AT=55p
.measure tran QSL_B FIND V(xqsl) AT=392p
.measure tran QSL_C FIND V(xqsl) AT=399p
.measure tran QSL_D FIND V(xqsl) AT=887p
.measure tran ESH_Z FIND V(xesh) AT=0.5p
.measure tran ESH_A FIND V(xesh) AT=55p
.measure tran ESH_B FIND V(xesh) AT=392p
.measure tran ESH_C FIND V(xesh) AT=399p
.measure tran ESH_D FIND V(xesh) AT=887p
.measure tran ESL_Z FIND V(xesl) AT=0.5p
.measure tran ESL_A FIND V(xesl) AT=55p
.measure tran ESL_B FIND V(xesl) AT=392p
.measure tran ESL_C FIND V(xesl) AT=399p
.measure tran ESL_D FIND V(xesl) AT=887p
.measure tran QGH_Z FIND V(xqgh) AT=0.5p
.measure tran QGH_A FIND V(xqgh) AT=55p
.measure tran QGH_B FIND V(xqgh) AT=392p
.measure tran QGH_C FIND V(xqgh) AT=399p
.measure tran QGH_D FIND V(xqgh) AT=887p
.measure tran QGL_Z FIND V(xqgl) AT=0.5p
.measure tran QGL_A FIND V(xqgl) AT=55p
.measure tran QGL_B FIND V(xqgl) AT=392p
.measure tran QGL_C FIND V(xqgl) AT=399p
.measure tran QGL_D FIND V(xqgl) AT=887p
.measure tran QIH_Z FIND V(xqih) AT=0.5p
.measure tran QIH_A FIND V(xqih) AT=55p
.measure tran QIH_B FIND V(xqih) AT=392p
.measure tran QIH_C FIND V(xqih) AT=399p
.measure tran QIH_D FIND V(xqih) AT=887p
.measure tran EIH_Z FIND V(xeih) AT=0.5p
.measure tran EIH_A FIND V(xeih) AT=55p
.measure tran EIH_B FIND V(xeih) AT=392p
.measure tran EIH_C FIND V(xeih) AT=399p
.measure tran EIH_D FIND V(xeih) AT=887p
.measure tran QIL_Z FIND V(xqil) AT=0.5p
.measure tran QIL_A FIND V(xqil) AT=55p
.measure tran QIL_B FIND V(xqil) AT=392p
.measure tran QIL_C FIND V(xqil) AT=399p
.measure tran QIL_D FIND V(xqil) AT=887p
.measure tran QLT_Z FIND V(xqlt) AT=0.5p
.measure tran QLT_A FIND V(xqlt) AT=55p
.measure tran QLT_B FIND V(xqlt) AT=392p
.measure tran QLT_C FIND V(xqlt) AT=399p
.measure tran QLT_D FIND V(xqlt) AT=887p
.measure tran EA_Z FIND V(xea) AT=0.5p
.measure tran EA_A FIND V(xea) AT=55p
.measure tran EA_B FIND V(xea) AT=392p
.measure tran EA_C FIND V(xea) AT=399p
.measure tran EA_D FIND V(xea) AT=887p
.measure tran EB_Z FIND V(xeb) AT=0.5p
.measure tran EB_A FIND V(xeb) AT=55p
.measure tran EB_B FIND V(xeb) AT=392p
.measure tran EB_C FIND V(xeb) AT=399p
.measure tran EB_D FIND V(xeb) AT=887p
.measure tran QBK_Z FIND V(xqbk) AT=0.5p
.measure tran QBK_A FIND V(xqbk) AT=55p
.measure tran QBK_B FIND V(xqbk) AT=392p
.measure tran QBK_C FIND V(xqbk) AT=399p
.measure tran QBK_D FIND V(xqbk) AT=887p
.measure tran EBK_Z FIND V(xebk) AT=0.5p
.measure tran EBK_A FIND V(xebk) AT=55p
.measure tran EBK_B FIND V(xebk) AT=392p
.measure tran EBK_C FIND V(xebk) AT=399p
.measure tran EBK_D FIND V(xebk) AT=887p
.measure tran ER_Z FIND V(xer) AT=0.5p
.measure tran ER_A FIND V(xer) AT=55p
.measure tran ER_B FIND V(xer) AT=392p
.measure tran ER_C FIND V(xer) AT=399p
.measure tran ER_D FIND V(xer) AT=887p
.measure tran ESW_Z FIND V(xesw) AT=0.5p
.measure tran ESW_A FIND V(xesw) AT=55p
.measure tran ESW_B FIND V(xesw) AT=392p
.measure tran ESW_C FIND V(xesw) AT=399p
.measure tran ESW_D FIND V(xesw) AT=887p
.measure tran QGT_Z FIND V(xqgt) AT=0.5p
.measure tran QGT_A FIND V(xqgt) AT=55p
.measure tran QGT_B FIND V(xqgt) AT=392p
.measure tran QGT_C FIND V(xqgt) AT=399p
.measure tran QGT_D FIND V(xqgt) AT=887p
.measure tran QGTP_Z FIND V(xqgtp) AT=0.5p
.measure tran QGTP_A FIND V(xqgtp) AT=55p
.measure tran QGTP_B FIND V(xqgtp) AT=392p
.measure tran QGTP_C FIND V(xqgtp) AT=399p
.measure tran QGTP_D FIND V(xqgtp) AT=887p
.measure tran QHI_Z FIND V(xqhi) AT=0.5p
.measure tran QHI_A FIND V(xqhi) AT=55p
.measure tran QHI_B FIND V(xqhi) AT=392p
.measure tran QHI_C FIND V(xqhi) AT=399p
.measure tran QHI_D FIND V(xqhi) AT=887p
.measure tran EGT_Z FIND V(xegt) AT=0.5p
.measure tran EGT_A FIND V(xegt) AT=55p
.measure tran EGT_B FIND V(xegt) AT=392p
.measure tran EGT_C FIND V(xegt) AT=399p
.measure tran EGT_D FIND V(xegt) AT=887p
.measure tran EHI_Z FIND V(xehi) AT=0.5p
.measure tran EHI_A FIND V(xehi) AT=55p
.measure tran EHI_B FIND V(xehi) AT=392p
.measure tran EHI_C FIND V(xehi) AT=399p
.measure tran EHI_D FIND V(xehi) AT=887p
.measure tran O0Z FIND V(o0) AT=392p
.measure tran O0E FIND V(o0) AT=887p
.measure tran O1Z FIND V(o1) AT=392p
.measure tran O1E FIND V(o1) AT=887p
.measure tran O2Z FIND V(o2) AT=392p
.measure tran O2E FIND V(o2) AT=887p
.measure tran O3Z FIND V(o3) AT=392p
.measure tran O3E FIND V(o3) AT=887p
.measure tran O4Z FIND V(o4) AT=392p
.measure tran O4E FIND V(o4) AT=887p
.measure tran O5Z FIND V(o5) AT=392p
.measure tran O5E FIND V(o5) AT=887p
.measure tran O6Z FIND V(o6) AT=392p
.measure tran O6E FIND V(o6) AT=887p
.measure tran O7Z FIND V(o7) AT=392p
.measure tran O7E FIND V(o7) AT=887p
.print tran V(bka) V(bkb) V(sw) I(LT) I(VMGH) I(VMGL) V(xqlt) V(xqbk) V(xqsh) V(xqsl) V(xqgh) V(xqgl) V(o0) V(o1)
.end
