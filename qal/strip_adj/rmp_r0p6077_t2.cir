* ADJUDICATION ramp sweep: rail 0.6077 V, ramp 2 ps
* every node starts at 0 V (internal nodes included); inputs ramp WITH the rail
.hdl "/usr/local/share/xyce/verilog-a/psp103/psp103.va"
.include "/usr/local/src/kestrel/sim/models/sg13g2_psp103_tt.lib"
.include "/usr/local/src/stat-sim/qal/sg13lv_compat.sp"
.OPTIONS TIMEINT METHOD=GEAR RELTOL=1e-6 ABSTOL=1e-15 CHGTOL=1e-17
VRAIL rail 0 PWL(0 0 2p 0 4p 0.607700 6000p 0.607700)
RHI hi rail 0.001
XP0s001 s001n14 A1s001 rail rail sg13_lv_pmos w=1.12u l=0.13u
XP1s001 qs001 A2s001 s001n14 rail sg13_lv_pmos w=1.12u l=0.13u
XP2s001 qs001 B1s001 rail rail sg13_lv_pmos w=1.12u l=0.13u
XN0s001 s001n1 A2s001 0 0 sg13_lv_nmos w=0.74u l=0.13u
XN2s001 s001n1 A1s001 0 0 sg13_lv_nmos w=0.74u l=0.13u
XN1s001 qs001 B1s001 s001n1 0 sg13_lv_nmos w=0.74u l=0.13u
CI0s001 s001n14 rail 0.1f
CI1s001 s001n1 0 0.1f
Cqs001 qs001 0 2f
RA1s001 A1s001 0 0.001
RA2s001 A2s001 0 0.001
RB1s001 B1s001 hi 0.001
Xx112001F1 qx112001 B1x112001 x112001Fi 0 sg13_lv_nmos w=0.74u l=0.13u
Xx112001F2 x112001Fi A1x112001 0 0 sg13_lv_nmos w=0.74u l=0.13u
Xx112001F3 x112001Fi A2x112001 0 0 sg13_lv_nmos w=0.74u l=0.13u
Xx112001G1 nx112001 A1Bx112001 x112001Gi 0 sg13_lv_nmos w=0.74u l=0.13u
Xx112001G2 x112001Gi A2Bx112001 0 0 sg13_lv_nmos w=0.74u l=0.13u
Xx112001G3 nx112001 B1Bx112001 0 0 sg13_lv_nmos w=0.74u l=0.13u
XXAx112001 qx112001 nx112001 rail rail sg13_lv_pmos w=1.12u l=0.13u
XXBx112001 nx112001 qx112001 rail rail sg13_lv_pmos w=1.12u l=0.13u
CIFx112001 x112001Fi 0 0.1f
CIGx112001 x112001Gi 0 0.1f
Cqx112001 qx112001 0 2f
Cnx112001 nx112001 0 2f
RA1x112001 A1x112001 0 0.001
RA2x112001 A2x112001 0 0.001
RB1x112001 B1x112001 hi 0.001
RA1Bx112001 A1Bx112001 hi 0.001
RA2Bx112001 A2Bx112001 hi 0.001
RB1Bx112001 B1Bx112001 0 0.001
Xx56001F1 qx56001 B1x56001 x56001Fi 0 sg13_lv_nmos w=0.74u l=0.13u
Xx56001F2 x56001Fi A1x56001 0 0 sg13_lv_nmos w=0.74u l=0.13u
Xx56001F3 x56001Fi A2x56001 0 0 sg13_lv_nmos w=0.74u l=0.13u
Xx56001G1 nx56001 A1Bx56001 x56001Gi 0 sg13_lv_nmos w=0.74u l=0.13u
Xx56001G2 x56001Gi A2Bx56001 0 0 sg13_lv_nmos w=0.74u l=0.13u
Xx56001G3 nx56001 B1Bx56001 0 0 sg13_lv_nmos w=0.74u l=0.13u
XXAx56001 qx56001 nx56001 rail rail sg13_lv_pmos w=0.56u l=0.13u
XXBx56001 nx56001 qx56001 rail rail sg13_lv_pmos w=0.56u l=0.13u
CIFx56001 x56001Fi 0 0.1f
CIGx56001 x56001Gi 0 0.1f
Cqx56001 qx56001 0 2f
Cnx56001 nx56001 0 2f
RA1x56001 A1x56001 0 0.001
RA2x56001 A2x56001 0 0.001
RB1x56001 B1x56001 hi 0.001
RA1Bx56001 A1Bx56001 hi 0.001
RA2Bx56001 A2Bx56001 hi 0.001
RB1Bx56001 B1Bx56001 0 0.001
XP0s101 s101n14 A1s101 rail rail sg13_lv_pmos w=1.12u l=0.13u
XP1s101 qs101 A2s101 s101n14 rail sg13_lv_pmos w=1.12u l=0.13u
XP2s101 qs101 B1s101 rail rail sg13_lv_pmos w=1.12u l=0.13u
XN0s101 s101n1 A2s101 0 0 sg13_lv_nmos w=0.74u l=0.13u
XN2s101 s101n1 A1s101 0 0 sg13_lv_nmos w=0.74u l=0.13u
XN1s101 qs101 B1s101 s101n1 0 sg13_lv_nmos w=0.74u l=0.13u
CI0s101 s101n14 rail 0.1f
CI1s101 s101n1 0 0.1f
Cqs101 qs101 0 2f
RA1s101 A1s101 hi 0.001
RA2s101 A2s101 0 0.001
RB1s101 B1s101 hi 0.001
Xx112101F1 qx112101 B1x112101 x112101Fi 0 sg13_lv_nmos w=0.74u l=0.13u
Xx112101F2 x112101Fi A1x112101 0 0 sg13_lv_nmos w=0.74u l=0.13u
Xx112101F3 x112101Fi A2x112101 0 0 sg13_lv_nmos w=0.74u l=0.13u
Xx112101G1 nx112101 A1Bx112101 x112101Gi 0 sg13_lv_nmos w=0.74u l=0.13u
Xx112101G2 x112101Gi A2Bx112101 0 0 sg13_lv_nmos w=0.74u l=0.13u
Xx112101G3 nx112101 B1Bx112101 0 0 sg13_lv_nmos w=0.74u l=0.13u
XXAx112101 qx112101 nx112101 rail rail sg13_lv_pmos w=1.12u l=0.13u
XXBx112101 nx112101 qx112101 rail rail sg13_lv_pmos w=1.12u l=0.13u
CIFx112101 x112101Fi 0 0.1f
CIGx112101 x112101Gi 0 0.1f
Cqx112101 qx112101 0 2f
Cnx112101 nx112101 0 2f
RA1x112101 A1x112101 hi 0.001
RA2x112101 A2x112101 0 0.001
RB1x112101 B1x112101 hi 0.001
RA1Bx112101 A1Bx112101 0 0.001
RA2Bx112101 A2Bx112101 hi 0.001
RB1Bx112101 B1Bx112101 0 0.001
Xx56101F1 qx56101 B1x56101 x56101Fi 0 sg13_lv_nmos w=0.74u l=0.13u
Xx56101F2 x56101Fi A1x56101 0 0 sg13_lv_nmos w=0.74u l=0.13u
Xx56101F3 x56101Fi A2x56101 0 0 sg13_lv_nmos w=0.74u l=0.13u
Xx56101G1 nx56101 A1Bx56101 x56101Gi 0 sg13_lv_nmos w=0.74u l=0.13u
Xx56101G2 x56101Gi A2Bx56101 0 0 sg13_lv_nmos w=0.74u l=0.13u
Xx56101G3 nx56101 B1Bx56101 0 0 sg13_lv_nmos w=0.74u l=0.13u
XXAx56101 qx56101 nx56101 rail rail sg13_lv_pmos w=0.56u l=0.13u
XXBx56101 nx56101 qx56101 rail rail sg13_lv_pmos w=0.56u l=0.13u
CIFx56101 x56101Fi 0 0.1f
CIGx56101 x56101Gi 0 0.1f
Cqx56101 qx56101 0 2f
Cnx56101 nx56101 0 2f
RA1x56101 A1x56101 hi 0.001
RA2x56101 A2x56101 0 0.001
RB1x56101 B1x56101 hi 0.001
RA1Bx56101 A1Bx56101 0 0.001
RA2Bx56101 A2Bx56101 hi 0.001
RB1Bx56101 B1Bx56101 0 0.001
XP0s011 s011n14 A1s011 rail rail sg13_lv_pmos w=1.12u l=0.13u
XP1s011 qs011 A2s011 s011n14 rail sg13_lv_pmos w=1.12u l=0.13u
XP2s011 qs011 B1s011 rail rail sg13_lv_pmos w=1.12u l=0.13u
XN0s011 s011n1 A2s011 0 0 sg13_lv_nmos w=0.74u l=0.13u
XN2s011 s011n1 A1s011 0 0 sg13_lv_nmos w=0.74u l=0.13u
XN1s011 qs011 B1s011 s011n1 0 sg13_lv_nmos w=0.74u l=0.13u
CI0s011 s011n14 rail 0.1f
CI1s011 s011n1 0 0.1f
Cqs011 qs011 0 2f
RA1s011 A1s011 0 0.001
RA2s011 A2s011 hi 0.001
RB1s011 B1s011 hi 0.001
Xx112011F1 qx112011 B1x112011 x112011Fi 0 sg13_lv_nmos w=0.74u l=0.13u
Xx112011F2 x112011Fi A1x112011 0 0 sg13_lv_nmos w=0.74u l=0.13u
Xx112011F3 x112011Fi A2x112011 0 0 sg13_lv_nmos w=0.74u l=0.13u
Xx112011G1 nx112011 A1Bx112011 x112011Gi 0 sg13_lv_nmos w=0.74u l=0.13u
Xx112011G2 x112011Gi A2Bx112011 0 0 sg13_lv_nmos w=0.74u l=0.13u
Xx112011G3 nx112011 B1Bx112011 0 0 sg13_lv_nmos w=0.74u l=0.13u
XXAx112011 qx112011 nx112011 rail rail sg13_lv_pmos w=1.12u l=0.13u
XXBx112011 nx112011 qx112011 rail rail sg13_lv_pmos w=1.12u l=0.13u
CIFx112011 x112011Fi 0 0.1f
CIGx112011 x112011Gi 0 0.1f
Cqx112011 qx112011 0 2f
Cnx112011 nx112011 0 2f
RA1x112011 A1x112011 0 0.001
RA2x112011 A2x112011 hi 0.001
RB1x112011 B1x112011 hi 0.001
RA1Bx112011 A1Bx112011 hi 0.001
RA2Bx112011 A2Bx112011 0 0.001
RB1Bx112011 B1Bx112011 0 0.001
Xx56011F1 qx56011 B1x56011 x56011Fi 0 sg13_lv_nmos w=0.74u l=0.13u
Xx56011F2 x56011Fi A1x56011 0 0 sg13_lv_nmos w=0.74u l=0.13u
Xx56011F3 x56011Fi A2x56011 0 0 sg13_lv_nmos w=0.74u l=0.13u
Xx56011G1 nx56011 A1Bx56011 x56011Gi 0 sg13_lv_nmos w=0.74u l=0.13u
Xx56011G2 x56011Gi A2Bx56011 0 0 sg13_lv_nmos w=0.74u l=0.13u
Xx56011G3 nx56011 B1Bx56011 0 0 sg13_lv_nmos w=0.74u l=0.13u
XXAx56011 qx56011 nx56011 rail rail sg13_lv_pmos w=0.56u l=0.13u
XXBx56011 nx56011 qx56011 rail rail sg13_lv_pmos w=0.56u l=0.13u
CIFx56011 x56011Fi 0 0.1f
CIGx56011 x56011Gi 0 0.1f
Cqx56011 qx56011 0 2f
Cnx56011 nx56011 0 2f
RA1x56011 A1x56011 0 0.001
RA2x56011 A2x56011 hi 0.001
RB1x56011 B1x56011 hi 0.001
RA1Bx56011 A1Bx56011 hi 0.001
RA2Bx56011 A2Bx56011 0 0.001
RB1Bx56011 B1Bx56011 0 0.001
XP0s100 s100n14 A1s100 rail rail sg13_lv_pmos w=1.12u l=0.13u
XP1s100 qs100 A2s100 s100n14 rail sg13_lv_pmos w=1.12u l=0.13u
XP2s100 qs100 B1s100 rail rail sg13_lv_pmos w=1.12u l=0.13u
XN0s100 s100n1 A2s100 0 0 sg13_lv_nmos w=0.74u l=0.13u
XN2s100 s100n1 A1s100 0 0 sg13_lv_nmos w=0.74u l=0.13u
XN1s100 qs100 B1s100 s100n1 0 sg13_lv_nmos w=0.74u l=0.13u
CI0s100 s100n14 rail 0.1f
CI1s100 s100n1 0 0.1f
Cqs100 qs100 0 2f
RA1s100 A1s100 hi 0.001
RA2s100 A2s100 0 0.001
RB1s100 B1s100 0 0.001
Xx112100F1 qx112100 B1x112100 x112100Fi 0 sg13_lv_nmos w=0.74u l=0.13u
Xx112100F2 x112100Fi A1x112100 0 0 sg13_lv_nmos w=0.74u l=0.13u
Xx112100F3 x112100Fi A2x112100 0 0 sg13_lv_nmos w=0.74u l=0.13u
Xx112100G1 nx112100 A1Bx112100 x112100Gi 0 sg13_lv_nmos w=0.74u l=0.13u
Xx112100G2 x112100Gi A2Bx112100 0 0 sg13_lv_nmos w=0.74u l=0.13u
Xx112100G3 nx112100 B1Bx112100 0 0 sg13_lv_nmos w=0.74u l=0.13u
XXAx112100 qx112100 nx112100 rail rail sg13_lv_pmos w=1.12u l=0.13u
XXBx112100 nx112100 qx112100 rail rail sg13_lv_pmos w=1.12u l=0.13u
CIFx112100 x112100Fi 0 0.1f
CIGx112100 x112100Gi 0 0.1f
Cqx112100 qx112100 0 2f
Cnx112100 nx112100 0 2f
RA1x112100 A1x112100 hi 0.001
RA2x112100 A2x112100 0 0.001
RB1x112100 B1x112100 0 0.001
RA1Bx112100 A1Bx112100 0 0.001
RA2Bx112100 A2Bx112100 hi 0.001
RB1Bx112100 B1Bx112100 hi 0.001
Xx56100F1 qx56100 B1x56100 x56100Fi 0 sg13_lv_nmos w=0.74u l=0.13u
Xx56100F2 x56100Fi A1x56100 0 0 sg13_lv_nmos w=0.74u l=0.13u
Xx56100F3 x56100Fi A2x56100 0 0 sg13_lv_nmos w=0.74u l=0.13u
Xx56100G1 nx56100 A1Bx56100 x56100Gi 0 sg13_lv_nmos w=0.74u l=0.13u
Xx56100G2 x56100Gi A2Bx56100 0 0 sg13_lv_nmos w=0.74u l=0.13u
Xx56100G3 nx56100 B1Bx56100 0 0 sg13_lv_nmos w=0.74u l=0.13u
XXAx56100 qx56100 nx56100 rail rail sg13_lv_pmos w=0.56u l=0.13u
XXBx56100 nx56100 qx56100 rail rail sg13_lv_pmos w=0.56u l=0.13u
CIFx56100 x56100Fi 0 0.1f
CIGx56100 x56100Gi 0 0.1f
Cqx56100 qx56100 0 2f
Cnx56100 nx56100 0 2f
RA1x56100 A1x56100 hi 0.001
RA2x56100 A2x56100 0 0.001
RB1x56100 B1x56100 0 0.001
RA1Bx56100 A1Bx56100 0 0.001
RA2Bx56100 A2Bx56100 hi 0.001
RB1Bx56100 B1Bx56100 hi 0.001
.ic V(qs001)=0 V(s001n14)=0 V(s001n1)=0 V(qx112001)=0 V(nx112001)=0 V(x112001Fi)=0 V(x112001Gi)=0 V(qx56001)=0 V(nx56001)=0 V(x56001Fi)=0 V(x56001Gi)=0 V(qs101)=0 V(s101n14)=0 V(s101n1)=0 V(qx112101)=0 V(nx112101)=0 V(x112101Fi)=0 V(x112101Gi)=0 V(qx56101)=0 V(nx56101)=0 V(x56101Fi)=0 V(x56101Gi)=0 V(qs011)=0 V(s011n14)=0 V(s011n1)=0 V(qx112011)=0 V(nx112011)=0 V(x112011Fi)=0 V(x112011Gi)=0 V(qx56011)=0 V(nx56011)=0 V(x56011Fi)=0 V(x56011Gi)=0 V(qs100)=0 V(s100n14)=0 V(s100n1)=0 V(qx112100)=0 V(nx112100)=0 V(x112100Fi)=0 V(x112100Gi)=0 V(qx56100)=0 V(nx56100)=0 V(x56100Fi)=0 V(x56100Gi)=0
.print tran format=noindex V(qs001) V(qx112001) V(nx112001) V(qx56001) V(nx56001) V(qs101) V(qx112101) V(nx112101)
+ V(qx56101) V(nx56101) V(qs011) V(qx112011) V(nx112011) V(qx56011) V(nx56011) V(qs100)
+ V(qx112100) V(nx112100) V(qx56100) V(nx56100)
+ V(rail)
.tran 1p 3000p 0 2p
.end
