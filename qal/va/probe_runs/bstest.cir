* test behavioral time source
BS ps 0 V={ 0.6 - 0.6*cos(6.283185307*0.25e9*TIME) }
RL ps 0 1e9
.print tran V(ps)
.tran 10p 4n
.end
