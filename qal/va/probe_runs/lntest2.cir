* lntest2 computed nvt
.hdl "/usr/local/src/stat-sim/qal/va/probe_runs/lntest2.va"
.model lm lntest2 NSS=1.85 PHIT=0.02585 R=6229
VP p 0 0.3
YLNTEST2 X1 p 0 lm
RL p 0 1e12
.tran 1p 10p
.end
