* qal_bankcap conservation WITH the inversion-peak bump active (bank A params).
.hdl "/usr/local/src/stat-sim/qal/va/qal_bankcap.va"
.OPTIONS TIMEINT METHOD=GEAR RELTOL=1e-8 ABSTOL=1e-16 CHGTOL=1e-18
.model bc qal_bankcap C0=23.200e-15 CT=12.964e-15 VK=0.3720 WV=0.047823 CP=71.315e-15 VA=0.4278 VB=0.4930 WP=0.0119 GM0=1e-12
VS p 0 PWL(0 0 1n 1.2 2n 1.2 3n 0 4n 0)
YQAL_BANKCAP XC p 0 bc
BPW pw 0 V={ V(p)*I(VS) }
CINT eint 0 1
BINT 0 eint I={ V(pw) }
BQ  qd 0 V={ I(VS) }
CQ  eq 0 1
BQI 0 eq I={ V(qd) }
.print tran V(p) V(eint) V(eq)
.tran 0.25p 4n UIC
.end
