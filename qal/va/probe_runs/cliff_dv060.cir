* qal_gate cliff probe: INV settling on a rail that peaks at 0.37251V
.hdl "/usr/local/src/stat-sim/qal/va/qal_gate.va"
.model qm qal_gate TOPO=0 RON_N=2.5e3 RON_P=6229 VTN=0.35 VTP=0.50 NSS=1.85
+ VREF=1.2 CY=2f CIN=2f CX=0.1f CW=0.1f GM0=1e-12 ESCALE=1e15
* hop-like ramp: 0 -> VR over 400 ps (the L=400nH half-cycle), then hold
VPC pc 0 PWL(0 0 400p 0.37251 2n 0.37251)
VA a 0 0
VB b 0 0
YQAL_GATE X1 a b y pc 0 ed er eq 0 qm
.tran 1p 2n UIC
.measure tran YHOLD FIND V(y) AT=1.99n
.measure tran RAIL  FIND V(pc) AT=1.99n
.end
