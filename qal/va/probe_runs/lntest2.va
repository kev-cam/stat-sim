`include "disciplines.vams"
module lntest2(p,n);
  inout p,n; electrical p,n;
  parameter real NSS=1.85; parameter real PHIT=0.02585; parameter real R=6229;
  real nvt, ov, t, g;
  analog begin
    nvt = NSS*PHIT;
    ov = V(p,n) - 0.5;
    t = ov; if (t<0.0) t=-t;
    if (ov<0.0) ov=0.0;
    ov = ov + nvt*ln(1.0 + limexp(-t/nvt));
    g = ov/(1.2*R);
    I(p,n) <+ g*V(p,n);
  end
endmodule
