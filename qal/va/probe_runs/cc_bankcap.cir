* qal_bankcap CHARGE-CONSERVATION check: closed V-cycle -> zero net energy.
* The element contributes I(p,n) <+ ddt(Q(V)) with Q a single-valued state
* function of V, so it is conservative BY CONSTRUCTION: over any closed V-loop
* the net charge and net energy are exactly zero. The classic V-dependent-cap
* bug (I=C(V)*dV/dt, non-conservative) would leave a finite energy residue.
* Route A: net charge returned (definitive -- proves Q is a pure state function).
* Route B: net energy via a 1F-cap integrator on V*i (bounded by the monitor's
*          product-integration error at the triangle corners, NOT the element).
.hdl "/usr/local/src/stat-sim/qal/va/qal_bankcap.va"
.OPTIONS TIMEINT METHOD=GEAR RELTOL=1e-8 ABSTOL=1e-16 CHGTOL=1e-18
.model bc qal_bankcap C0=24.084e-15 CT=5.231e-15 VK=0.25307 WV=0.047823 GM0=1e-12
* symmetric triangle 0 -> 1.2 (1ns) -> hold (1ns) -> 0 (1ns): V returns to start
VS p 0 PWL(0 0 1n 1.2 2n 1.2 3n 0 4n 0)
YQAL_BANKCAP XC p 0 bc
BPW pw 0 V={ V(p)*I(VS) }
CINT eint 0 1
BINT 0 eint I={ V(pw) }
BQ  qd 0 V={ I(VS) }
CQ  eq 0 1
BQI 0 eq I={ V(qd) }
.print tran V(p) V(eint) V(eq)
.tran 0.25p 4n UIC
.end
