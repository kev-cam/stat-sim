.hdl "/usr/local/share/xyce/verilog-a/psp103/psp103.va"
.include "/usr/local/src/kestrel/sim/models/sg13g2_psp103_tt.lib"
.include "/usr/local/src/stat-sim/qal/sg13lv_compat.sp"
.OPTIONS TIMEINT METHOD=GEAR RELTOL=1e-6 ABSTOL=1e-15 CHGTOL=1e-17
* ---- qal/lsteer steered-inductor network (replaces VPHk/RSk) ----
VDDH vddh 0 1.65
VZR vzr 0 0
VPH1 ph1 pA 0
VPH2 ph2 pB 0
VPH3 ph3 pC 0
VPH4 ph4 pA 0
VPH5 ph5 pB 0
VPH6 ph6 pC 0
VPH7 ph7 pA 0
VPH8 ph8 pB 0
VPH9 ph9 pC 0
VPH10 ph10 pA 0
VPH11 ph11 pB 0
VPH12 ph12 pC 0
VPH13 ph13 pA 0
VPH14 ph14 pB 0
VPH15 ph15 pC 0
VPH16 ph16 pA 0
VPH17 ph17 pB 0
VPH18 ph18 pC 0
VPH19 ph19 pA 0
VPH20 ph20 pB 0
VPH21 ph21 pC 0
VPH22 ph22 pA 0
VPH23 ph23 pB 0
VPH24 ph24 pC 0
Ctin lin 0 20f
Ctout lout 0 20f
VML lin lmid 0
RL1 lmid lx 10
L1 lx lout 30n IC=15.3491m
.model SWI VSWITCH RON=0.05 ROFF=1e8 VON=0.7 VOFF=0.3
Vcss css 0 PWL(0 1 275.5p 1 275.8p 0)
Sfw lin lout css 0 SWI
VTRA trA 0 PWL(0 0 92p 1.65 184p 1.65 276p 0 368p 1.65 460p 1.65 552p 0 644p 1.65 736p 1.65)
StrA trA pA css 0 SWI
VTRB trB 0 PWL(0 1.65 92p 0 184p 1.65 276p 1.65 368p 0 460p 1.65 552p 1.65)
StrB trB pB css 0 SWI
VTRC trC 0 PWL(0 1.65 92p 1.65 184p 0 276p 1.65 368p 1.65 460p 0 552p 1.65 644p 1.65)
StrC trC pC css 0 SWI
VcinA cinA 0 PWL(0 0 460.2p 0 460.5p 1 533.1p 1 533.4p 0 736.2p 0 736.5p 1 809.1p 1 809.4p 0 1012.2p 0 1012.5p 1 1085.1p 1 1085.4p 0 1288.2p 0 1288.5p 1 1361.1p 1 1361.4p 0 1564.2p 0 1564.5p 1 1637.1p 1 1637.4p 0 1840.2p 0 1840.5p 1 1913.1p 1 1913.4p 0 2116.2p 0 2116.5p 1 2189.1p 1 2189.4p 0)
VSinA pA sinA 0
SinA sinA lin cinA 0 SWI
VcoutA coutA 0 PWL(0 0 276.2p 0 276.5p 1 367.5p 1 367.8p 0 552.2p 0 552.5p 1 643.5p 1 643.8p 0 828.2p 0 828.5p 1 919.5p 1 919.8p 0 1104.2p 0 1104.5p 1 1195.5p 1 1195.8p 0 1380.2p 0 1380.5p 1 1471.5p 1 1471.8p 0 1656.2p 0 1656.5p 1 1747.5p 1 1747.8p 0 1932.2p 0 1932.5p 1 2023.5p 1 2023.8p 0)
VSoutA pA soutA 0
SoutA soutA lout coutA 0 SWI
VcholdA choldA 0 PWL(0 0 368.2p 0 368.5p 1 459.5p 1 459.8p 0 644.2p 0 644.5p 1 735.5p 1 735.8p 0 920.2p 0 920.5p 1 1011.5p 1 1011.8p 0 1196.2p 0 1196.5p 1 1287.5p 1 1287.8p 0 1472.2p 0 1472.5p 1 1563.5p 1 1563.8p 0 1748.2p 0 1748.5p 1 1839.5p 1 1839.8p 0 2024.2p 0 2024.5p 1 2115.5p 1 2115.8p 0)
VSholdA pA sholdA 0
SholdA sholdA vddh choldA 0 SWI
VczeroA czeroA 0 PWL(0 0 533.8p 0 534.1p 1 551.5p 1 551.8p 0 809.8p 0 810.1p 1 827.5p 1 827.8p 0 1085.8p 0 1086.1p 1 1103.5p 1 1103.8p 0 1361.8p 0 1362.1p 1 1379.5p 1 1379.8p 0 1637.8p 0 1638.1p 1 1655.5p 1 1655.8p 0 1913.8p 0 1914.1p 1 1931.5p 1 1931.8p 0 2189.8p 0 2190.1p 1 2207.5p 1 2207.8p 0)
VSzeroA pA szeroA 0
SzeroA szeroA vzr czeroA 0 SWI
Vcindd cindd 0 PWL(0 0 349.8p 0 350.1p 1 367.5p 1 367.8p 0 441.8p 0 442.1p 1 459.5p 1 459.8p 0 533.8p 0 534.1p 1 551.5p 1 551.8p 0 625.8p 0 626.1p 1 643.5p 1 643.8p 0 717.8p 0 718.1p 1 735.5p 1 735.8p 0 809.8p 0 810.1p 1 827.5p 1 827.8p 0 901.8p 0 902.1p 1 919.5p 1 919.8p 0 993.8p 0 994.1p 1 1011.5p 1 1011.8p 0 1085.8p 0 1086.1p 1 1103.5p 1 1103.8p 0 1177.8p 0 1178.1p 1 1195.5p 1 1195.8p 0 1269.8p 0 1270.1p 1 1287.5p 1 1287.8p 0 1361.8p 0 1362.1p 1 1379.5p 1 1379.8p 0 1453.8p 0 1454.1p 1 1471.5p 1 1471.8p 0 1545.8p 0 1546.1p 1 1563.5p 1 1563.8p 0 1637.8p 0 1638.1p 1 1655.5p 1 1655.8p 0 1729.8p 0 1730.1p 1 1747.5p 1 1747.8p 0 1821.8p 0 1822.1p 1 1839.5p 1 1839.8p 0 1913.8p 0 1914.1p 1 1931.5p 1 1931.8p 0 2005.8p 0 2006.1p 1 2023.5p 1 2023.8p 0 2097.8p 0 2098.1p 1 2115.5p 1 2115.8p 0 2189.8p 0 2190.1p 1 2207.5p 1 2207.8p 0)
VSindd vddh sindd 0
Sindd sindd lin cindd 0 SWI
VcinB cinB 0 PWL(0 0 276.2p 0 276.5p 1 349.1p 1 349.4p 0 552.2p 0 552.5p 1 625.1p 1 625.4p 0 828.2p 0 828.5p 1 901.1p 1 901.4p 0 1104.2p 0 1104.5p 1 1177.1p 1 1177.4p 0 1380.2p 0 1380.5p 1 1453.1p 1 1453.4p 0 1656.2p 0 1656.5p 1 1729.1p 1 1729.4p 0 1932.2p 0 1932.5p 1 2005.1p 1 2005.4p 0)
VSinB pB sinB 0
SinB sinB lin cinB 0 SWI
VcoutB coutB 0 PWL(0 0 368.2p 0 368.5p 1 459.5p 1 459.8p 0 644.2p 0 644.5p 1 735.5p 1 735.8p 0 920.2p 0 920.5p 1 1011.5p 1 1011.8p 0 1196.2p 0 1196.5p 1 1287.5p 1 1287.8p 0 1472.2p 0 1472.5p 1 1563.5p 1 1563.8p 0 1748.2p 0 1748.5p 1 1839.5p 1 1839.8p 0 2024.2p 0 2024.5p 1 2115.5p 1 2115.8p 0)
VSoutB pB soutB 0
SoutB soutB lout coutB 0 SWI
VcholdB choldB 0 PWL(0 0 460.2p 0 460.5p 1 551.5p 1 551.8p 0 736.2p 0 736.5p 1 827.5p 1 827.8p 0 1012.2p 0 1012.5p 1 1103.5p 1 1103.8p 0 1288.2p 0 1288.5p 1 1379.5p 1 1379.8p 0 1564.2p 0 1564.5p 1 1655.5p 1 1655.8p 0 1840.2p 0 1840.5p 1 1931.5p 1 1931.8p 0 2116.2p 0 2116.5p 1 2207.5p 1 2207.8p 0)
VSholdB pB sholdB 0
SholdB sholdB vddh choldB 0 SWI
VczeroB czeroB 0 PWL(0 0 349.8p 0 350.1p 1 367.5p 1 367.8p 0 625.8p 0 626.1p 1 643.5p 1 643.8p 0 901.8p 0 902.1p 1 919.5p 1 919.8p 0 1177.8p 0 1178.1p 1 1195.5p 1 1195.8p 0 1453.8p 0 1454.1p 1 1471.5p 1 1471.8p 0 1729.8p 0 1730.1p 1 1747.5p 1 1747.8p 0 2005.8p 0 2006.1p 1 2023.5p 1 2023.8p 0)
VSzeroB pB szeroB 0
SzeroB szeroB vzr czeroB 0 SWI
VcinC cinC 0 PWL(0 0 368.2p 0 368.5p 1 441.1p 1 441.4p 0 644.2p 0 644.5p 1 717.1p 1 717.4p 0 920.2p 0 920.5p 1 993.1p 1 993.4p 0 1196.2p 0 1196.5p 1 1269.1p 1 1269.4p 0 1472.2p 0 1472.5p 1 1545.1p 1 1545.4p 0 1748.2p 0 1748.5p 1 1821.1p 1 1821.4p 0 2024.2p 0 2024.5p 1 2097.1p 1 2097.4p 0)
VSinC pC sinC 0
SinC sinC lin cinC 0 SWI
VcoutC coutC 0 PWL(0 0 460.2p 0 460.5p 1 551.5p 1 551.8p 0 736.2p 0 736.5p 1 827.5p 1 827.8p 0 1012.2p 0 1012.5p 1 1103.5p 1 1103.8p 0 1288.2p 0 1288.5p 1 1379.5p 1 1379.8p 0 1564.2p 0 1564.5p 1 1655.5p 1 1655.8p 0 1840.2p 0 1840.5p 1 1931.5p 1 1931.8p 0 2116.2p 0 2116.5p 1 2207.5p 1 2207.8p 0)
VSoutC pC soutC 0
SoutC soutC lout coutC 0 SWI
VcholdC choldC 0 PWL(0 0 276.2p 0 276.5p 1 367.5p 1 367.8p 0 552.2p 0 552.5p 1 643.5p 1 643.8p 0 828.2p 0 828.5p 1 919.5p 1 919.8p 0 1104.2p 0 1104.5p 1 1195.5p 1 1195.8p 0 1380.2p 0 1380.5p 1 1471.5p 1 1471.8p 0 1656.2p 0 1656.5p 1 1747.5p 1 1747.8p 0 1932.2p 0 1932.5p 1 2023.5p 1 2023.8p 0)
VSholdC pC sholdC 0
SholdC sholdC vddh choldC 0 SWI
VczeroC czeroC 0 PWL(0 0 441.8p 0 442.1p 1 459.5p 1 459.8p 0 717.8p 0 718.1p 1 735.5p 1 735.8p 0 993.8p 0 994.1p 1 1011.5p 1 1011.8p 0 1269.8p 0 1270.1p 1 1287.5p 1 1287.8p 0 1545.8p 0 1546.1p 1 1563.5p 1 1563.8p 0 1821.8p 0 1822.1p 1 1839.5p 1 1839.8p 0 2097.8p 0 2098.1p 1 2115.5p 1 2115.8p 0)
VSzeroC pC szeroC 0
SzeroC szeroC vzr czeroC 0 SWI
VI2_0 in2_0 0 PWL(0 1.65 275p 1.65 277p 0 551p 0 553p 1.65 827p 1.65 829p 0 1103p 0 1105p 1.65 1379p 1.65 1381p 0 1655p 0 1657p 1.65 1931p 1.65 1933p 0)
VI2_1 in2_1 0 PWL(0 1.65 275p 1.65 277p 0 551p 0 553p 1.65 827p 1.65 829p 0 1103p 0 1105p 1.65 1379p 1.65 1381p 0 1655p 0 1657p 1.65 1931p 1.65 1933p 0)
VI2_2 in2_2 0 PWL(0 1.65 275p 1.65 277p 0 551p 0 553p 1.65 827p 1.65 829p 0 1103p 0 1105p 1.65 1379p 1.65 1381p 0 1655p 0 1657p 1.65 1931p 1.65 1933p 0)
VI2_3 in2_3 0 PWL(0 0 275p 0 277p 1.65 551p 1.65 553p 0 827p 0 829p 1.65 1103p 1.65 1105p 0 1379p 0 1381p 1.65 1655p 1.65 1657p 0 1931p 0 1933p 1.65)
VI2_4 in2_4 0 PWL(0 1.65 275p 1.65 277p 0 551p 0 553p 1.65 827p 1.65 829p 0 1103p 0 1105p 1.65 1379p 1.65 1381p 0 1655p 0 1657p 1.65 1931p 1.65 1933p 0)
VI2_5 in2_5 0 PWL(0 0 275p 0 277p 1.65 551p 1.65 553p 0 827p 0 829p 1.65 1103p 1.65 1105p 0 1379p 0 1381p 1.65 1655p 1.65 1657p 0 1931p 0 1933p 1.65)
VI2_6 in2_6 0 PWL(0 0 275p 0 277p 1.65 551p 1.65 553p 0 827p 0 829p 1.65 1103p 1.65 1105p 0 1379p 0 1381p 1.65 1655p 1.65 1657p 0 1931p 0 1933p 1.65)
VI2_7 in2_7 0 PWL(0 1.65 275p 1.65 277p 0 551p 0 553p 1.65 827p 1.65 829p 0 1103p 0 1105p 1.65 1379p 1.65 1381p 0 1655p 0 1657p 1.65 1931p 1.65 1933p 0)
VMG7 gn7 0 0
XP7_1_0 o7_1_0 in2_0 ph7 ph7 sg13_lv_pmos w=1.12u l=0.13u
XN7_1_0 o7_1_0 in2_0 gn7 gn7 sg13_lv_nmos w=0.74u l=0.13u
CL7_1_0 o7_1_0 gn7 2f
XP7_1_1 o7_1_1 in2_1 ph7 ph7 sg13_lv_pmos w=1.12u l=0.13u
XN7_1_1 o7_1_1 in2_1 gn7 gn7 sg13_lv_nmos w=0.74u l=0.13u
CL7_1_1 o7_1_1 gn7 2f
XP7_1_2 o7_1_2 in2_2 ph7 ph7 sg13_lv_pmos w=1.12u l=0.13u
XN7_1_2 o7_1_2 in2_2 gn7 gn7 sg13_lv_nmos w=0.74u l=0.13u
CL7_1_2 o7_1_2 gn7 2f
XP7_1_3 o7_1_3 in2_3 ph7 ph7 sg13_lv_pmos w=1.12u l=0.13u
XN7_1_3 o7_1_3 in2_3 gn7 gn7 sg13_lv_nmos w=0.74u l=0.13u
CL7_1_3 o7_1_3 gn7 2f
XP7_1_4 o7_1_4 in2_4 ph7 ph7 sg13_lv_pmos w=1.12u l=0.13u
XN7_1_4 o7_1_4 in2_4 gn7 gn7 sg13_lv_nmos w=0.74u l=0.13u
CL7_1_4 o7_1_4 gn7 2f
XP7_1_5 o7_1_5 in2_5 ph7 ph7 sg13_lv_pmos w=1.12u l=0.13u
XN7_1_5 o7_1_5 in2_5 gn7 gn7 sg13_lv_nmos w=0.74u l=0.13u
CL7_1_5 o7_1_5 gn7 2f
XP7_1_6 o7_1_6 in2_6 ph7 ph7 sg13_lv_pmos w=1.12u l=0.13u
XN7_1_6 o7_1_6 in2_6 gn7 gn7 sg13_lv_nmos w=0.74u l=0.13u
CL7_1_6 o7_1_6 gn7 2f
XP7_1_7 o7_1_7 in2_7 ph7 ph7 sg13_lv_pmos w=1.12u l=0.13u
XN7_1_7 o7_1_7 in2_7 gn7 gn7 sg13_lv_nmos w=0.74u l=0.13u
CL7_1_7 o7_1_7 gn7 2f
XP7_2_0 o7_2_0 o7_1_0 ph7 ph7 sg13_lv_pmos w=1.12u l=0.13u
XN7_2_0 o7_2_0 o7_1_0 gn7 gn7 sg13_lv_nmos w=0.74u l=0.13u
CL7_2_0 o7_2_0 gn7 2f
XP7_2_1 o7_2_1 o7_1_1 ph7 ph7 sg13_lv_pmos w=1.12u l=0.13u
XN7_2_1 o7_2_1 o7_1_1 gn7 gn7 sg13_lv_nmos w=0.74u l=0.13u
CL7_2_1 o7_2_1 gn7 2f
XP7_2_2 o7_2_2 o7_1_2 ph7 ph7 sg13_lv_pmos w=1.12u l=0.13u
XN7_2_2 o7_2_2 o7_1_2 gn7 gn7 sg13_lv_nmos w=0.74u l=0.13u
CL7_2_2 o7_2_2 gn7 2f
XP7_2_3 o7_2_3 o7_1_3 ph7 ph7 sg13_lv_pmos w=1.12u l=0.13u
XN7_2_3 o7_2_3 o7_1_3 gn7 gn7 sg13_lv_nmos w=0.74u l=0.13u
CL7_2_3 o7_2_3 gn7 2f
XP7_2_4 o7_2_4 o7_1_4 ph7 ph7 sg13_lv_pmos w=1.12u l=0.13u
XN7_2_4 o7_2_4 o7_1_4 gn7 gn7 sg13_lv_nmos w=0.74u l=0.13u
CL7_2_4 o7_2_4 gn7 2f
XP7_2_5 o7_2_5 o7_1_5 ph7 ph7 sg13_lv_pmos w=1.12u l=0.13u
XN7_2_5 o7_2_5 o7_1_5 gn7 gn7 sg13_lv_nmos w=0.74u l=0.13u
CL7_2_5 o7_2_5 gn7 2f
XP7_2_6 o7_2_6 o7_1_6 ph7 ph7 sg13_lv_pmos w=1.12u l=0.13u
XN7_2_6 o7_2_6 o7_1_6 gn7 gn7 sg13_lv_nmos w=0.74u l=0.13u
CL7_2_6 o7_2_6 gn7 2f
XP7_2_7 o7_2_7 o7_1_7 ph7 ph7 sg13_lv_pmos w=1.12u l=0.13u
XN7_2_7 o7_2_7 o7_1_7 gn7 gn7 sg13_lv_nmos w=0.74u l=0.13u
CL7_2_7 o7_2_7 gn7 2f
XP7_3_0 o7_3_0 o7_2_0 ph7 ph7 sg13_lv_pmos w=1.12u l=0.13u
XN7_3_0 o7_3_0 o7_2_0 gn7 gn7 sg13_lv_nmos w=0.74u l=0.13u
CL7_3_0 o7_3_0 gn7 2f
XP7_3_1 o7_3_1 o7_2_1 ph7 ph7 sg13_lv_pmos w=1.12u l=0.13u
XN7_3_1 o7_3_1 o7_2_1 gn7 gn7 sg13_lv_nmos w=0.74u l=0.13u
CL7_3_1 o7_3_1 gn7 2f
XP7_3_2 o7_3_2 o7_2_2 ph7 ph7 sg13_lv_pmos w=1.12u l=0.13u
XN7_3_2 o7_3_2 o7_2_2 gn7 gn7 sg13_lv_nmos w=0.74u l=0.13u
CL7_3_2 o7_3_2 gn7 2f
XP7_3_3 o7_3_3 o7_2_3 ph7 ph7 sg13_lv_pmos w=1.12u l=0.13u
XN7_3_3 o7_3_3 o7_2_3 gn7 gn7 sg13_lv_nmos w=0.74u l=0.13u
CL7_3_3 o7_3_3 gn7 2f
XP7_3_4 o7_3_4 o7_2_4 ph7 ph7 sg13_lv_pmos w=1.12u l=0.13u
XN7_3_4 o7_3_4 o7_2_4 gn7 gn7 sg13_lv_nmos w=0.74u l=0.13u
CL7_3_4 o7_3_4 gn7 2f
XP7_3_5 o7_3_5 o7_2_5 ph7 ph7 sg13_lv_pmos w=1.12u l=0.13u
XN7_3_5 o7_3_5 o7_2_5 gn7 gn7 sg13_lv_nmos w=0.74u l=0.13u
CL7_3_5 o7_3_5 gn7 2f
XP7_3_6 o7_3_6 o7_2_6 ph7 ph7 sg13_lv_pmos w=1.12u l=0.13u
XN7_3_6 o7_3_6 o7_2_6 gn7 gn7 sg13_lv_nmos w=0.74u l=0.13u
CL7_3_6 o7_3_6 gn7 2f
XP7_3_7 o7_3_7 o7_2_7 ph7 ph7 sg13_lv_pmos w=1.12u l=0.13u
XN7_3_7 o7_3_7 o7_2_7 gn7 gn7 sg13_lv_nmos w=0.74u l=0.13u
CL7_3_7 o7_3_7 gn7 2f
VMG8 gn8 0 0
XP8_1_0 o8_1_0 o7_3_0 ph8 ph8 sg13_lv_pmos w=1.12u l=0.13u
XN8_1_0 o8_1_0 o7_3_0 gn8 gn8 sg13_lv_nmos w=0.74u l=0.13u
CL8_1_0 o8_1_0 gn8 2f
XP8_1_1 o8_1_1 o7_3_1 ph8 ph8 sg13_lv_pmos w=1.12u l=0.13u
XN8_1_1 o8_1_1 o7_3_1 gn8 gn8 sg13_lv_nmos w=0.74u l=0.13u
CL8_1_1 o8_1_1 gn8 2f
XP8_1_2 o8_1_2 o7_3_2 ph8 ph8 sg13_lv_pmos w=1.12u l=0.13u
XN8_1_2 o8_1_2 o7_3_2 gn8 gn8 sg13_lv_nmos w=0.74u l=0.13u
CL8_1_2 o8_1_2 gn8 2f
XP8_1_3 o8_1_3 o7_3_3 ph8 ph8 sg13_lv_pmos w=1.12u l=0.13u
XN8_1_3 o8_1_3 o7_3_3 gn8 gn8 sg13_lv_nmos w=0.74u l=0.13u
CL8_1_3 o8_1_3 gn8 2f
XP8_1_4 o8_1_4 o7_3_4 ph8 ph8 sg13_lv_pmos w=1.12u l=0.13u
XN8_1_4 o8_1_4 o7_3_4 gn8 gn8 sg13_lv_nmos w=0.74u l=0.13u
CL8_1_4 o8_1_4 gn8 2f
XP8_1_5 o8_1_5 o7_3_5 ph8 ph8 sg13_lv_pmos w=1.12u l=0.13u
XN8_1_5 o8_1_5 o7_3_5 gn8 gn8 sg13_lv_nmos w=0.74u l=0.13u
CL8_1_5 o8_1_5 gn8 2f
XP8_1_6 o8_1_6 o7_3_6 ph8 ph8 sg13_lv_pmos w=1.12u l=0.13u
XN8_1_6 o8_1_6 o7_3_6 gn8 gn8 sg13_lv_nmos w=0.74u l=0.13u
CL8_1_6 o8_1_6 gn8 2f
XP8_1_7 o8_1_7 o7_3_7 ph8 ph8 sg13_lv_pmos w=1.12u l=0.13u
XN8_1_7 o8_1_7 o7_3_7 gn8 gn8 sg13_lv_nmos w=0.74u l=0.13u
CL8_1_7 o8_1_7 gn8 2f
XP8_2_0 o8_2_0 o8_1_0 ph8 ph8 sg13_lv_pmos w=1.12u l=0.13u
XN8_2_0 o8_2_0 o8_1_0 gn8 gn8 sg13_lv_nmos w=0.74u l=0.13u
CL8_2_0 o8_2_0 gn8 2f
XP8_2_1 o8_2_1 o8_1_1 ph8 ph8 sg13_lv_pmos w=1.12u l=0.13u
XN8_2_1 o8_2_1 o8_1_1 gn8 gn8 sg13_lv_nmos w=0.74u l=0.13u
CL8_2_1 o8_2_1 gn8 2f
XP8_2_2 o8_2_2 o8_1_2 ph8 ph8 sg13_lv_pmos w=1.12u l=0.13u
XN8_2_2 o8_2_2 o8_1_2 gn8 gn8 sg13_lv_nmos w=0.74u l=0.13u
CL8_2_2 o8_2_2 gn8 2f
XP8_2_3 o8_2_3 o8_1_3 ph8 ph8 sg13_lv_pmos w=1.12u l=0.13u
XN8_2_3 o8_2_3 o8_1_3 gn8 gn8 sg13_lv_nmos w=0.74u l=0.13u
CL8_2_3 o8_2_3 gn8 2f
XP8_2_4 o8_2_4 o8_1_4 ph8 ph8 sg13_lv_pmos w=1.12u l=0.13u
XN8_2_4 o8_2_4 o8_1_4 gn8 gn8 sg13_lv_nmos w=0.74u l=0.13u
CL8_2_4 o8_2_4 gn8 2f
XP8_2_5 o8_2_5 o8_1_5 ph8 ph8 sg13_lv_pmos w=1.12u l=0.13u
XN8_2_5 o8_2_5 o8_1_5 gn8 gn8 sg13_lv_nmos w=0.74u l=0.13u
CL8_2_5 o8_2_5 gn8 2f
XP8_2_6 o8_2_6 o8_1_6 ph8 ph8 sg13_lv_pmos w=1.12u l=0.13u
XN8_2_6 o8_2_6 o8_1_6 gn8 gn8 sg13_lv_nmos w=0.74u l=0.13u
CL8_2_6 o8_2_6 gn8 2f
XP8_2_7 o8_2_7 o8_1_7 ph8 ph8 sg13_lv_pmos w=1.12u l=0.13u
XN8_2_7 o8_2_7 o8_1_7 gn8 gn8 sg13_lv_nmos w=0.74u l=0.13u
CL8_2_7 o8_2_7 gn8 2f
XP8_3_0 o8_3_0 o8_2_0 ph8 ph8 sg13_lv_pmos w=1.12u l=0.13u
XN8_3_0 o8_3_0 o8_2_0 gn8 gn8 sg13_lv_nmos w=0.74u l=0.13u
CL8_3_0 o8_3_0 gn8 2f
XP8_3_1 o8_3_1 o8_2_1 ph8 ph8 sg13_lv_pmos w=1.12u l=0.13u
XN8_3_1 o8_3_1 o8_2_1 gn8 gn8 sg13_lv_nmos w=0.74u l=0.13u
CL8_3_1 o8_3_1 gn8 2f
XP8_3_2 o8_3_2 o8_2_2 ph8 ph8 sg13_lv_pmos w=1.12u l=0.13u
XN8_3_2 o8_3_2 o8_2_2 gn8 gn8 sg13_lv_nmos w=0.74u l=0.13u
CL8_3_2 o8_3_2 gn8 2f
XP8_3_3 o8_3_3 o8_2_3 ph8 ph8 sg13_lv_pmos w=1.12u l=0.13u
XN8_3_3 o8_3_3 o8_2_3 gn8 gn8 sg13_lv_nmos w=0.74u l=0.13u
CL8_3_3 o8_3_3 gn8 2f
XP8_3_4 o8_3_4 o8_2_4 ph8 ph8 sg13_lv_pmos w=1.12u l=0.13u
XN8_3_4 o8_3_4 o8_2_4 gn8 gn8 sg13_lv_nmos w=0.74u l=0.13u
CL8_3_4 o8_3_4 gn8 2f
XP8_3_5 o8_3_5 o8_2_5 ph8 ph8 sg13_lv_pmos w=1.12u l=0.13u
XN8_3_5 o8_3_5 o8_2_5 gn8 gn8 sg13_lv_nmos w=0.74u l=0.13u
CL8_3_5 o8_3_5 gn8 2f
XP8_3_6 o8_3_6 o8_2_6 ph8 ph8 sg13_lv_pmos w=1.12u l=0.13u
XN8_3_6 o8_3_6 o8_2_6 gn8 gn8 sg13_lv_nmos w=0.74u l=0.13u
CL8_3_6 o8_3_6 gn8 2f
XP8_3_7 o8_3_7 o8_2_7 ph8 ph8 sg13_lv_pmos w=1.12u l=0.13u
XN8_3_7 o8_3_7 o8_2_7 gn8 gn8 sg13_lv_nmos w=0.74u l=0.13u
CL8_3_7 o8_3_7 gn8 2f
VMG9 gn9 0 0
XP9_1_0 o9_1_0 o8_3_0 ph9 ph9 sg13_lv_pmos w=1.12u l=0.13u
XN9_1_0 o9_1_0 o8_3_0 gn9 gn9 sg13_lv_nmos w=0.74u l=0.13u
CL9_1_0 o9_1_0 gn9 2f
XP9_1_1 o9_1_1 o8_3_1 ph9 ph9 sg13_lv_pmos w=1.12u l=0.13u
XN9_1_1 o9_1_1 o8_3_1 gn9 gn9 sg13_lv_nmos w=0.74u l=0.13u
CL9_1_1 o9_1_1 gn9 2f
XP9_1_2 o9_1_2 o8_3_2 ph9 ph9 sg13_lv_pmos w=1.12u l=0.13u
XN9_1_2 o9_1_2 o8_3_2 gn9 gn9 sg13_lv_nmos w=0.74u l=0.13u
CL9_1_2 o9_1_2 gn9 2f
XP9_1_3 o9_1_3 o8_3_3 ph9 ph9 sg13_lv_pmos w=1.12u l=0.13u
XN9_1_3 o9_1_3 o8_3_3 gn9 gn9 sg13_lv_nmos w=0.74u l=0.13u
CL9_1_3 o9_1_3 gn9 2f
XP9_1_4 o9_1_4 o8_3_4 ph9 ph9 sg13_lv_pmos w=1.12u l=0.13u
XN9_1_4 o9_1_4 o8_3_4 gn9 gn9 sg13_lv_nmos w=0.74u l=0.13u
CL9_1_4 o9_1_4 gn9 2f
XP9_1_5 o9_1_5 o8_3_5 ph9 ph9 sg13_lv_pmos w=1.12u l=0.13u
XN9_1_5 o9_1_5 o8_3_5 gn9 gn9 sg13_lv_nmos w=0.74u l=0.13u
CL9_1_5 o9_1_5 gn9 2f
XP9_1_6 o9_1_6 o8_3_6 ph9 ph9 sg13_lv_pmos w=1.12u l=0.13u
XN9_1_6 o9_1_6 o8_3_6 gn9 gn9 sg13_lv_nmos w=0.74u l=0.13u
CL9_1_6 o9_1_6 gn9 2f
XP9_1_7 o9_1_7 o8_3_7 ph9 ph9 sg13_lv_pmos w=1.12u l=0.13u
XN9_1_7 o9_1_7 o8_3_7 gn9 gn9 sg13_lv_nmos w=0.74u l=0.13u
CL9_1_7 o9_1_7 gn9 2f
XP9_2_0 o9_2_0 o9_1_0 ph9 ph9 sg13_lv_pmos w=1.12u l=0.13u
XN9_2_0 o9_2_0 o9_1_0 gn9 gn9 sg13_lv_nmos w=0.74u l=0.13u
CL9_2_0 o9_2_0 gn9 2f
XP9_2_1 o9_2_1 o9_1_1 ph9 ph9 sg13_lv_pmos w=1.12u l=0.13u
XN9_2_1 o9_2_1 o9_1_1 gn9 gn9 sg13_lv_nmos w=0.74u l=0.13u
CL9_2_1 o9_2_1 gn9 2f
XP9_2_2 o9_2_2 o9_1_2 ph9 ph9 sg13_lv_pmos w=1.12u l=0.13u
XN9_2_2 o9_2_2 o9_1_2 gn9 gn9 sg13_lv_nmos w=0.74u l=0.13u
CL9_2_2 o9_2_2 gn9 2f
XP9_2_3 o9_2_3 o9_1_3 ph9 ph9 sg13_lv_pmos w=1.12u l=0.13u
XN9_2_3 o9_2_3 o9_1_3 gn9 gn9 sg13_lv_nmos w=0.74u l=0.13u
CL9_2_3 o9_2_3 gn9 2f
XP9_2_4 o9_2_4 o9_1_4 ph9 ph9 sg13_lv_pmos w=1.12u l=0.13u
XN9_2_4 o9_2_4 o9_1_4 gn9 gn9 sg13_lv_nmos w=0.74u l=0.13u
CL9_2_4 o9_2_4 gn9 2f
XP9_2_5 o9_2_5 o9_1_5 ph9 ph9 sg13_lv_pmos w=1.12u l=0.13u
XN9_2_5 o9_2_5 o9_1_5 gn9 gn9 sg13_lv_nmos w=0.74u l=0.13u
CL9_2_5 o9_2_5 gn9 2f
XP9_2_6 o9_2_6 o9_1_6 ph9 ph9 sg13_lv_pmos w=1.12u l=0.13u
XN9_2_6 o9_2_6 o9_1_6 gn9 gn9 sg13_lv_nmos w=0.74u l=0.13u
CL9_2_6 o9_2_6 gn9 2f
XP9_2_7 o9_2_7 o9_1_7 ph9 ph9 sg13_lv_pmos w=1.12u l=0.13u
XN9_2_7 o9_2_7 o9_1_7 gn9 gn9 sg13_lv_nmos w=0.74u l=0.13u
CL9_2_7 o9_2_7 gn9 2f
XP9_3_0 o9_3_0 o9_2_0 ph9 ph9 sg13_lv_pmos w=1.12u l=0.13u
XN9_3_0 o9_3_0 o9_2_0 gn9 gn9 sg13_lv_nmos w=0.74u l=0.13u
CL9_3_0 o9_3_0 gn9 2f
XP9_3_1 o9_3_1 o9_2_1 ph9 ph9 sg13_lv_pmos w=1.12u l=0.13u
XN9_3_1 o9_3_1 o9_2_1 gn9 gn9 sg13_lv_nmos w=0.74u l=0.13u
CL9_3_1 o9_3_1 gn9 2f
XP9_3_2 o9_3_2 o9_2_2 ph9 ph9 sg13_lv_pmos w=1.12u l=0.13u
XN9_3_2 o9_3_2 o9_2_2 gn9 gn9 sg13_lv_nmos w=0.74u l=0.13u
CL9_3_2 o9_3_2 gn9 2f
XP9_3_3 o9_3_3 o9_2_3 ph9 ph9 sg13_lv_pmos w=1.12u l=0.13u
XN9_3_3 o9_3_3 o9_2_3 gn9 gn9 sg13_lv_nmos w=0.74u l=0.13u
CL9_3_3 o9_3_3 gn9 2f
XP9_3_4 o9_3_4 o9_2_4 ph9 ph9 sg13_lv_pmos w=1.12u l=0.13u
XN9_3_4 o9_3_4 o9_2_4 gn9 gn9 sg13_lv_nmos w=0.74u l=0.13u
CL9_3_4 o9_3_4 gn9 2f
XP9_3_5 o9_3_5 o9_2_5 ph9 ph9 sg13_lv_pmos w=1.12u l=0.13u
XN9_3_5 o9_3_5 o9_2_5 gn9 gn9 sg13_lv_nmos w=0.74u l=0.13u
CL9_3_5 o9_3_5 gn9 2f
XP9_3_6 o9_3_6 o9_2_6 ph9 ph9 sg13_lv_pmos w=1.12u l=0.13u
XN9_3_6 o9_3_6 o9_2_6 gn9 gn9 sg13_lv_nmos w=0.74u l=0.13u
CL9_3_6 o9_3_6 gn9 2f
XP9_3_7 o9_3_7 o9_2_7 ph9 ph9 sg13_lv_pmos w=1.12u l=0.13u
XN9_3_7 o9_3_7 o9_2_7 gn9 gn9 sg13_lv_nmos w=0.74u l=0.13u
CL9_3_7 o9_3_7 gn9 2f
VMG10 gn10 0 0
XP10_1_0 o10_1_0 o9_3_0 ph10 ph10 sg13_lv_pmos w=1.12u l=0.13u
XN10_1_0 o10_1_0 o9_3_0 gn10 gn10 sg13_lv_nmos w=0.74u l=0.13u
CL10_1_0 o10_1_0 gn10 2f
XP10_1_1 o10_1_1 o9_3_1 ph10 ph10 sg13_lv_pmos w=1.12u l=0.13u
XN10_1_1 o10_1_1 o9_3_1 gn10 gn10 sg13_lv_nmos w=0.74u l=0.13u
CL10_1_1 o10_1_1 gn10 2f
XP10_1_2 o10_1_2 o9_3_2 ph10 ph10 sg13_lv_pmos w=1.12u l=0.13u
XN10_1_2 o10_1_2 o9_3_2 gn10 gn10 sg13_lv_nmos w=0.74u l=0.13u
CL10_1_2 o10_1_2 gn10 2f
XP10_1_3 o10_1_3 o9_3_3 ph10 ph10 sg13_lv_pmos w=1.12u l=0.13u
XN10_1_3 o10_1_3 o9_3_3 gn10 gn10 sg13_lv_nmos w=0.74u l=0.13u
CL10_1_3 o10_1_3 gn10 2f
XP10_1_4 o10_1_4 o9_3_4 ph10 ph10 sg13_lv_pmos w=1.12u l=0.13u
XN10_1_4 o10_1_4 o9_3_4 gn10 gn10 sg13_lv_nmos w=0.74u l=0.13u
CL10_1_4 o10_1_4 gn10 2f
XP10_1_5 o10_1_5 o9_3_5 ph10 ph10 sg13_lv_pmos w=1.12u l=0.13u
XN10_1_5 o10_1_5 o9_3_5 gn10 gn10 sg13_lv_nmos w=0.74u l=0.13u
CL10_1_5 o10_1_5 gn10 2f
XP10_1_6 o10_1_6 o9_3_6 ph10 ph10 sg13_lv_pmos w=1.12u l=0.13u
XN10_1_6 o10_1_6 o9_3_6 gn10 gn10 sg13_lv_nmos w=0.74u l=0.13u
CL10_1_6 o10_1_6 gn10 2f
XP10_1_7 o10_1_7 o9_3_7 ph10 ph10 sg13_lv_pmos w=1.12u l=0.13u
XN10_1_7 o10_1_7 o9_3_7 gn10 gn10 sg13_lv_nmos w=0.74u l=0.13u
CL10_1_7 o10_1_7 gn10 2f
XP10_2_0 o10_2_0 o10_1_0 ph10 ph10 sg13_lv_pmos w=1.12u l=0.13u
XN10_2_0 o10_2_0 o10_1_0 gn10 gn10 sg13_lv_nmos w=0.74u l=0.13u
CL10_2_0 o10_2_0 gn10 2f
XP10_2_1 o10_2_1 o10_1_1 ph10 ph10 sg13_lv_pmos w=1.12u l=0.13u
XN10_2_1 o10_2_1 o10_1_1 gn10 gn10 sg13_lv_nmos w=0.74u l=0.13u
CL10_2_1 o10_2_1 gn10 2f
XP10_2_2 o10_2_2 o10_1_2 ph10 ph10 sg13_lv_pmos w=1.12u l=0.13u
XN10_2_2 o10_2_2 o10_1_2 gn10 gn10 sg13_lv_nmos w=0.74u l=0.13u
CL10_2_2 o10_2_2 gn10 2f
XP10_2_3 o10_2_3 o10_1_3 ph10 ph10 sg13_lv_pmos w=1.12u l=0.13u
XN10_2_3 o10_2_3 o10_1_3 gn10 gn10 sg13_lv_nmos w=0.74u l=0.13u
CL10_2_3 o10_2_3 gn10 2f
XP10_2_4 o10_2_4 o10_1_4 ph10 ph10 sg13_lv_pmos w=1.12u l=0.13u
XN10_2_4 o10_2_4 o10_1_4 gn10 gn10 sg13_lv_nmos w=0.74u l=0.13u
CL10_2_4 o10_2_4 gn10 2f
XP10_2_5 o10_2_5 o10_1_5 ph10 ph10 sg13_lv_pmos w=1.12u l=0.13u
XN10_2_5 o10_2_5 o10_1_5 gn10 gn10 sg13_lv_nmos w=0.74u l=0.13u
CL10_2_5 o10_2_5 gn10 2f
XP10_2_6 o10_2_6 o10_1_6 ph10 ph10 sg13_lv_pmos w=1.12u l=0.13u
XN10_2_6 o10_2_6 o10_1_6 gn10 gn10 sg13_lv_nmos w=0.74u l=0.13u
CL10_2_6 o10_2_6 gn10 2f
XP10_2_7 o10_2_7 o10_1_7 ph10 ph10 sg13_lv_pmos w=1.12u l=0.13u
XN10_2_7 o10_2_7 o10_1_7 gn10 gn10 sg13_lv_nmos w=0.74u l=0.13u
CL10_2_7 o10_2_7 gn10 2f
XP10_3_0 o10_3_0 o10_2_0 ph10 ph10 sg13_lv_pmos w=1.12u l=0.13u
XN10_3_0 o10_3_0 o10_2_0 gn10 gn10 sg13_lv_nmos w=0.74u l=0.13u
CL10_3_0 o10_3_0 gn10 2f
XP10_3_1 o10_3_1 o10_2_1 ph10 ph10 sg13_lv_pmos w=1.12u l=0.13u
XN10_3_1 o10_3_1 o10_2_1 gn10 gn10 sg13_lv_nmos w=0.74u l=0.13u
CL10_3_1 o10_3_1 gn10 2f
XP10_3_2 o10_3_2 o10_2_2 ph10 ph10 sg13_lv_pmos w=1.12u l=0.13u
XN10_3_2 o10_3_2 o10_2_2 gn10 gn10 sg13_lv_nmos w=0.74u l=0.13u
CL10_3_2 o10_3_2 gn10 2f
XP10_3_3 o10_3_3 o10_2_3 ph10 ph10 sg13_lv_pmos w=1.12u l=0.13u
XN10_3_3 o10_3_3 o10_2_3 gn10 gn10 sg13_lv_nmos w=0.74u l=0.13u
CL10_3_3 o10_3_3 gn10 2f
XP10_3_4 o10_3_4 o10_2_4 ph10 ph10 sg13_lv_pmos w=1.12u l=0.13u
XN10_3_4 o10_3_4 o10_2_4 gn10 gn10 sg13_lv_nmos w=0.74u l=0.13u
CL10_3_4 o10_3_4 gn10 2f
XP10_3_5 o10_3_5 o10_2_5 ph10 ph10 sg13_lv_pmos w=1.12u l=0.13u
XN10_3_5 o10_3_5 o10_2_5 gn10 gn10 sg13_lv_nmos w=0.74u l=0.13u
CL10_3_5 o10_3_5 gn10 2f
XP10_3_6 o10_3_6 o10_2_6 ph10 ph10 sg13_lv_pmos w=1.12u l=0.13u
XN10_3_6 o10_3_6 o10_2_6 gn10 gn10 sg13_lv_nmos w=0.74u l=0.13u
CL10_3_6 o10_3_6 gn10 2f
XP10_3_7 o10_3_7 o10_2_7 ph10 ph10 sg13_lv_pmos w=1.12u l=0.13u
XN10_3_7 o10_3_7 o10_2_7 gn10 gn10 sg13_lv_nmos w=0.74u l=0.13u
CL10_3_7 o10_3_7 gn10 2f
VMG11 gn11 0 0
XP11_1_0 o11_1_0 o10_3_0 ph11 ph11 sg13_lv_pmos w=1.12u l=0.13u
XN11_1_0 o11_1_0 o10_3_0 gn11 gn11 sg13_lv_nmos w=0.74u l=0.13u
CL11_1_0 o11_1_0 gn11 2f
XP11_1_1 o11_1_1 o10_3_1 ph11 ph11 sg13_lv_pmos w=1.12u l=0.13u
XN11_1_1 o11_1_1 o10_3_1 gn11 gn11 sg13_lv_nmos w=0.74u l=0.13u
CL11_1_1 o11_1_1 gn11 2f
XP11_1_2 o11_1_2 o10_3_2 ph11 ph11 sg13_lv_pmos w=1.12u l=0.13u
XN11_1_2 o11_1_2 o10_3_2 gn11 gn11 sg13_lv_nmos w=0.74u l=0.13u
CL11_1_2 o11_1_2 gn11 2f
XP11_1_3 o11_1_3 o10_3_3 ph11 ph11 sg13_lv_pmos w=1.12u l=0.13u
XN11_1_3 o11_1_3 o10_3_3 gn11 gn11 sg13_lv_nmos w=0.74u l=0.13u
CL11_1_3 o11_1_3 gn11 2f
XP11_1_4 o11_1_4 o10_3_4 ph11 ph11 sg13_lv_pmos w=1.12u l=0.13u
XN11_1_4 o11_1_4 o10_3_4 gn11 gn11 sg13_lv_nmos w=0.74u l=0.13u
CL11_1_4 o11_1_4 gn11 2f
XP11_1_5 o11_1_5 o10_3_5 ph11 ph11 sg13_lv_pmos w=1.12u l=0.13u
XN11_1_5 o11_1_5 o10_3_5 gn11 gn11 sg13_lv_nmos w=0.74u l=0.13u
CL11_1_5 o11_1_5 gn11 2f
XP11_1_6 o11_1_6 o10_3_6 ph11 ph11 sg13_lv_pmos w=1.12u l=0.13u
XN11_1_6 o11_1_6 o10_3_6 gn11 gn11 sg13_lv_nmos w=0.74u l=0.13u
CL11_1_6 o11_1_6 gn11 2f
XP11_1_7 o11_1_7 o10_3_7 ph11 ph11 sg13_lv_pmos w=1.12u l=0.13u
XN11_1_7 o11_1_7 o10_3_7 gn11 gn11 sg13_lv_nmos w=0.74u l=0.13u
CL11_1_7 o11_1_7 gn11 2f
XP11_2_0 o11_2_0 o11_1_0 ph11 ph11 sg13_lv_pmos w=1.12u l=0.13u
XN11_2_0 o11_2_0 o11_1_0 gn11 gn11 sg13_lv_nmos w=0.74u l=0.13u
CL11_2_0 o11_2_0 gn11 2f
XP11_2_1 o11_2_1 o11_1_1 ph11 ph11 sg13_lv_pmos w=1.12u l=0.13u
XN11_2_1 o11_2_1 o11_1_1 gn11 gn11 sg13_lv_nmos w=0.74u l=0.13u
CL11_2_1 o11_2_1 gn11 2f
XP11_2_2 o11_2_2 o11_1_2 ph11 ph11 sg13_lv_pmos w=1.12u l=0.13u
XN11_2_2 o11_2_2 o11_1_2 gn11 gn11 sg13_lv_nmos w=0.74u l=0.13u
CL11_2_2 o11_2_2 gn11 2f
XP11_2_3 o11_2_3 o11_1_3 ph11 ph11 sg13_lv_pmos w=1.12u l=0.13u
XN11_2_3 o11_2_3 o11_1_3 gn11 gn11 sg13_lv_nmos w=0.74u l=0.13u
CL11_2_3 o11_2_3 gn11 2f
XP11_2_4 o11_2_4 o11_1_4 ph11 ph11 sg13_lv_pmos w=1.12u l=0.13u
XN11_2_4 o11_2_4 o11_1_4 gn11 gn11 sg13_lv_nmos w=0.74u l=0.13u
CL11_2_4 o11_2_4 gn11 2f
XP11_2_5 o11_2_5 o11_1_5 ph11 ph11 sg13_lv_pmos w=1.12u l=0.13u
XN11_2_5 o11_2_5 o11_1_5 gn11 gn11 sg13_lv_nmos w=0.74u l=0.13u
CL11_2_5 o11_2_5 gn11 2f
XP11_2_6 o11_2_6 o11_1_6 ph11 ph11 sg13_lv_pmos w=1.12u l=0.13u
XN11_2_6 o11_2_6 o11_1_6 gn11 gn11 sg13_lv_nmos w=0.74u l=0.13u
CL11_2_6 o11_2_6 gn11 2f
XP11_2_7 o11_2_7 o11_1_7 ph11 ph11 sg13_lv_pmos w=1.12u l=0.13u
XN11_2_7 o11_2_7 o11_1_7 gn11 gn11 sg13_lv_nmos w=0.74u l=0.13u
CL11_2_7 o11_2_7 gn11 2f
XP11_3_0 o11_3_0 o11_2_0 ph11 ph11 sg13_lv_pmos w=1.12u l=0.13u
XN11_3_0 o11_3_0 o11_2_0 gn11 gn11 sg13_lv_nmos w=0.74u l=0.13u
CL11_3_0 o11_3_0 gn11 2f
XP11_3_1 o11_3_1 o11_2_1 ph11 ph11 sg13_lv_pmos w=1.12u l=0.13u
XN11_3_1 o11_3_1 o11_2_1 gn11 gn11 sg13_lv_nmos w=0.74u l=0.13u
CL11_3_1 o11_3_1 gn11 2f
XP11_3_2 o11_3_2 o11_2_2 ph11 ph11 sg13_lv_pmos w=1.12u l=0.13u
XN11_3_2 o11_3_2 o11_2_2 gn11 gn11 sg13_lv_nmos w=0.74u l=0.13u
CL11_3_2 o11_3_2 gn11 2f
XP11_3_3 o11_3_3 o11_2_3 ph11 ph11 sg13_lv_pmos w=1.12u l=0.13u
XN11_3_3 o11_3_3 o11_2_3 gn11 gn11 sg13_lv_nmos w=0.74u l=0.13u
CL11_3_3 o11_3_3 gn11 2f
XP11_3_4 o11_3_4 o11_2_4 ph11 ph11 sg13_lv_pmos w=1.12u l=0.13u
XN11_3_4 o11_3_4 o11_2_4 gn11 gn11 sg13_lv_nmos w=0.74u l=0.13u
CL11_3_4 o11_3_4 gn11 2f
XP11_3_5 o11_3_5 o11_2_5 ph11 ph11 sg13_lv_pmos w=1.12u l=0.13u
XN11_3_5 o11_3_5 o11_2_5 gn11 gn11 sg13_lv_nmos w=0.74u l=0.13u
CL11_3_5 o11_3_5 gn11 2f
XP11_3_6 o11_3_6 o11_2_6 ph11 ph11 sg13_lv_pmos w=1.12u l=0.13u
XN11_3_6 o11_3_6 o11_2_6 gn11 gn11 sg13_lv_nmos w=0.74u l=0.13u
CL11_3_6 o11_3_6 gn11 2f
XP11_3_7 o11_3_7 o11_2_7 ph11 ph11 sg13_lv_pmos w=1.12u l=0.13u
XN11_3_7 o11_3_7 o11_2_7 gn11 gn11 sg13_lv_nmos w=0.74u l=0.13u
CL11_3_7 o11_3_7 gn11 2f
VMG12 gn12 0 0
XP12_1_0 o12_1_0 o11_3_0 ph12 ph12 sg13_lv_pmos w=1.12u l=0.13u
XN12_1_0 o12_1_0 o11_3_0 gn12 gn12 sg13_lv_nmos w=0.74u l=0.13u
CL12_1_0 o12_1_0 gn12 2f
XP12_1_1 o12_1_1 o11_3_1 ph12 ph12 sg13_lv_pmos w=1.12u l=0.13u
XN12_1_1 o12_1_1 o11_3_1 gn12 gn12 sg13_lv_nmos w=0.74u l=0.13u
CL12_1_1 o12_1_1 gn12 2f
XP12_1_2 o12_1_2 o11_3_2 ph12 ph12 sg13_lv_pmos w=1.12u l=0.13u
XN12_1_2 o12_1_2 o11_3_2 gn12 gn12 sg13_lv_nmos w=0.74u l=0.13u
CL12_1_2 o12_1_2 gn12 2f
XP12_1_3 o12_1_3 o11_3_3 ph12 ph12 sg13_lv_pmos w=1.12u l=0.13u
XN12_1_3 o12_1_3 o11_3_3 gn12 gn12 sg13_lv_nmos w=0.74u l=0.13u
CL12_1_3 o12_1_3 gn12 2f
XP12_1_4 o12_1_4 o11_3_4 ph12 ph12 sg13_lv_pmos w=1.12u l=0.13u
XN12_1_4 o12_1_4 o11_3_4 gn12 gn12 sg13_lv_nmos w=0.74u l=0.13u
CL12_1_4 o12_1_4 gn12 2f
XP12_1_5 o12_1_5 o11_3_5 ph12 ph12 sg13_lv_pmos w=1.12u l=0.13u
XN12_1_5 o12_1_5 o11_3_5 gn12 gn12 sg13_lv_nmos w=0.74u l=0.13u
CL12_1_5 o12_1_5 gn12 2f
XP12_1_6 o12_1_6 o11_3_6 ph12 ph12 sg13_lv_pmos w=1.12u l=0.13u
XN12_1_6 o12_1_6 o11_3_6 gn12 gn12 sg13_lv_nmos w=0.74u l=0.13u
CL12_1_6 o12_1_6 gn12 2f
XP12_1_7 o12_1_7 o11_3_7 ph12 ph12 sg13_lv_pmos w=1.12u l=0.13u
XN12_1_7 o12_1_7 o11_3_7 gn12 gn12 sg13_lv_nmos w=0.74u l=0.13u
CL12_1_7 o12_1_7 gn12 2f
XP12_2_0 o12_2_0 o12_1_0 ph12 ph12 sg13_lv_pmos w=1.12u l=0.13u
XN12_2_0 o12_2_0 o12_1_0 gn12 gn12 sg13_lv_nmos w=0.74u l=0.13u
CL12_2_0 o12_2_0 gn12 2f
XP12_2_1 o12_2_1 o12_1_1 ph12 ph12 sg13_lv_pmos w=1.12u l=0.13u
XN12_2_1 o12_2_1 o12_1_1 gn12 gn12 sg13_lv_nmos w=0.74u l=0.13u
CL12_2_1 o12_2_1 gn12 2f
XP12_2_2 o12_2_2 o12_1_2 ph12 ph12 sg13_lv_pmos w=1.12u l=0.13u
XN12_2_2 o12_2_2 o12_1_2 gn12 gn12 sg13_lv_nmos w=0.74u l=0.13u
CL12_2_2 o12_2_2 gn12 2f
XP12_2_3 o12_2_3 o12_1_3 ph12 ph12 sg13_lv_pmos w=1.12u l=0.13u
XN12_2_3 o12_2_3 o12_1_3 gn12 gn12 sg13_lv_nmos w=0.74u l=0.13u
CL12_2_3 o12_2_3 gn12 2f
XP12_2_4 o12_2_4 o12_1_4 ph12 ph12 sg13_lv_pmos w=1.12u l=0.13u
XN12_2_4 o12_2_4 o12_1_4 gn12 gn12 sg13_lv_nmos w=0.74u l=0.13u
CL12_2_4 o12_2_4 gn12 2f
XP12_2_5 o12_2_5 o12_1_5 ph12 ph12 sg13_lv_pmos w=1.12u l=0.13u
XN12_2_5 o12_2_5 o12_1_5 gn12 gn12 sg13_lv_nmos w=0.74u l=0.13u
CL12_2_5 o12_2_5 gn12 2f
XP12_2_6 o12_2_6 o12_1_6 ph12 ph12 sg13_lv_pmos w=1.12u l=0.13u
XN12_2_6 o12_2_6 o12_1_6 gn12 gn12 sg13_lv_nmos w=0.74u l=0.13u
CL12_2_6 o12_2_6 gn12 2f
XP12_2_7 o12_2_7 o12_1_7 ph12 ph12 sg13_lv_pmos w=1.12u l=0.13u
XN12_2_7 o12_2_7 o12_1_7 gn12 gn12 sg13_lv_nmos w=0.74u l=0.13u
CL12_2_7 o12_2_7 gn12 2f
XP12_3_0 o12_3_0 o12_2_0 ph12 ph12 sg13_lv_pmos w=1.12u l=0.13u
XN12_3_0 o12_3_0 o12_2_0 gn12 gn12 sg13_lv_nmos w=0.74u l=0.13u
CL12_3_0 o12_3_0 gn12 2f
XP12_3_1 o12_3_1 o12_2_1 ph12 ph12 sg13_lv_pmos w=1.12u l=0.13u
XN12_3_1 o12_3_1 o12_2_1 gn12 gn12 sg13_lv_nmos w=0.74u l=0.13u
CL12_3_1 o12_3_1 gn12 2f
XP12_3_2 o12_3_2 o12_2_2 ph12 ph12 sg13_lv_pmos w=1.12u l=0.13u
XN12_3_2 o12_3_2 o12_2_2 gn12 gn12 sg13_lv_nmos w=0.74u l=0.13u
CL12_3_2 o12_3_2 gn12 2f
XP12_3_3 o12_3_3 o12_2_3 ph12 ph12 sg13_lv_pmos w=1.12u l=0.13u
XN12_3_3 o12_3_3 o12_2_3 gn12 gn12 sg13_lv_nmos w=0.74u l=0.13u
CL12_3_3 o12_3_3 gn12 2f
XP12_3_4 o12_3_4 o12_2_4 ph12 ph12 sg13_lv_pmos w=1.12u l=0.13u
XN12_3_4 o12_3_4 o12_2_4 gn12 gn12 sg13_lv_nmos w=0.74u l=0.13u
CL12_3_4 o12_3_4 gn12 2f
XP12_3_5 o12_3_5 o12_2_5 ph12 ph12 sg13_lv_pmos w=1.12u l=0.13u
XN12_3_5 o12_3_5 o12_2_5 gn12 gn12 sg13_lv_nmos w=0.74u l=0.13u
CL12_3_5 o12_3_5 gn12 2f
XP12_3_6 o12_3_6 o12_2_6 ph12 ph12 sg13_lv_pmos w=1.12u l=0.13u
XN12_3_6 o12_3_6 o12_2_6 gn12 gn12 sg13_lv_nmos w=0.74u l=0.13u
CL12_3_6 o12_3_6 gn12 2f
XP12_3_7 o12_3_7 o12_2_7 ph12 ph12 sg13_lv_pmos w=1.12u l=0.13u
XN12_3_7 o12_3_7 o12_2_7 gn12 gn12 sg13_lv_nmos w=0.74u l=0.13u
CL12_3_7 o12_3_7 gn12 2f
VI3_0 in3_0 0 PWL(0 1.65 275p 1.65 277p 0 551p 0 553p 1.65 827p 1.65 829p 0 1103p 0 1105p 1.65 1379p 1.65 1381p 0 1655p 0 1657p 1.65 1931p 1.65 1933p 0)
VI3_1 in3_1 0 PWL(0 1.65 275p 1.65 277p 0 551p 0 553p 1.65 827p 1.65 829p 0 1103p 0 1105p 1.65 1379p 1.65 1381p 0 1655p 0 1657p 1.65 1931p 1.65 1933p 0)
VI3_2 in3_2 0 PWL(0 1.65 275p 1.65 277p 0 551p 0 553p 1.65 827p 1.65 829p 0 1103p 0 1105p 1.65 1379p 1.65 1381p 0 1655p 0 1657p 1.65 1931p 1.65 1933p 0)
VI3_3 in3_3 0 PWL(0 0 275p 0 277p 1.65 551p 1.65 553p 0 827p 0 829p 1.65 1103p 1.65 1105p 0 1379p 0 1381p 1.65 1655p 1.65 1657p 0 1931p 0 1933p 1.65)
VI3_4 in3_4 0 PWL(0 1.65 275p 1.65 277p 0 551p 0 553p 1.65 827p 1.65 829p 0 1103p 0 1105p 1.65 1379p 1.65 1381p 0 1655p 0 1657p 1.65 1931p 1.65 1933p 0)
VI3_5 in3_5 0 PWL(0 0 275p 0 277p 1.65 551p 1.65 553p 0 827p 0 829p 1.65 1103p 1.65 1105p 0 1379p 0 1381p 1.65 1655p 1.65 1657p 0 1931p 0 1933p 1.65)
VI3_6 in3_6 0 PWL(0 0 275p 0 277p 1.65 551p 1.65 553p 0 827p 0 829p 1.65 1103p 1.65 1105p 0 1379p 0 1381p 1.65 1655p 1.65 1657p 0 1931p 0 1933p 1.65)
VI3_7 in3_7 0 PWL(0 1.65 275p 1.65 277p 0 551p 0 553p 1.65 827p 1.65 829p 0 1103p 0 1105p 1.65 1379p 1.65 1381p 0 1655p 0 1657p 1.65 1931p 1.65 1933p 0)
VMG13 gn13 0 0
XP13_1_0 o13_1_0 in3_0 ph13 ph13 sg13_lv_pmos w=1.12u l=0.13u
XN13_1_0 o13_1_0 in3_0 gn13 gn13 sg13_lv_nmos w=0.74u l=0.13u
CL13_1_0 o13_1_0 gn13 2f
XP13_1_1 o13_1_1 in3_1 ph13 ph13 sg13_lv_pmos w=1.12u l=0.13u
XN13_1_1 o13_1_1 in3_1 gn13 gn13 sg13_lv_nmos w=0.74u l=0.13u
CL13_1_1 o13_1_1 gn13 2f
XP13_1_2 o13_1_2 in3_2 ph13 ph13 sg13_lv_pmos w=1.12u l=0.13u
XN13_1_2 o13_1_2 in3_2 gn13 gn13 sg13_lv_nmos w=0.74u l=0.13u
CL13_1_2 o13_1_2 gn13 2f
XP13_1_3 o13_1_3 in3_3 ph13 ph13 sg13_lv_pmos w=1.12u l=0.13u
XN13_1_3 o13_1_3 in3_3 gn13 gn13 sg13_lv_nmos w=0.74u l=0.13u
CL13_1_3 o13_1_3 gn13 2f
XP13_1_4 o13_1_4 in3_4 ph13 ph13 sg13_lv_pmos w=1.12u l=0.13u
XN13_1_4 o13_1_4 in3_4 gn13 gn13 sg13_lv_nmos w=0.74u l=0.13u
CL13_1_4 o13_1_4 gn13 2f
XP13_1_5 o13_1_5 in3_5 ph13 ph13 sg13_lv_pmos w=1.12u l=0.13u
XN13_1_5 o13_1_5 in3_5 gn13 gn13 sg13_lv_nmos w=0.74u l=0.13u
CL13_1_5 o13_1_5 gn13 2f
XP13_1_6 o13_1_6 in3_6 ph13 ph13 sg13_lv_pmos w=1.12u l=0.13u
XN13_1_6 o13_1_6 in3_6 gn13 gn13 sg13_lv_nmos w=0.74u l=0.13u
CL13_1_6 o13_1_6 gn13 2f
XP13_1_7 o13_1_7 in3_7 ph13 ph13 sg13_lv_pmos w=1.12u l=0.13u
XN13_1_7 o13_1_7 in3_7 gn13 gn13 sg13_lv_nmos w=0.74u l=0.13u
CL13_1_7 o13_1_7 gn13 2f
XP13_2_0 o13_2_0 o13_1_0 ph13 ph13 sg13_lv_pmos w=1.12u l=0.13u
XN13_2_0 o13_2_0 o13_1_0 gn13 gn13 sg13_lv_nmos w=0.74u l=0.13u
CL13_2_0 o13_2_0 gn13 2f
XP13_2_1 o13_2_1 o13_1_1 ph13 ph13 sg13_lv_pmos w=1.12u l=0.13u
XN13_2_1 o13_2_1 o13_1_1 gn13 gn13 sg13_lv_nmos w=0.74u l=0.13u
CL13_2_1 o13_2_1 gn13 2f
XP13_2_2 o13_2_2 o13_1_2 ph13 ph13 sg13_lv_pmos w=1.12u l=0.13u
XN13_2_2 o13_2_2 o13_1_2 gn13 gn13 sg13_lv_nmos w=0.74u l=0.13u
CL13_2_2 o13_2_2 gn13 2f
XP13_2_3 o13_2_3 o13_1_3 ph13 ph13 sg13_lv_pmos w=1.12u l=0.13u
XN13_2_3 o13_2_3 o13_1_3 gn13 gn13 sg13_lv_nmos w=0.74u l=0.13u
CL13_2_3 o13_2_3 gn13 2f
XP13_2_4 o13_2_4 o13_1_4 ph13 ph13 sg13_lv_pmos w=1.12u l=0.13u
XN13_2_4 o13_2_4 o13_1_4 gn13 gn13 sg13_lv_nmos w=0.74u l=0.13u
CL13_2_4 o13_2_4 gn13 2f
XP13_2_5 o13_2_5 o13_1_5 ph13 ph13 sg13_lv_pmos w=1.12u l=0.13u
XN13_2_5 o13_2_5 o13_1_5 gn13 gn13 sg13_lv_nmos w=0.74u l=0.13u
CL13_2_5 o13_2_5 gn13 2f
XP13_2_6 o13_2_6 o13_1_6 ph13 ph13 sg13_lv_pmos w=1.12u l=0.13u
XN13_2_6 o13_2_6 o13_1_6 gn13 gn13 sg13_lv_nmos w=0.74u l=0.13u
CL13_2_6 o13_2_6 gn13 2f
XP13_2_7 o13_2_7 o13_1_7 ph13 ph13 sg13_lv_pmos w=1.12u l=0.13u
XN13_2_7 o13_2_7 o13_1_7 gn13 gn13 sg13_lv_nmos w=0.74u l=0.13u
CL13_2_7 o13_2_7 gn13 2f
XP13_3_0 o13_3_0 o13_2_0 ph13 ph13 sg13_lv_pmos w=1.12u l=0.13u
XN13_3_0 o13_3_0 o13_2_0 gn13 gn13 sg13_lv_nmos w=0.74u l=0.13u
CL13_3_0 o13_3_0 gn13 2f
XP13_3_1 o13_3_1 o13_2_1 ph13 ph13 sg13_lv_pmos w=1.12u l=0.13u
XN13_3_1 o13_3_1 o13_2_1 gn13 gn13 sg13_lv_nmos w=0.74u l=0.13u
CL13_3_1 o13_3_1 gn13 2f
XP13_3_2 o13_3_2 o13_2_2 ph13 ph13 sg13_lv_pmos w=1.12u l=0.13u
XN13_3_2 o13_3_2 o13_2_2 gn13 gn13 sg13_lv_nmos w=0.74u l=0.13u
CL13_3_2 o13_3_2 gn13 2f
XP13_3_3 o13_3_3 o13_2_3 ph13 ph13 sg13_lv_pmos w=1.12u l=0.13u
XN13_3_3 o13_3_3 o13_2_3 gn13 gn13 sg13_lv_nmos w=0.74u l=0.13u
CL13_3_3 o13_3_3 gn13 2f
XP13_3_4 o13_3_4 o13_2_4 ph13 ph13 sg13_lv_pmos w=1.12u l=0.13u
XN13_3_4 o13_3_4 o13_2_4 gn13 gn13 sg13_lv_nmos w=0.74u l=0.13u
CL13_3_4 o13_3_4 gn13 2f
XP13_3_5 o13_3_5 o13_2_5 ph13 ph13 sg13_lv_pmos w=1.12u l=0.13u
XN13_3_5 o13_3_5 o13_2_5 gn13 gn13 sg13_lv_nmos w=0.74u l=0.13u
CL13_3_5 o13_3_5 gn13 2f
XP13_3_6 o13_3_6 o13_2_6 ph13 ph13 sg13_lv_pmos w=1.12u l=0.13u
XN13_3_6 o13_3_6 o13_2_6 gn13 gn13 sg13_lv_nmos w=0.74u l=0.13u
CL13_3_6 o13_3_6 gn13 2f
XP13_3_7 o13_3_7 o13_2_7 ph13 ph13 sg13_lv_pmos w=1.12u l=0.13u
XN13_3_7 o13_3_7 o13_2_7 gn13 gn13 sg13_lv_nmos w=0.74u l=0.13u
CL13_3_7 o13_3_7 gn13 2f
VMG14 gn14 0 0
XP14_1_0 o14_1_0 o13_3_0 ph14 ph14 sg13_lv_pmos w=1.12u l=0.13u
XN14_1_0 o14_1_0 o13_3_0 gn14 gn14 sg13_lv_nmos w=0.74u l=0.13u
CL14_1_0 o14_1_0 gn14 2f
XP14_1_1 o14_1_1 o13_3_1 ph14 ph14 sg13_lv_pmos w=1.12u l=0.13u
XN14_1_1 o14_1_1 o13_3_1 gn14 gn14 sg13_lv_nmos w=0.74u l=0.13u
CL14_1_1 o14_1_1 gn14 2f
XP14_1_2 o14_1_2 o13_3_2 ph14 ph14 sg13_lv_pmos w=1.12u l=0.13u
XN14_1_2 o14_1_2 o13_3_2 gn14 gn14 sg13_lv_nmos w=0.74u l=0.13u
CL14_1_2 o14_1_2 gn14 2f
XP14_1_3 o14_1_3 o13_3_3 ph14 ph14 sg13_lv_pmos w=1.12u l=0.13u
XN14_1_3 o14_1_3 o13_3_3 gn14 gn14 sg13_lv_nmos w=0.74u l=0.13u
CL14_1_3 o14_1_3 gn14 2f
XP14_1_4 o14_1_4 o13_3_4 ph14 ph14 sg13_lv_pmos w=1.12u l=0.13u
XN14_1_4 o14_1_4 o13_3_4 gn14 gn14 sg13_lv_nmos w=0.74u l=0.13u
CL14_1_4 o14_1_4 gn14 2f
XP14_1_5 o14_1_5 o13_3_5 ph14 ph14 sg13_lv_pmos w=1.12u l=0.13u
XN14_1_5 o14_1_5 o13_3_5 gn14 gn14 sg13_lv_nmos w=0.74u l=0.13u
CL14_1_5 o14_1_5 gn14 2f
XP14_1_6 o14_1_6 o13_3_6 ph14 ph14 sg13_lv_pmos w=1.12u l=0.13u
XN14_1_6 o14_1_6 o13_3_6 gn14 gn14 sg13_lv_nmos w=0.74u l=0.13u
CL14_1_6 o14_1_6 gn14 2f
XP14_1_7 o14_1_7 o13_3_7 ph14 ph14 sg13_lv_pmos w=1.12u l=0.13u
XN14_1_7 o14_1_7 o13_3_7 gn14 gn14 sg13_lv_nmos w=0.74u l=0.13u
CL14_1_7 o14_1_7 gn14 2f
XP14_2_0 o14_2_0 o14_1_0 ph14 ph14 sg13_lv_pmos w=1.12u l=0.13u
XN14_2_0 o14_2_0 o14_1_0 gn14 gn14 sg13_lv_nmos w=0.74u l=0.13u
CL14_2_0 o14_2_0 gn14 2f
XP14_2_1 o14_2_1 o14_1_1 ph14 ph14 sg13_lv_pmos w=1.12u l=0.13u
XN14_2_1 o14_2_1 o14_1_1 gn14 gn14 sg13_lv_nmos w=0.74u l=0.13u
CL14_2_1 o14_2_1 gn14 2f
XP14_2_2 o14_2_2 o14_1_2 ph14 ph14 sg13_lv_pmos w=1.12u l=0.13u
XN14_2_2 o14_2_2 o14_1_2 gn14 gn14 sg13_lv_nmos w=0.74u l=0.13u
CL14_2_2 o14_2_2 gn14 2f
XP14_2_3 o14_2_3 o14_1_3 ph14 ph14 sg13_lv_pmos w=1.12u l=0.13u
XN14_2_3 o14_2_3 o14_1_3 gn14 gn14 sg13_lv_nmos w=0.74u l=0.13u
CL14_2_3 o14_2_3 gn14 2f
XP14_2_4 o14_2_4 o14_1_4 ph14 ph14 sg13_lv_pmos w=1.12u l=0.13u
XN14_2_4 o14_2_4 o14_1_4 gn14 gn14 sg13_lv_nmos w=0.74u l=0.13u
CL14_2_4 o14_2_4 gn14 2f
XP14_2_5 o14_2_5 o14_1_5 ph14 ph14 sg13_lv_pmos w=1.12u l=0.13u
XN14_2_5 o14_2_5 o14_1_5 gn14 gn14 sg13_lv_nmos w=0.74u l=0.13u
CL14_2_5 o14_2_5 gn14 2f
XP14_2_6 o14_2_6 o14_1_6 ph14 ph14 sg13_lv_pmos w=1.12u l=0.13u
XN14_2_6 o14_2_6 o14_1_6 gn14 gn14 sg13_lv_nmos w=0.74u l=0.13u
CL14_2_6 o14_2_6 gn14 2f
XP14_2_7 o14_2_7 o14_1_7 ph14 ph14 sg13_lv_pmos w=1.12u l=0.13u
XN14_2_7 o14_2_7 o14_1_7 gn14 gn14 sg13_lv_nmos w=0.74u l=0.13u
CL14_2_7 o14_2_7 gn14 2f
XP14_3_0 o14_3_0 o14_2_0 ph14 ph14 sg13_lv_pmos w=1.12u l=0.13u
XN14_3_0 o14_3_0 o14_2_0 gn14 gn14 sg13_lv_nmos w=0.74u l=0.13u
CL14_3_0 o14_3_0 gn14 2f
XP14_3_1 o14_3_1 o14_2_1 ph14 ph14 sg13_lv_pmos w=1.12u l=0.13u
XN14_3_1 o14_3_1 o14_2_1 gn14 gn14 sg13_lv_nmos w=0.74u l=0.13u
CL14_3_1 o14_3_1 gn14 2f
XP14_3_2 o14_3_2 o14_2_2 ph14 ph14 sg13_lv_pmos w=1.12u l=0.13u
XN14_3_2 o14_3_2 o14_2_2 gn14 gn14 sg13_lv_nmos w=0.74u l=0.13u
CL14_3_2 o14_3_2 gn14 2f
XP14_3_3 o14_3_3 o14_2_3 ph14 ph14 sg13_lv_pmos w=1.12u l=0.13u
XN14_3_3 o14_3_3 o14_2_3 gn14 gn14 sg13_lv_nmos w=0.74u l=0.13u
CL14_3_3 o14_3_3 gn14 2f
XP14_3_4 o14_3_4 o14_2_4 ph14 ph14 sg13_lv_pmos w=1.12u l=0.13u
XN14_3_4 o14_3_4 o14_2_4 gn14 gn14 sg13_lv_nmos w=0.74u l=0.13u
CL14_3_4 o14_3_4 gn14 2f
XP14_3_5 o14_3_5 o14_2_5 ph14 ph14 sg13_lv_pmos w=1.12u l=0.13u
XN14_3_5 o14_3_5 o14_2_5 gn14 gn14 sg13_lv_nmos w=0.74u l=0.13u
CL14_3_5 o14_3_5 gn14 2f
XP14_3_6 o14_3_6 o14_2_6 ph14 ph14 sg13_lv_pmos w=1.12u l=0.13u
XN14_3_6 o14_3_6 o14_2_6 gn14 gn14 sg13_lv_nmos w=0.74u l=0.13u
CL14_3_6 o14_3_6 gn14 2f
XP14_3_7 o14_3_7 o14_2_7 ph14 ph14 sg13_lv_pmos w=1.12u l=0.13u
XN14_3_7 o14_3_7 o14_2_7 gn14 gn14 sg13_lv_nmos w=0.74u l=0.13u
CL14_3_7 o14_3_7 gn14 2f
VMG15 gn15 0 0
XP15_1_0 o15_1_0 o14_3_0 ph15 ph15 sg13_lv_pmos w=1.12u l=0.13u
XN15_1_0 o15_1_0 o14_3_0 gn15 gn15 sg13_lv_nmos w=0.74u l=0.13u
CL15_1_0 o15_1_0 gn15 2f
XP15_1_1 o15_1_1 o14_3_1 ph15 ph15 sg13_lv_pmos w=1.12u l=0.13u
XN15_1_1 o15_1_1 o14_3_1 gn15 gn15 sg13_lv_nmos w=0.74u l=0.13u
CL15_1_1 o15_1_1 gn15 2f
XP15_1_2 o15_1_2 o14_3_2 ph15 ph15 sg13_lv_pmos w=1.12u l=0.13u
XN15_1_2 o15_1_2 o14_3_2 gn15 gn15 sg13_lv_nmos w=0.74u l=0.13u
CL15_1_2 o15_1_2 gn15 2f
XP15_1_3 o15_1_3 o14_3_3 ph15 ph15 sg13_lv_pmos w=1.12u l=0.13u
XN15_1_3 o15_1_3 o14_3_3 gn15 gn15 sg13_lv_nmos w=0.74u l=0.13u
CL15_1_3 o15_1_3 gn15 2f
XP15_1_4 o15_1_4 o14_3_4 ph15 ph15 sg13_lv_pmos w=1.12u l=0.13u
XN15_1_4 o15_1_4 o14_3_4 gn15 gn15 sg13_lv_nmos w=0.74u l=0.13u
CL15_1_4 o15_1_4 gn15 2f
XP15_1_5 o15_1_5 o14_3_5 ph15 ph15 sg13_lv_pmos w=1.12u l=0.13u
XN15_1_5 o15_1_5 o14_3_5 gn15 gn15 sg13_lv_nmos w=0.74u l=0.13u
CL15_1_5 o15_1_5 gn15 2f
XP15_1_6 o15_1_6 o14_3_6 ph15 ph15 sg13_lv_pmos w=1.12u l=0.13u
XN15_1_6 o15_1_6 o14_3_6 gn15 gn15 sg13_lv_nmos w=0.74u l=0.13u
CL15_1_6 o15_1_6 gn15 2f
XP15_1_7 o15_1_7 o14_3_7 ph15 ph15 sg13_lv_pmos w=1.12u l=0.13u
XN15_1_7 o15_1_7 o14_3_7 gn15 gn15 sg13_lv_nmos w=0.74u l=0.13u
CL15_1_7 o15_1_7 gn15 2f
XP15_2_0 o15_2_0 o15_1_0 ph15 ph15 sg13_lv_pmos w=1.12u l=0.13u
XN15_2_0 o15_2_0 o15_1_0 gn15 gn15 sg13_lv_nmos w=0.74u l=0.13u
CL15_2_0 o15_2_0 gn15 2f
XP15_2_1 o15_2_1 o15_1_1 ph15 ph15 sg13_lv_pmos w=1.12u l=0.13u
XN15_2_1 o15_2_1 o15_1_1 gn15 gn15 sg13_lv_nmos w=0.74u l=0.13u
CL15_2_1 o15_2_1 gn15 2f
XP15_2_2 o15_2_2 o15_1_2 ph15 ph15 sg13_lv_pmos w=1.12u l=0.13u
XN15_2_2 o15_2_2 o15_1_2 gn15 gn15 sg13_lv_nmos w=0.74u l=0.13u
CL15_2_2 o15_2_2 gn15 2f
XP15_2_3 o15_2_3 o15_1_3 ph15 ph15 sg13_lv_pmos w=1.12u l=0.13u
XN15_2_3 o15_2_3 o15_1_3 gn15 gn15 sg13_lv_nmos w=0.74u l=0.13u
CL15_2_3 o15_2_3 gn15 2f
XP15_2_4 o15_2_4 o15_1_4 ph15 ph15 sg13_lv_pmos w=1.12u l=0.13u
XN15_2_4 o15_2_4 o15_1_4 gn15 gn15 sg13_lv_nmos w=0.74u l=0.13u
CL15_2_4 o15_2_4 gn15 2f
XP15_2_5 o15_2_5 o15_1_5 ph15 ph15 sg13_lv_pmos w=1.12u l=0.13u
XN15_2_5 o15_2_5 o15_1_5 gn15 gn15 sg13_lv_nmos w=0.74u l=0.13u
CL15_2_5 o15_2_5 gn15 2f
XP15_2_6 o15_2_6 o15_1_6 ph15 ph15 sg13_lv_pmos w=1.12u l=0.13u
XN15_2_6 o15_2_6 o15_1_6 gn15 gn15 sg13_lv_nmos w=0.74u l=0.13u
CL15_2_6 o15_2_6 gn15 2f
XP15_2_7 o15_2_7 o15_1_7 ph15 ph15 sg13_lv_pmos w=1.12u l=0.13u
XN15_2_7 o15_2_7 o15_1_7 gn15 gn15 sg13_lv_nmos w=0.74u l=0.13u
CL15_2_7 o15_2_7 gn15 2f
XP15_3_0 o15_3_0 o15_2_0 ph15 ph15 sg13_lv_pmos w=1.12u l=0.13u
XN15_3_0 o15_3_0 o15_2_0 gn15 gn15 sg13_lv_nmos w=0.74u l=0.13u
CL15_3_0 o15_3_0 gn15 2f
XP15_3_1 o15_3_1 o15_2_1 ph15 ph15 sg13_lv_pmos w=1.12u l=0.13u
XN15_3_1 o15_3_1 o15_2_1 gn15 gn15 sg13_lv_nmos w=0.74u l=0.13u
CL15_3_1 o15_3_1 gn15 2f
XP15_3_2 o15_3_2 o15_2_2 ph15 ph15 sg13_lv_pmos w=1.12u l=0.13u
XN15_3_2 o15_3_2 o15_2_2 gn15 gn15 sg13_lv_nmos w=0.74u l=0.13u
CL15_3_2 o15_3_2 gn15 2f
XP15_3_3 o15_3_3 o15_2_3 ph15 ph15 sg13_lv_pmos w=1.12u l=0.13u
XN15_3_3 o15_3_3 o15_2_3 gn15 gn15 sg13_lv_nmos w=0.74u l=0.13u
CL15_3_3 o15_3_3 gn15 2f
XP15_3_4 o15_3_4 o15_2_4 ph15 ph15 sg13_lv_pmos w=1.12u l=0.13u
XN15_3_4 o15_3_4 o15_2_4 gn15 gn15 sg13_lv_nmos w=0.74u l=0.13u
CL15_3_4 o15_3_4 gn15 2f
XP15_3_5 o15_3_5 o15_2_5 ph15 ph15 sg13_lv_pmos w=1.12u l=0.13u
XN15_3_5 o15_3_5 o15_2_5 gn15 gn15 sg13_lv_nmos w=0.74u l=0.13u
CL15_3_5 o15_3_5 gn15 2f
XP15_3_6 o15_3_6 o15_2_6 ph15 ph15 sg13_lv_pmos w=1.12u l=0.13u
XN15_3_6 o15_3_6 o15_2_6 gn15 gn15 sg13_lv_nmos w=0.74u l=0.13u
CL15_3_6 o15_3_6 gn15 2f
XP15_3_7 o15_3_7 o15_2_7 ph15 ph15 sg13_lv_pmos w=1.12u l=0.13u
XN15_3_7 o15_3_7 o15_2_7 gn15 gn15 sg13_lv_nmos w=0.74u l=0.13u
CL15_3_7 o15_3_7 gn15 2f
VMG16 gn16 0 0
XP16_1_0 o16_1_0 o15_3_0 ph16 ph16 sg13_lv_pmos w=1.12u l=0.13u
XN16_1_0 o16_1_0 o15_3_0 gn16 gn16 sg13_lv_nmos w=0.74u l=0.13u
CL16_1_0 o16_1_0 gn16 2f
XP16_1_1 o16_1_1 o15_3_1 ph16 ph16 sg13_lv_pmos w=1.12u l=0.13u
XN16_1_1 o16_1_1 o15_3_1 gn16 gn16 sg13_lv_nmos w=0.74u l=0.13u
CL16_1_1 o16_1_1 gn16 2f
XP16_1_2 o16_1_2 o15_3_2 ph16 ph16 sg13_lv_pmos w=1.12u l=0.13u
XN16_1_2 o16_1_2 o15_3_2 gn16 gn16 sg13_lv_nmos w=0.74u l=0.13u
CL16_1_2 o16_1_2 gn16 2f
XP16_1_3 o16_1_3 o15_3_3 ph16 ph16 sg13_lv_pmos w=1.12u l=0.13u
XN16_1_3 o16_1_3 o15_3_3 gn16 gn16 sg13_lv_nmos w=0.74u l=0.13u
CL16_1_3 o16_1_3 gn16 2f
XP16_1_4 o16_1_4 o15_3_4 ph16 ph16 sg13_lv_pmos w=1.12u l=0.13u
XN16_1_4 o16_1_4 o15_3_4 gn16 gn16 sg13_lv_nmos w=0.74u l=0.13u
CL16_1_4 o16_1_4 gn16 2f
XP16_1_5 o16_1_5 o15_3_5 ph16 ph16 sg13_lv_pmos w=1.12u l=0.13u
XN16_1_5 o16_1_5 o15_3_5 gn16 gn16 sg13_lv_nmos w=0.74u l=0.13u
CL16_1_5 o16_1_5 gn16 2f
XP16_1_6 o16_1_6 o15_3_6 ph16 ph16 sg13_lv_pmos w=1.12u l=0.13u
XN16_1_6 o16_1_6 o15_3_6 gn16 gn16 sg13_lv_nmos w=0.74u l=0.13u
CL16_1_6 o16_1_6 gn16 2f
XP16_1_7 o16_1_7 o15_3_7 ph16 ph16 sg13_lv_pmos w=1.12u l=0.13u
XN16_1_7 o16_1_7 o15_3_7 gn16 gn16 sg13_lv_nmos w=0.74u l=0.13u
CL16_1_7 o16_1_7 gn16 2f
XP16_2_0 o16_2_0 o16_1_0 ph16 ph16 sg13_lv_pmos w=1.12u l=0.13u
XN16_2_0 o16_2_0 o16_1_0 gn16 gn16 sg13_lv_nmos w=0.74u l=0.13u
CL16_2_0 o16_2_0 gn16 2f
XP16_2_1 o16_2_1 o16_1_1 ph16 ph16 sg13_lv_pmos w=1.12u l=0.13u
XN16_2_1 o16_2_1 o16_1_1 gn16 gn16 sg13_lv_nmos w=0.74u l=0.13u
CL16_2_1 o16_2_1 gn16 2f
XP16_2_2 o16_2_2 o16_1_2 ph16 ph16 sg13_lv_pmos w=1.12u l=0.13u
XN16_2_2 o16_2_2 o16_1_2 gn16 gn16 sg13_lv_nmos w=0.74u l=0.13u
CL16_2_2 o16_2_2 gn16 2f
XP16_2_3 o16_2_3 o16_1_3 ph16 ph16 sg13_lv_pmos w=1.12u l=0.13u
XN16_2_3 o16_2_3 o16_1_3 gn16 gn16 sg13_lv_nmos w=0.74u l=0.13u
CL16_2_3 o16_2_3 gn16 2f
XP16_2_4 o16_2_4 o16_1_4 ph16 ph16 sg13_lv_pmos w=1.12u l=0.13u
XN16_2_4 o16_2_4 o16_1_4 gn16 gn16 sg13_lv_nmos w=0.74u l=0.13u
CL16_2_4 o16_2_4 gn16 2f
XP16_2_5 o16_2_5 o16_1_5 ph16 ph16 sg13_lv_pmos w=1.12u l=0.13u
XN16_2_5 o16_2_5 o16_1_5 gn16 gn16 sg13_lv_nmos w=0.74u l=0.13u
CL16_2_5 o16_2_5 gn16 2f
XP16_2_6 o16_2_6 o16_1_6 ph16 ph16 sg13_lv_pmos w=1.12u l=0.13u
XN16_2_6 o16_2_6 o16_1_6 gn16 gn16 sg13_lv_nmos w=0.74u l=0.13u
CL16_2_6 o16_2_6 gn16 2f
XP16_2_7 o16_2_7 o16_1_7 ph16 ph16 sg13_lv_pmos w=1.12u l=0.13u
XN16_2_7 o16_2_7 o16_1_7 gn16 gn16 sg13_lv_nmos w=0.74u l=0.13u
CL16_2_7 o16_2_7 gn16 2f
XP16_3_0 o16_3_0 o16_2_0 ph16 ph16 sg13_lv_pmos w=1.12u l=0.13u
XN16_3_0 o16_3_0 o16_2_0 gn16 gn16 sg13_lv_nmos w=0.74u l=0.13u
CL16_3_0 o16_3_0 gn16 2f
XP16_3_1 o16_3_1 o16_2_1 ph16 ph16 sg13_lv_pmos w=1.12u l=0.13u
XN16_3_1 o16_3_1 o16_2_1 gn16 gn16 sg13_lv_nmos w=0.74u l=0.13u
CL16_3_1 o16_3_1 gn16 2f
XP16_3_2 o16_3_2 o16_2_2 ph16 ph16 sg13_lv_pmos w=1.12u l=0.13u
XN16_3_2 o16_3_2 o16_2_2 gn16 gn16 sg13_lv_nmos w=0.74u l=0.13u
CL16_3_2 o16_3_2 gn16 2f
XP16_3_3 o16_3_3 o16_2_3 ph16 ph16 sg13_lv_pmos w=1.12u l=0.13u
XN16_3_3 o16_3_3 o16_2_3 gn16 gn16 sg13_lv_nmos w=0.74u l=0.13u
CL16_3_3 o16_3_3 gn16 2f
XP16_3_4 o16_3_4 o16_2_4 ph16 ph16 sg13_lv_pmos w=1.12u l=0.13u
XN16_3_4 o16_3_4 o16_2_4 gn16 gn16 sg13_lv_nmos w=0.74u l=0.13u
CL16_3_4 o16_3_4 gn16 2f
XP16_3_5 o16_3_5 o16_2_5 ph16 ph16 sg13_lv_pmos w=1.12u l=0.13u
XN16_3_5 o16_3_5 o16_2_5 gn16 gn16 sg13_lv_nmos w=0.74u l=0.13u
CL16_3_5 o16_3_5 gn16 2f
XP16_3_6 o16_3_6 o16_2_6 ph16 ph16 sg13_lv_pmos w=1.12u l=0.13u
XN16_3_6 o16_3_6 o16_2_6 gn16 gn16 sg13_lv_nmos w=0.74u l=0.13u
CL16_3_6 o16_3_6 gn16 2f
XP16_3_7 o16_3_7 o16_2_7 ph16 ph16 sg13_lv_pmos w=1.12u l=0.13u
XN16_3_7 o16_3_7 o16_2_7 gn16 gn16 sg13_lv_nmos w=0.74u l=0.13u
CL16_3_7 o16_3_7 gn16 2f
VMG17 gn17 0 0
XP17_1_0 o17_1_0 o16_3_0 ph17 ph17 sg13_lv_pmos w=1.12u l=0.13u
XN17_1_0 o17_1_0 o16_3_0 gn17 gn17 sg13_lv_nmos w=0.74u l=0.13u
CL17_1_0 o17_1_0 gn17 2f
XP17_1_1 o17_1_1 o16_3_1 ph17 ph17 sg13_lv_pmos w=1.12u l=0.13u
XN17_1_1 o17_1_1 o16_3_1 gn17 gn17 sg13_lv_nmos w=0.74u l=0.13u
CL17_1_1 o17_1_1 gn17 2f
XP17_1_2 o17_1_2 o16_3_2 ph17 ph17 sg13_lv_pmos w=1.12u l=0.13u
XN17_1_2 o17_1_2 o16_3_2 gn17 gn17 sg13_lv_nmos w=0.74u l=0.13u
CL17_1_2 o17_1_2 gn17 2f
XP17_1_3 o17_1_3 o16_3_3 ph17 ph17 sg13_lv_pmos w=1.12u l=0.13u
XN17_1_3 o17_1_3 o16_3_3 gn17 gn17 sg13_lv_nmos w=0.74u l=0.13u
CL17_1_3 o17_1_3 gn17 2f
XP17_1_4 o17_1_4 o16_3_4 ph17 ph17 sg13_lv_pmos w=1.12u l=0.13u
XN17_1_4 o17_1_4 o16_3_4 gn17 gn17 sg13_lv_nmos w=0.74u l=0.13u
CL17_1_4 o17_1_4 gn17 2f
XP17_1_5 o17_1_5 o16_3_5 ph17 ph17 sg13_lv_pmos w=1.12u l=0.13u
XN17_1_5 o17_1_5 o16_3_5 gn17 gn17 sg13_lv_nmos w=0.74u l=0.13u
CL17_1_5 o17_1_5 gn17 2f
XP17_1_6 o17_1_6 o16_3_6 ph17 ph17 sg13_lv_pmos w=1.12u l=0.13u
XN17_1_6 o17_1_6 o16_3_6 gn17 gn17 sg13_lv_nmos w=0.74u l=0.13u
CL17_1_6 o17_1_6 gn17 2f
XP17_1_7 o17_1_7 o16_3_7 ph17 ph17 sg13_lv_pmos w=1.12u l=0.13u
XN17_1_7 o17_1_7 o16_3_7 gn17 gn17 sg13_lv_nmos w=0.74u l=0.13u
CL17_1_7 o17_1_7 gn17 2f
XP17_2_0 o17_2_0 o17_1_0 ph17 ph17 sg13_lv_pmos w=1.12u l=0.13u
XN17_2_0 o17_2_0 o17_1_0 gn17 gn17 sg13_lv_nmos w=0.74u l=0.13u
CL17_2_0 o17_2_0 gn17 2f
XP17_2_1 o17_2_1 o17_1_1 ph17 ph17 sg13_lv_pmos w=1.12u l=0.13u
XN17_2_1 o17_2_1 o17_1_1 gn17 gn17 sg13_lv_nmos w=0.74u l=0.13u
CL17_2_1 o17_2_1 gn17 2f
XP17_2_2 o17_2_2 o17_1_2 ph17 ph17 sg13_lv_pmos w=1.12u l=0.13u
XN17_2_2 o17_2_2 o17_1_2 gn17 gn17 sg13_lv_nmos w=0.74u l=0.13u
CL17_2_2 o17_2_2 gn17 2f
XP17_2_3 o17_2_3 o17_1_3 ph17 ph17 sg13_lv_pmos w=1.12u l=0.13u
XN17_2_3 o17_2_3 o17_1_3 gn17 gn17 sg13_lv_nmos w=0.74u l=0.13u
CL17_2_3 o17_2_3 gn17 2f
XP17_2_4 o17_2_4 o17_1_4 ph17 ph17 sg13_lv_pmos w=1.12u l=0.13u
XN17_2_4 o17_2_4 o17_1_4 gn17 gn17 sg13_lv_nmos w=0.74u l=0.13u
CL17_2_4 o17_2_4 gn17 2f
XP17_2_5 o17_2_5 o17_1_5 ph17 ph17 sg13_lv_pmos w=1.12u l=0.13u
XN17_2_5 o17_2_5 o17_1_5 gn17 gn17 sg13_lv_nmos w=0.74u l=0.13u
CL17_2_5 o17_2_5 gn17 2f
XP17_2_6 o17_2_6 o17_1_6 ph17 ph17 sg13_lv_pmos w=1.12u l=0.13u
XN17_2_6 o17_2_6 o17_1_6 gn17 gn17 sg13_lv_nmos w=0.74u l=0.13u
CL17_2_6 o17_2_6 gn17 2f
XP17_2_7 o17_2_7 o17_1_7 ph17 ph17 sg13_lv_pmos w=1.12u l=0.13u
XN17_2_7 o17_2_7 o17_1_7 gn17 gn17 sg13_lv_nmos w=0.74u l=0.13u
CL17_2_7 o17_2_7 gn17 2f
XP17_3_0 o17_3_0 o17_2_0 ph17 ph17 sg13_lv_pmos w=1.12u l=0.13u
XN17_3_0 o17_3_0 o17_2_0 gn17 gn17 sg13_lv_nmos w=0.74u l=0.13u
CL17_3_0 o17_3_0 gn17 2f
XP17_3_1 o17_3_1 o17_2_1 ph17 ph17 sg13_lv_pmos w=1.12u l=0.13u
XN17_3_1 o17_3_1 o17_2_1 gn17 gn17 sg13_lv_nmos w=0.74u l=0.13u
CL17_3_1 o17_3_1 gn17 2f
XP17_3_2 o17_3_2 o17_2_2 ph17 ph17 sg13_lv_pmos w=1.12u l=0.13u
XN17_3_2 o17_3_2 o17_2_2 gn17 gn17 sg13_lv_nmos w=0.74u l=0.13u
CL17_3_2 o17_3_2 gn17 2f
XP17_3_3 o17_3_3 o17_2_3 ph17 ph17 sg13_lv_pmos w=1.12u l=0.13u
XN17_3_3 o17_3_3 o17_2_3 gn17 gn17 sg13_lv_nmos w=0.74u l=0.13u
CL17_3_3 o17_3_3 gn17 2f
XP17_3_4 o17_3_4 o17_2_4 ph17 ph17 sg13_lv_pmos w=1.12u l=0.13u
XN17_3_4 o17_3_4 o17_2_4 gn17 gn17 sg13_lv_nmos w=0.74u l=0.13u
CL17_3_4 o17_3_4 gn17 2f
XP17_3_5 o17_3_5 o17_2_5 ph17 ph17 sg13_lv_pmos w=1.12u l=0.13u
XN17_3_5 o17_3_5 o17_2_5 gn17 gn17 sg13_lv_nmos w=0.74u l=0.13u
CL17_3_5 o17_3_5 gn17 2f
XP17_3_6 o17_3_6 o17_2_6 ph17 ph17 sg13_lv_pmos w=1.12u l=0.13u
XN17_3_6 o17_3_6 o17_2_6 gn17 gn17 sg13_lv_nmos w=0.74u l=0.13u
CL17_3_6 o17_3_6 gn17 2f
XP17_3_7 o17_3_7 o17_2_7 ph17 ph17 sg13_lv_pmos w=1.12u l=0.13u
XN17_3_7 o17_3_7 o17_2_7 gn17 gn17 sg13_lv_nmos w=0.74u l=0.13u
CL17_3_7 o17_3_7 gn17 2f
VMG18 gn18 0 0
XP18_1_0 o18_1_0 o17_3_0 ph18 ph18 sg13_lv_pmos w=1.12u l=0.13u
XN18_1_0 o18_1_0 o17_3_0 gn18 gn18 sg13_lv_nmos w=0.74u l=0.13u
CL18_1_0 o18_1_0 gn18 2f
XP18_1_1 o18_1_1 o17_3_1 ph18 ph18 sg13_lv_pmos w=1.12u l=0.13u
XN18_1_1 o18_1_1 o17_3_1 gn18 gn18 sg13_lv_nmos w=0.74u l=0.13u
CL18_1_1 o18_1_1 gn18 2f
XP18_1_2 o18_1_2 o17_3_2 ph18 ph18 sg13_lv_pmos w=1.12u l=0.13u
XN18_1_2 o18_1_2 o17_3_2 gn18 gn18 sg13_lv_nmos w=0.74u l=0.13u
CL18_1_2 o18_1_2 gn18 2f
XP18_1_3 o18_1_3 o17_3_3 ph18 ph18 sg13_lv_pmos w=1.12u l=0.13u
XN18_1_3 o18_1_3 o17_3_3 gn18 gn18 sg13_lv_nmos w=0.74u l=0.13u
CL18_1_3 o18_1_3 gn18 2f
XP18_1_4 o18_1_4 o17_3_4 ph18 ph18 sg13_lv_pmos w=1.12u l=0.13u
XN18_1_4 o18_1_4 o17_3_4 gn18 gn18 sg13_lv_nmos w=0.74u l=0.13u
CL18_1_4 o18_1_4 gn18 2f
XP18_1_5 o18_1_5 o17_3_5 ph18 ph18 sg13_lv_pmos w=1.12u l=0.13u
XN18_1_5 o18_1_5 o17_3_5 gn18 gn18 sg13_lv_nmos w=0.74u l=0.13u
CL18_1_5 o18_1_5 gn18 2f
XP18_1_6 o18_1_6 o17_3_6 ph18 ph18 sg13_lv_pmos w=1.12u l=0.13u
XN18_1_6 o18_1_6 o17_3_6 gn18 gn18 sg13_lv_nmos w=0.74u l=0.13u
CL18_1_6 o18_1_6 gn18 2f
XP18_1_7 o18_1_7 o17_3_7 ph18 ph18 sg13_lv_pmos w=1.12u l=0.13u
XN18_1_7 o18_1_7 o17_3_7 gn18 gn18 sg13_lv_nmos w=0.74u l=0.13u
CL18_1_7 o18_1_7 gn18 2f
XP18_2_0 o18_2_0 o18_1_0 ph18 ph18 sg13_lv_pmos w=1.12u l=0.13u
XN18_2_0 o18_2_0 o18_1_0 gn18 gn18 sg13_lv_nmos w=0.74u l=0.13u
CL18_2_0 o18_2_0 gn18 2f
XP18_2_1 o18_2_1 o18_1_1 ph18 ph18 sg13_lv_pmos w=1.12u l=0.13u
XN18_2_1 o18_2_1 o18_1_1 gn18 gn18 sg13_lv_nmos w=0.74u l=0.13u
CL18_2_1 o18_2_1 gn18 2f
XP18_2_2 o18_2_2 o18_1_2 ph18 ph18 sg13_lv_pmos w=1.12u l=0.13u
XN18_2_2 o18_2_2 o18_1_2 gn18 gn18 sg13_lv_nmos w=0.74u l=0.13u
CL18_2_2 o18_2_2 gn18 2f
XP18_2_3 o18_2_3 o18_1_3 ph18 ph18 sg13_lv_pmos w=1.12u l=0.13u
XN18_2_3 o18_2_3 o18_1_3 gn18 gn18 sg13_lv_nmos w=0.74u l=0.13u
CL18_2_3 o18_2_3 gn18 2f
XP18_2_4 o18_2_4 o18_1_4 ph18 ph18 sg13_lv_pmos w=1.12u l=0.13u
XN18_2_4 o18_2_4 o18_1_4 gn18 gn18 sg13_lv_nmos w=0.74u l=0.13u
CL18_2_4 o18_2_4 gn18 2f
XP18_2_5 o18_2_5 o18_1_5 ph18 ph18 sg13_lv_pmos w=1.12u l=0.13u
XN18_2_5 o18_2_5 o18_1_5 gn18 gn18 sg13_lv_nmos w=0.74u l=0.13u
CL18_2_5 o18_2_5 gn18 2f
XP18_2_6 o18_2_6 o18_1_6 ph18 ph18 sg13_lv_pmos w=1.12u l=0.13u
XN18_2_6 o18_2_6 o18_1_6 gn18 gn18 sg13_lv_nmos w=0.74u l=0.13u
CL18_2_6 o18_2_6 gn18 2f
XP18_2_7 o18_2_7 o18_1_7 ph18 ph18 sg13_lv_pmos w=1.12u l=0.13u
XN18_2_7 o18_2_7 o18_1_7 gn18 gn18 sg13_lv_nmos w=0.74u l=0.13u
CL18_2_7 o18_2_7 gn18 2f
XP18_3_0 o18_3_0 o18_2_0 ph18 ph18 sg13_lv_pmos w=1.12u l=0.13u
XN18_3_0 o18_3_0 o18_2_0 gn18 gn18 sg13_lv_nmos w=0.74u l=0.13u
CL18_3_0 o18_3_0 gn18 2f
XP18_3_1 o18_3_1 o18_2_1 ph18 ph18 sg13_lv_pmos w=1.12u l=0.13u
XN18_3_1 o18_3_1 o18_2_1 gn18 gn18 sg13_lv_nmos w=0.74u l=0.13u
CL18_3_1 o18_3_1 gn18 2f
XP18_3_2 o18_3_2 o18_2_2 ph18 ph18 sg13_lv_pmos w=1.12u l=0.13u
XN18_3_2 o18_3_2 o18_2_2 gn18 gn18 sg13_lv_nmos w=0.74u l=0.13u
CL18_3_2 o18_3_2 gn18 2f
XP18_3_3 o18_3_3 o18_2_3 ph18 ph18 sg13_lv_pmos w=1.12u l=0.13u
XN18_3_3 o18_3_3 o18_2_3 gn18 gn18 sg13_lv_nmos w=0.74u l=0.13u
CL18_3_3 o18_3_3 gn18 2f
XP18_3_4 o18_3_4 o18_2_4 ph18 ph18 sg13_lv_pmos w=1.12u l=0.13u
XN18_3_4 o18_3_4 o18_2_4 gn18 gn18 sg13_lv_nmos w=0.74u l=0.13u
CL18_3_4 o18_3_4 gn18 2f
XP18_3_5 o18_3_5 o18_2_5 ph18 ph18 sg13_lv_pmos w=1.12u l=0.13u
XN18_3_5 o18_3_5 o18_2_5 gn18 gn18 sg13_lv_nmos w=0.74u l=0.13u
CL18_3_5 o18_3_5 gn18 2f
XP18_3_6 o18_3_6 o18_2_6 ph18 ph18 sg13_lv_pmos w=1.12u l=0.13u
XN18_3_6 o18_3_6 o18_2_6 gn18 gn18 sg13_lv_nmos w=0.74u l=0.13u
CL18_3_6 o18_3_6 gn18 2f
XP18_3_7 o18_3_7 o18_2_7 ph18 ph18 sg13_lv_pmos w=1.12u l=0.13u
XN18_3_7 o18_3_7 o18_2_7 gn18 gn18 sg13_lv_nmos w=0.74u l=0.13u
CL18_3_7 o18_3_7 gn18 2f
VI4_0 in4_0 0 PWL(0 1.65 275p 1.65 277p 0 551p 0 553p 1.65 827p 1.65 829p 0 1103p 0 1105p 1.65 1379p 1.65 1381p 0 1655p 0 1657p 1.65 1931p 1.65 1933p 0)
VI4_1 in4_1 0 PWL(0 1.65 275p 1.65 277p 0 551p 0 553p 1.65 827p 1.65 829p 0 1103p 0 1105p 1.65 1379p 1.65 1381p 0 1655p 0 1657p 1.65 1931p 1.65 1933p 0)
VI4_2 in4_2 0 PWL(0 1.65 275p 1.65 277p 0 551p 0 553p 1.65 827p 1.65 829p 0 1103p 0 1105p 1.65 1379p 1.65 1381p 0 1655p 0 1657p 1.65 1931p 1.65 1933p 0)
VI4_3 in4_3 0 PWL(0 0 275p 0 277p 1.65 551p 1.65 553p 0 827p 0 829p 1.65 1103p 1.65 1105p 0 1379p 0 1381p 1.65 1655p 1.65 1657p 0 1931p 0 1933p 1.65)
VI4_4 in4_4 0 PWL(0 1.65 275p 1.65 277p 0 551p 0 553p 1.65 827p 1.65 829p 0 1103p 0 1105p 1.65 1379p 1.65 1381p 0 1655p 0 1657p 1.65 1931p 1.65 1933p 0)
VI4_5 in4_5 0 PWL(0 0 275p 0 277p 1.65 551p 1.65 553p 0 827p 0 829p 1.65 1103p 1.65 1105p 0 1379p 0 1381p 1.65 1655p 1.65 1657p 0 1931p 0 1933p 1.65)
VI4_6 in4_6 0 PWL(0 0 275p 0 277p 1.65 551p 1.65 553p 0 827p 0 829p 1.65 1103p 1.65 1105p 0 1379p 0 1381p 1.65 1655p 1.65 1657p 0 1931p 0 1933p 1.65)
VI4_7 in4_7 0 PWL(0 1.65 275p 1.65 277p 0 551p 0 553p 1.65 827p 1.65 829p 0 1103p 0 1105p 1.65 1379p 1.65 1381p 0 1655p 0 1657p 1.65 1931p 1.65 1933p 0)
VMG19 gn19 0 0
XP19_1_0 o19_1_0 in4_0 ph19 ph19 sg13_lv_pmos w=1.12u l=0.13u
XN19_1_0 o19_1_0 in4_0 gn19 gn19 sg13_lv_nmos w=0.74u l=0.13u
CL19_1_0 o19_1_0 gn19 2f
XP19_1_1 o19_1_1 in4_1 ph19 ph19 sg13_lv_pmos w=1.12u l=0.13u
XN19_1_1 o19_1_1 in4_1 gn19 gn19 sg13_lv_nmos w=0.74u l=0.13u
CL19_1_1 o19_1_1 gn19 2f
XP19_1_2 o19_1_2 in4_2 ph19 ph19 sg13_lv_pmos w=1.12u l=0.13u
XN19_1_2 o19_1_2 in4_2 gn19 gn19 sg13_lv_nmos w=0.74u l=0.13u
CL19_1_2 o19_1_2 gn19 2f
XP19_1_3 o19_1_3 in4_3 ph19 ph19 sg13_lv_pmos w=1.12u l=0.13u
XN19_1_3 o19_1_3 in4_3 gn19 gn19 sg13_lv_nmos w=0.74u l=0.13u
CL19_1_3 o19_1_3 gn19 2f
XP19_1_4 o19_1_4 in4_4 ph19 ph19 sg13_lv_pmos w=1.12u l=0.13u
XN19_1_4 o19_1_4 in4_4 gn19 gn19 sg13_lv_nmos w=0.74u l=0.13u
CL19_1_4 o19_1_4 gn19 2f
XP19_1_5 o19_1_5 in4_5 ph19 ph19 sg13_lv_pmos w=1.12u l=0.13u
XN19_1_5 o19_1_5 in4_5 gn19 gn19 sg13_lv_nmos w=0.74u l=0.13u
CL19_1_5 o19_1_5 gn19 2f
XP19_1_6 o19_1_6 in4_6 ph19 ph19 sg13_lv_pmos w=1.12u l=0.13u
XN19_1_6 o19_1_6 in4_6 gn19 gn19 sg13_lv_nmos w=0.74u l=0.13u
CL19_1_6 o19_1_6 gn19 2f
XP19_1_7 o19_1_7 in4_7 ph19 ph19 sg13_lv_pmos w=1.12u l=0.13u
XN19_1_7 o19_1_7 in4_7 gn19 gn19 sg13_lv_nmos w=0.74u l=0.13u
CL19_1_7 o19_1_7 gn19 2f
XP19_2_0 o19_2_0 o19_1_0 ph19 ph19 sg13_lv_pmos w=1.12u l=0.13u
XN19_2_0 o19_2_0 o19_1_0 gn19 gn19 sg13_lv_nmos w=0.74u l=0.13u
CL19_2_0 o19_2_0 gn19 2f
XP19_2_1 o19_2_1 o19_1_1 ph19 ph19 sg13_lv_pmos w=1.12u l=0.13u
XN19_2_1 o19_2_1 o19_1_1 gn19 gn19 sg13_lv_nmos w=0.74u l=0.13u
CL19_2_1 o19_2_1 gn19 2f
XP19_2_2 o19_2_2 o19_1_2 ph19 ph19 sg13_lv_pmos w=1.12u l=0.13u
XN19_2_2 o19_2_2 o19_1_2 gn19 gn19 sg13_lv_nmos w=0.74u l=0.13u
CL19_2_2 o19_2_2 gn19 2f
XP19_2_3 o19_2_3 o19_1_3 ph19 ph19 sg13_lv_pmos w=1.12u l=0.13u
XN19_2_3 o19_2_3 o19_1_3 gn19 gn19 sg13_lv_nmos w=0.74u l=0.13u
CL19_2_3 o19_2_3 gn19 2f
XP19_2_4 o19_2_4 o19_1_4 ph19 ph19 sg13_lv_pmos w=1.12u l=0.13u
XN19_2_4 o19_2_4 o19_1_4 gn19 gn19 sg13_lv_nmos w=0.74u l=0.13u
CL19_2_4 o19_2_4 gn19 2f
XP19_2_5 o19_2_5 o19_1_5 ph19 ph19 sg13_lv_pmos w=1.12u l=0.13u
XN19_2_5 o19_2_5 o19_1_5 gn19 gn19 sg13_lv_nmos w=0.74u l=0.13u
CL19_2_5 o19_2_5 gn19 2f
XP19_2_6 o19_2_6 o19_1_6 ph19 ph19 sg13_lv_pmos w=1.12u l=0.13u
XN19_2_6 o19_2_6 o19_1_6 gn19 gn19 sg13_lv_nmos w=0.74u l=0.13u
CL19_2_6 o19_2_6 gn19 2f
XP19_2_7 o19_2_7 o19_1_7 ph19 ph19 sg13_lv_pmos w=1.12u l=0.13u
XN19_2_7 o19_2_7 o19_1_7 gn19 gn19 sg13_lv_nmos w=0.74u l=0.13u
CL19_2_7 o19_2_7 gn19 2f
XP19_3_0 o19_3_0 o19_2_0 ph19 ph19 sg13_lv_pmos w=1.12u l=0.13u
XN19_3_0 o19_3_0 o19_2_0 gn19 gn19 sg13_lv_nmos w=0.74u l=0.13u
CL19_3_0 o19_3_0 gn19 2f
XP19_3_1 o19_3_1 o19_2_1 ph19 ph19 sg13_lv_pmos w=1.12u l=0.13u
XN19_3_1 o19_3_1 o19_2_1 gn19 gn19 sg13_lv_nmos w=0.74u l=0.13u
CL19_3_1 o19_3_1 gn19 2f
XP19_3_2 o19_3_2 o19_2_2 ph19 ph19 sg13_lv_pmos w=1.12u l=0.13u
XN19_3_2 o19_3_2 o19_2_2 gn19 gn19 sg13_lv_nmos w=0.74u l=0.13u
CL19_3_2 o19_3_2 gn19 2f
XP19_3_3 o19_3_3 o19_2_3 ph19 ph19 sg13_lv_pmos w=1.12u l=0.13u
XN19_3_3 o19_3_3 o19_2_3 gn19 gn19 sg13_lv_nmos w=0.74u l=0.13u
CL19_3_3 o19_3_3 gn19 2f
XP19_3_4 o19_3_4 o19_2_4 ph19 ph19 sg13_lv_pmos w=1.12u l=0.13u
XN19_3_4 o19_3_4 o19_2_4 gn19 gn19 sg13_lv_nmos w=0.74u l=0.13u
CL19_3_4 o19_3_4 gn19 2f
XP19_3_5 o19_3_5 o19_2_5 ph19 ph19 sg13_lv_pmos w=1.12u l=0.13u
XN19_3_5 o19_3_5 o19_2_5 gn19 gn19 sg13_lv_nmos w=0.74u l=0.13u
CL19_3_5 o19_3_5 gn19 2f
XP19_3_6 o19_3_6 o19_2_6 ph19 ph19 sg13_lv_pmos w=1.12u l=0.13u
XN19_3_6 o19_3_6 o19_2_6 gn19 gn19 sg13_lv_nmos w=0.74u l=0.13u
CL19_3_6 o19_3_6 gn19 2f
XP19_3_7 o19_3_7 o19_2_7 ph19 ph19 sg13_lv_pmos w=1.12u l=0.13u
XN19_3_7 o19_3_7 o19_2_7 gn19 gn19 sg13_lv_nmos w=0.74u l=0.13u
CL19_3_7 o19_3_7 gn19 2f
VMG20 gn20 0 0
XP20_1_0 o20_1_0 o19_3_0 ph20 ph20 sg13_lv_pmos w=1.12u l=0.13u
XN20_1_0 o20_1_0 o19_3_0 gn20 gn20 sg13_lv_nmos w=0.74u l=0.13u
CL20_1_0 o20_1_0 gn20 2f
XP20_1_1 o20_1_1 o19_3_1 ph20 ph20 sg13_lv_pmos w=1.12u l=0.13u
XN20_1_1 o20_1_1 o19_3_1 gn20 gn20 sg13_lv_nmos w=0.74u l=0.13u
CL20_1_1 o20_1_1 gn20 2f
XP20_1_2 o20_1_2 o19_3_2 ph20 ph20 sg13_lv_pmos w=1.12u l=0.13u
XN20_1_2 o20_1_2 o19_3_2 gn20 gn20 sg13_lv_nmos w=0.74u l=0.13u
CL20_1_2 o20_1_2 gn20 2f
XP20_1_3 o20_1_3 o19_3_3 ph20 ph20 sg13_lv_pmos w=1.12u l=0.13u
XN20_1_3 o20_1_3 o19_3_3 gn20 gn20 sg13_lv_nmos w=0.74u l=0.13u
CL20_1_3 o20_1_3 gn20 2f
XP20_1_4 o20_1_4 o19_3_4 ph20 ph20 sg13_lv_pmos w=1.12u l=0.13u
XN20_1_4 o20_1_4 o19_3_4 gn20 gn20 sg13_lv_nmos w=0.74u l=0.13u
CL20_1_4 o20_1_4 gn20 2f
XP20_1_5 o20_1_5 o19_3_5 ph20 ph20 sg13_lv_pmos w=1.12u l=0.13u
XN20_1_5 o20_1_5 o19_3_5 gn20 gn20 sg13_lv_nmos w=0.74u l=0.13u
CL20_1_5 o20_1_5 gn20 2f
XP20_1_6 o20_1_6 o19_3_6 ph20 ph20 sg13_lv_pmos w=1.12u l=0.13u
XN20_1_6 o20_1_6 o19_3_6 gn20 gn20 sg13_lv_nmos w=0.74u l=0.13u
CL20_1_6 o20_1_6 gn20 2f
XP20_1_7 o20_1_7 o19_3_7 ph20 ph20 sg13_lv_pmos w=1.12u l=0.13u
XN20_1_7 o20_1_7 o19_3_7 gn20 gn20 sg13_lv_nmos w=0.74u l=0.13u
CL20_1_7 o20_1_7 gn20 2f
XP20_2_0 o20_2_0 o20_1_0 ph20 ph20 sg13_lv_pmos w=1.12u l=0.13u
XN20_2_0 o20_2_0 o20_1_0 gn20 gn20 sg13_lv_nmos w=0.74u l=0.13u
CL20_2_0 o20_2_0 gn20 2f
XP20_2_1 o20_2_1 o20_1_1 ph20 ph20 sg13_lv_pmos w=1.12u l=0.13u
XN20_2_1 o20_2_1 o20_1_1 gn20 gn20 sg13_lv_nmos w=0.74u l=0.13u
CL20_2_1 o20_2_1 gn20 2f
XP20_2_2 o20_2_2 o20_1_2 ph20 ph20 sg13_lv_pmos w=1.12u l=0.13u
XN20_2_2 o20_2_2 o20_1_2 gn20 gn20 sg13_lv_nmos w=0.74u l=0.13u
CL20_2_2 o20_2_2 gn20 2f
XP20_2_3 o20_2_3 o20_1_3 ph20 ph20 sg13_lv_pmos w=1.12u l=0.13u
XN20_2_3 o20_2_3 o20_1_3 gn20 gn20 sg13_lv_nmos w=0.74u l=0.13u
CL20_2_3 o20_2_3 gn20 2f
XP20_2_4 o20_2_4 o20_1_4 ph20 ph20 sg13_lv_pmos w=1.12u l=0.13u
XN20_2_4 o20_2_4 o20_1_4 gn20 gn20 sg13_lv_nmos w=0.74u l=0.13u
CL20_2_4 o20_2_4 gn20 2f
XP20_2_5 o20_2_5 o20_1_5 ph20 ph20 sg13_lv_pmos w=1.12u l=0.13u
XN20_2_5 o20_2_5 o20_1_5 gn20 gn20 sg13_lv_nmos w=0.74u l=0.13u
CL20_2_5 o20_2_5 gn20 2f
XP20_2_6 o20_2_6 o20_1_6 ph20 ph20 sg13_lv_pmos w=1.12u l=0.13u
XN20_2_6 o20_2_6 o20_1_6 gn20 gn20 sg13_lv_nmos w=0.74u l=0.13u
CL20_2_6 o20_2_6 gn20 2f
XP20_2_7 o20_2_7 o20_1_7 ph20 ph20 sg13_lv_pmos w=1.12u l=0.13u
XN20_2_7 o20_2_7 o20_1_7 gn20 gn20 sg13_lv_nmos w=0.74u l=0.13u
CL20_2_7 o20_2_7 gn20 2f
XP20_3_0 o20_3_0 o20_2_0 ph20 ph20 sg13_lv_pmos w=1.12u l=0.13u
XN20_3_0 o20_3_0 o20_2_0 gn20 gn20 sg13_lv_nmos w=0.74u l=0.13u
CL20_3_0 o20_3_0 gn20 2f
XP20_3_1 o20_3_1 o20_2_1 ph20 ph20 sg13_lv_pmos w=1.12u l=0.13u
XN20_3_1 o20_3_1 o20_2_1 gn20 gn20 sg13_lv_nmos w=0.74u l=0.13u
CL20_3_1 o20_3_1 gn20 2f
XP20_3_2 o20_3_2 o20_2_2 ph20 ph20 sg13_lv_pmos w=1.12u l=0.13u
XN20_3_2 o20_3_2 o20_2_2 gn20 gn20 sg13_lv_nmos w=0.74u l=0.13u
CL20_3_2 o20_3_2 gn20 2f
XP20_3_3 o20_3_3 o20_2_3 ph20 ph20 sg13_lv_pmos w=1.12u l=0.13u
XN20_3_3 o20_3_3 o20_2_3 gn20 gn20 sg13_lv_nmos w=0.74u l=0.13u
CL20_3_3 o20_3_3 gn20 2f
XP20_3_4 o20_3_4 o20_2_4 ph20 ph20 sg13_lv_pmos w=1.12u l=0.13u
XN20_3_4 o20_3_4 o20_2_4 gn20 gn20 sg13_lv_nmos w=0.74u l=0.13u
CL20_3_4 o20_3_4 gn20 2f
XP20_3_5 o20_3_5 o20_2_5 ph20 ph20 sg13_lv_pmos w=1.12u l=0.13u
XN20_3_5 o20_3_5 o20_2_5 gn20 gn20 sg13_lv_nmos w=0.74u l=0.13u
CL20_3_5 o20_3_5 gn20 2f
XP20_3_6 o20_3_6 o20_2_6 ph20 ph20 sg13_lv_pmos w=1.12u l=0.13u
XN20_3_6 o20_3_6 o20_2_6 gn20 gn20 sg13_lv_nmos w=0.74u l=0.13u
CL20_3_6 o20_3_6 gn20 2f
XP20_3_7 o20_3_7 o20_2_7 ph20 ph20 sg13_lv_pmos w=1.12u l=0.13u
XN20_3_7 o20_3_7 o20_2_7 gn20 gn20 sg13_lv_nmos w=0.74u l=0.13u
CL20_3_7 o20_3_7 gn20 2f
VMG21 gn21 0 0
XP21_1_0 o21_1_0 o20_3_0 ph21 ph21 sg13_lv_pmos w=1.12u l=0.13u
XN21_1_0 o21_1_0 o20_3_0 gn21 gn21 sg13_lv_nmos w=0.74u l=0.13u
CL21_1_0 o21_1_0 gn21 2f
XP21_1_1 o21_1_1 o20_3_1 ph21 ph21 sg13_lv_pmos w=1.12u l=0.13u
XN21_1_1 o21_1_1 o20_3_1 gn21 gn21 sg13_lv_nmos w=0.74u l=0.13u
CL21_1_1 o21_1_1 gn21 2f
XP21_1_2 o21_1_2 o20_3_2 ph21 ph21 sg13_lv_pmos w=1.12u l=0.13u
XN21_1_2 o21_1_2 o20_3_2 gn21 gn21 sg13_lv_nmos w=0.74u l=0.13u
CL21_1_2 o21_1_2 gn21 2f
XP21_1_3 o21_1_3 o20_3_3 ph21 ph21 sg13_lv_pmos w=1.12u l=0.13u
XN21_1_3 o21_1_3 o20_3_3 gn21 gn21 sg13_lv_nmos w=0.74u l=0.13u
CL21_1_3 o21_1_3 gn21 2f
XP21_1_4 o21_1_4 o20_3_4 ph21 ph21 sg13_lv_pmos w=1.12u l=0.13u
XN21_1_4 o21_1_4 o20_3_4 gn21 gn21 sg13_lv_nmos w=0.74u l=0.13u
CL21_1_4 o21_1_4 gn21 2f
XP21_1_5 o21_1_5 o20_3_5 ph21 ph21 sg13_lv_pmos w=1.12u l=0.13u
XN21_1_5 o21_1_5 o20_3_5 gn21 gn21 sg13_lv_nmos w=0.74u l=0.13u
CL21_1_5 o21_1_5 gn21 2f
XP21_1_6 o21_1_6 o20_3_6 ph21 ph21 sg13_lv_pmos w=1.12u l=0.13u
XN21_1_6 o21_1_6 o20_3_6 gn21 gn21 sg13_lv_nmos w=0.74u l=0.13u
CL21_1_6 o21_1_6 gn21 2f
XP21_1_7 o21_1_7 o20_3_7 ph21 ph21 sg13_lv_pmos w=1.12u l=0.13u
XN21_1_7 o21_1_7 o20_3_7 gn21 gn21 sg13_lv_nmos w=0.74u l=0.13u
CL21_1_7 o21_1_7 gn21 2f
XP21_2_0 o21_2_0 o21_1_0 ph21 ph21 sg13_lv_pmos w=1.12u l=0.13u
XN21_2_0 o21_2_0 o21_1_0 gn21 gn21 sg13_lv_nmos w=0.74u l=0.13u
CL21_2_0 o21_2_0 gn21 2f
XP21_2_1 o21_2_1 o21_1_1 ph21 ph21 sg13_lv_pmos w=1.12u l=0.13u
XN21_2_1 o21_2_1 o21_1_1 gn21 gn21 sg13_lv_nmos w=0.74u l=0.13u
CL21_2_1 o21_2_1 gn21 2f
XP21_2_2 o21_2_2 o21_1_2 ph21 ph21 sg13_lv_pmos w=1.12u l=0.13u
XN21_2_2 o21_2_2 o21_1_2 gn21 gn21 sg13_lv_nmos w=0.74u l=0.13u
CL21_2_2 o21_2_2 gn21 2f
XP21_2_3 o21_2_3 o21_1_3 ph21 ph21 sg13_lv_pmos w=1.12u l=0.13u
XN21_2_3 o21_2_3 o21_1_3 gn21 gn21 sg13_lv_nmos w=0.74u l=0.13u
CL21_2_3 o21_2_3 gn21 2f
XP21_2_4 o21_2_4 o21_1_4 ph21 ph21 sg13_lv_pmos w=1.12u l=0.13u
XN21_2_4 o21_2_4 o21_1_4 gn21 gn21 sg13_lv_nmos w=0.74u l=0.13u
CL21_2_4 o21_2_4 gn21 2f
XP21_2_5 o21_2_5 o21_1_5 ph21 ph21 sg13_lv_pmos w=1.12u l=0.13u
XN21_2_5 o21_2_5 o21_1_5 gn21 gn21 sg13_lv_nmos w=0.74u l=0.13u
CL21_2_5 o21_2_5 gn21 2f
XP21_2_6 o21_2_6 o21_1_6 ph21 ph21 sg13_lv_pmos w=1.12u l=0.13u
XN21_2_6 o21_2_6 o21_1_6 gn21 gn21 sg13_lv_nmos w=0.74u l=0.13u
CL21_2_6 o21_2_6 gn21 2f
XP21_2_7 o21_2_7 o21_1_7 ph21 ph21 sg13_lv_pmos w=1.12u l=0.13u
XN21_2_7 o21_2_7 o21_1_7 gn21 gn21 sg13_lv_nmos w=0.74u l=0.13u
CL21_2_7 o21_2_7 gn21 2f
XP21_3_0 o21_3_0 o21_2_0 ph21 ph21 sg13_lv_pmos w=1.12u l=0.13u
XN21_3_0 o21_3_0 o21_2_0 gn21 gn21 sg13_lv_nmos w=0.74u l=0.13u
CL21_3_0 o21_3_0 gn21 2f
XP21_3_1 o21_3_1 o21_2_1 ph21 ph21 sg13_lv_pmos w=1.12u l=0.13u
XN21_3_1 o21_3_1 o21_2_1 gn21 gn21 sg13_lv_nmos w=0.74u l=0.13u
CL21_3_1 o21_3_1 gn21 2f
XP21_3_2 o21_3_2 o21_2_2 ph21 ph21 sg13_lv_pmos w=1.12u l=0.13u
XN21_3_2 o21_3_2 o21_2_2 gn21 gn21 sg13_lv_nmos w=0.74u l=0.13u
CL21_3_2 o21_3_2 gn21 2f
XP21_3_3 o21_3_3 o21_2_3 ph21 ph21 sg13_lv_pmos w=1.12u l=0.13u
XN21_3_3 o21_3_3 o21_2_3 gn21 gn21 sg13_lv_nmos w=0.74u l=0.13u
CL21_3_3 o21_3_3 gn21 2f
XP21_3_4 o21_3_4 o21_2_4 ph21 ph21 sg13_lv_pmos w=1.12u l=0.13u
XN21_3_4 o21_3_4 o21_2_4 gn21 gn21 sg13_lv_nmos w=0.74u l=0.13u
CL21_3_4 o21_3_4 gn21 2f
XP21_3_5 o21_3_5 o21_2_5 ph21 ph21 sg13_lv_pmos w=1.12u l=0.13u
XN21_3_5 o21_3_5 o21_2_5 gn21 gn21 sg13_lv_nmos w=0.74u l=0.13u
CL21_3_5 o21_3_5 gn21 2f
XP21_3_6 o21_3_6 o21_2_6 ph21 ph21 sg13_lv_pmos w=1.12u l=0.13u
XN21_3_6 o21_3_6 o21_2_6 gn21 gn21 sg13_lv_nmos w=0.74u l=0.13u
CL21_3_6 o21_3_6 gn21 2f
XP21_3_7 o21_3_7 o21_2_7 ph21 ph21 sg13_lv_pmos w=1.12u l=0.13u
XN21_3_7 o21_3_7 o21_2_7 gn21 gn21 sg13_lv_nmos w=0.74u l=0.13u
CL21_3_7 o21_3_7 gn21 2f
VMG22 gn22 0 0
XP22_1_0 o22_1_0 o21_3_0 ph22 ph22 sg13_lv_pmos w=1.12u l=0.13u
XN22_1_0 o22_1_0 o21_3_0 gn22 gn22 sg13_lv_nmos w=0.74u l=0.13u
CL22_1_0 o22_1_0 gn22 2f
XP22_1_1 o22_1_1 o21_3_1 ph22 ph22 sg13_lv_pmos w=1.12u l=0.13u
XN22_1_1 o22_1_1 o21_3_1 gn22 gn22 sg13_lv_nmos w=0.74u l=0.13u
CL22_1_1 o22_1_1 gn22 2f
XP22_1_2 o22_1_2 o21_3_2 ph22 ph22 sg13_lv_pmos w=1.12u l=0.13u
XN22_1_2 o22_1_2 o21_3_2 gn22 gn22 sg13_lv_nmos w=0.74u l=0.13u
CL22_1_2 o22_1_2 gn22 2f
XP22_1_3 o22_1_3 o21_3_3 ph22 ph22 sg13_lv_pmos w=1.12u l=0.13u
XN22_1_3 o22_1_3 o21_3_3 gn22 gn22 sg13_lv_nmos w=0.74u l=0.13u
CL22_1_3 o22_1_3 gn22 2f
XP22_1_4 o22_1_4 o21_3_4 ph22 ph22 sg13_lv_pmos w=1.12u l=0.13u
XN22_1_4 o22_1_4 o21_3_4 gn22 gn22 sg13_lv_nmos w=0.74u l=0.13u
CL22_1_4 o22_1_4 gn22 2f
XP22_1_5 o22_1_5 o21_3_5 ph22 ph22 sg13_lv_pmos w=1.12u l=0.13u
XN22_1_5 o22_1_5 o21_3_5 gn22 gn22 sg13_lv_nmos w=0.74u l=0.13u
CL22_1_5 o22_1_5 gn22 2f
XP22_1_6 o22_1_6 o21_3_6 ph22 ph22 sg13_lv_pmos w=1.12u l=0.13u
XN22_1_6 o22_1_6 o21_3_6 gn22 gn22 sg13_lv_nmos w=0.74u l=0.13u
CL22_1_6 o22_1_6 gn22 2f
XP22_1_7 o22_1_7 o21_3_7 ph22 ph22 sg13_lv_pmos w=1.12u l=0.13u
XN22_1_7 o22_1_7 o21_3_7 gn22 gn22 sg13_lv_nmos w=0.74u l=0.13u
CL22_1_7 o22_1_7 gn22 2f
XP22_2_0 o22_2_0 o22_1_0 ph22 ph22 sg13_lv_pmos w=1.12u l=0.13u
XN22_2_0 o22_2_0 o22_1_0 gn22 gn22 sg13_lv_nmos w=0.74u l=0.13u
CL22_2_0 o22_2_0 gn22 2f
XP22_2_1 o22_2_1 o22_1_1 ph22 ph22 sg13_lv_pmos w=1.12u l=0.13u
XN22_2_1 o22_2_1 o22_1_1 gn22 gn22 sg13_lv_nmos w=0.74u l=0.13u
CL22_2_1 o22_2_1 gn22 2f
XP22_2_2 o22_2_2 o22_1_2 ph22 ph22 sg13_lv_pmos w=1.12u l=0.13u
XN22_2_2 o22_2_2 o22_1_2 gn22 gn22 sg13_lv_nmos w=0.74u l=0.13u
CL22_2_2 o22_2_2 gn22 2f
XP22_2_3 o22_2_3 o22_1_3 ph22 ph22 sg13_lv_pmos w=1.12u l=0.13u
XN22_2_3 o22_2_3 o22_1_3 gn22 gn22 sg13_lv_nmos w=0.74u l=0.13u
CL22_2_3 o22_2_3 gn22 2f
XP22_2_4 o22_2_4 o22_1_4 ph22 ph22 sg13_lv_pmos w=1.12u l=0.13u
XN22_2_4 o22_2_4 o22_1_4 gn22 gn22 sg13_lv_nmos w=0.74u l=0.13u
CL22_2_4 o22_2_4 gn22 2f
XP22_2_5 o22_2_5 o22_1_5 ph22 ph22 sg13_lv_pmos w=1.12u l=0.13u
XN22_2_5 o22_2_5 o22_1_5 gn22 gn22 sg13_lv_nmos w=0.74u l=0.13u
CL22_2_5 o22_2_5 gn22 2f
XP22_2_6 o22_2_6 o22_1_6 ph22 ph22 sg13_lv_pmos w=1.12u l=0.13u
XN22_2_6 o22_2_6 o22_1_6 gn22 gn22 sg13_lv_nmos w=0.74u l=0.13u
CL22_2_6 o22_2_6 gn22 2f
XP22_2_7 o22_2_7 o22_1_7 ph22 ph22 sg13_lv_pmos w=1.12u l=0.13u
XN22_2_7 o22_2_7 o22_1_7 gn22 gn22 sg13_lv_nmos w=0.74u l=0.13u
CL22_2_7 o22_2_7 gn22 2f
XP22_3_0 o22_3_0 o22_2_0 ph22 ph22 sg13_lv_pmos w=1.12u l=0.13u
XN22_3_0 o22_3_0 o22_2_0 gn22 gn22 sg13_lv_nmos w=0.74u l=0.13u
CL22_3_0 o22_3_0 gn22 2f
XP22_3_1 o22_3_1 o22_2_1 ph22 ph22 sg13_lv_pmos w=1.12u l=0.13u
XN22_3_1 o22_3_1 o22_2_1 gn22 gn22 sg13_lv_nmos w=0.74u l=0.13u
CL22_3_1 o22_3_1 gn22 2f
XP22_3_2 o22_3_2 o22_2_2 ph22 ph22 sg13_lv_pmos w=1.12u l=0.13u
XN22_3_2 o22_3_2 o22_2_2 gn22 gn22 sg13_lv_nmos w=0.74u l=0.13u
CL22_3_2 o22_3_2 gn22 2f
XP22_3_3 o22_3_3 o22_2_3 ph22 ph22 sg13_lv_pmos w=1.12u l=0.13u
XN22_3_3 o22_3_3 o22_2_3 gn22 gn22 sg13_lv_nmos w=0.74u l=0.13u
CL22_3_3 o22_3_3 gn22 2f
XP22_3_4 o22_3_4 o22_2_4 ph22 ph22 sg13_lv_pmos w=1.12u l=0.13u
XN22_3_4 o22_3_4 o22_2_4 gn22 gn22 sg13_lv_nmos w=0.74u l=0.13u
CL22_3_4 o22_3_4 gn22 2f
XP22_3_5 o22_3_5 o22_2_5 ph22 ph22 sg13_lv_pmos w=1.12u l=0.13u
XN22_3_5 o22_3_5 o22_2_5 gn22 gn22 sg13_lv_nmos w=0.74u l=0.13u
CL22_3_5 o22_3_5 gn22 2f
XP22_3_6 o22_3_6 o22_2_6 ph22 ph22 sg13_lv_pmos w=1.12u l=0.13u
XN22_3_6 o22_3_6 o22_2_6 gn22 gn22 sg13_lv_nmos w=0.74u l=0.13u
CL22_3_6 o22_3_6 gn22 2f
XP22_3_7 o22_3_7 o22_2_7 ph22 ph22 sg13_lv_pmos w=1.12u l=0.13u
XN22_3_7 o22_3_7 o22_2_7 gn22 gn22 sg13_lv_nmos w=0.74u l=0.13u
CL22_3_7 o22_3_7 gn22 2f
VMG23 gn23 0 0
XP23_1_0 o23_1_0 o22_3_0 ph23 ph23 sg13_lv_pmos w=1.12u l=0.13u
XN23_1_0 o23_1_0 o22_3_0 gn23 gn23 sg13_lv_nmos w=0.74u l=0.13u
CL23_1_0 o23_1_0 gn23 2f
XP23_1_1 o23_1_1 o22_3_1 ph23 ph23 sg13_lv_pmos w=1.12u l=0.13u
XN23_1_1 o23_1_1 o22_3_1 gn23 gn23 sg13_lv_nmos w=0.74u l=0.13u
CL23_1_1 o23_1_1 gn23 2f
XP23_1_2 o23_1_2 o22_3_2 ph23 ph23 sg13_lv_pmos w=1.12u l=0.13u
XN23_1_2 o23_1_2 o22_3_2 gn23 gn23 sg13_lv_nmos w=0.74u l=0.13u
CL23_1_2 o23_1_2 gn23 2f
XP23_1_3 o23_1_3 o22_3_3 ph23 ph23 sg13_lv_pmos w=1.12u l=0.13u
XN23_1_3 o23_1_3 o22_3_3 gn23 gn23 sg13_lv_nmos w=0.74u l=0.13u
CL23_1_3 o23_1_3 gn23 2f
XP23_1_4 o23_1_4 o22_3_4 ph23 ph23 sg13_lv_pmos w=1.12u l=0.13u
XN23_1_4 o23_1_4 o22_3_4 gn23 gn23 sg13_lv_nmos w=0.74u l=0.13u
CL23_1_4 o23_1_4 gn23 2f
XP23_1_5 o23_1_5 o22_3_5 ph23 ph23 sg13_lv_pmos w=1.12u l=0.13u
XN23_1_5 o23_1_5 o22_3_5 gn23 gn23 sg13_lv_nmos w=0.74u l=0.13u
CL23_1_5 o23_1_5 gn23 2f
XP23_1_6 o23_1_6 o22_3_6 ph23 ph23 sg13_lv_pmos w=1.12u l=0.13u
XN23_1_6 o23_1_6 o22_3_6 gn23 gn23 sg13_lv_nmos w=0.74u l=0.13u
CL23_1_6 o23_1_6 gn23 2f
XP23_1_7 o23_1_7 o22_3_7 ph23 ph23 sg13_lv_pmos w=1.12u l=0.13u
XN23_1_7 o23_1_7 o22_3_7 gn23 gn23 sg13_lv_nmos w=0.74u l=0.13u
CL23_1_7 o23_1_7 gn23 2f
XP23_2_0 o23_2_0 o23_1_0 ph23 ph23 sg13_lv_pmos w=1.12u l=0.13u
XN23_2_0 o23_2_0 o23_1_0 gn23 gn23 sg13_lv_nmos w=0.74u l=0.13u
CL23_2_0 o23_2_0 gn23 2f
XP23_2_1 o23_2_1 o23_1_1 ph23 ph23 sg13_lv_pmos w=1.12u l=0.13u
XN23_2_1 o23_2_1 o23_1_1 gn23 gn23 sg13_lv_nmos w=0.74u l=0.13u
CL23_2_1 o23_2_1 gn23 2f
XP23_2_2 o23_2_2 o23_1_2 ph23 ph23 sg13_lv_pmos w=1.12u l=0.13u
XN23_2_2 o23_2_2 o23_1_2 gn23 gn23 sg13_lv_nmos w=0.74u l=0.13u
CL23_2_2 o23_2_2 gn23 2f
XP23_2_3 o23_2_3 o23_1_3 ph23 ph23 sg13_lv_pmos w=1.12u l=0.13u
XN23_2_3 o23_2_3 o23_1_3 gn23 gn23 sg13_lv_nmos w=0.74u l=0.13u
CL23_2_3 o23_2_3 gn23 2f
XP23_2_4 o23_2_4 o23_1_4 ph23 ph23 sg13_lv_pmos w=1.12u l=0.13u
XN23_2_4 o23_2_4 o23_1_4 gn23 gn23 sg13_lv_nmos w=0.74u l=0.13u
CL23_2_4 o23_2_4 gn23 2f
XP23_2_5 o23_2_5 o23_1_5 ph23 ph23 sg13_lv_pmos w=1.12u l=0.13u
XN23_2_5 o23_2_5 o23_1_5 gn23 gn23 sg13_lv_nmos w=0.74u l=0.13u
CL23_2_5 o23_2_5 gn23 2f
XP23_2_6 o23_2_6 o23_1_6 ph23 ph23 sg13_lv_pmos w=1.12u l=0.13u
XN23_2_6 o23_2_6 o23_1_6 gn23 gn23 sg13_lv_nmos w=0.74u l=0.13u
CL23_2_6 o23_2_6 gn23 2f
XP23_2_7 o23_2_7 o23_1_7 ph23 ph23 sg13_lv_pmos w=1.12u l=0.13u
XN23_2_7 o23_2_7 o23_1_7 gn23 gn23 sg13_lv_nmos w=0.74u l=0.13u
CL23_2_7 o23_2_7 gn23 2f
XP23_3_0 o23_3_0 o23_2_0 ph23 ph23 sg13_lv_pmos w=1.12u l=0.13u
XN23_3_0 o23_3_0 o23_2_0 gn23 gn23 sg13_lv_nmos w=0.74u l=0.13u
CL23_3_0 o23_3_0 gn23 2f
XP23_3_1 o23_3_1 o23_2_1 ph23 ph23 sg13_lv_pmos w=1.12u l=0.13u
XN23_3_1 o23_3_1 o23_2_1 gn23 gn23 sg13_lv_nmos w=0.74u l=0.13u
CL23_3_1 o23_3_1 gn23 2f
XP23_3_2 o23_3_2 o23_2_2 ph23 ph23 sg13_lv_pmos w=1.12u l=0.13u
XN23_3_2 o23_3_2 o23_2_2 gn23 gn23 sg13_lv_nmos w=0.74u l=0.13u
CL23_3_2 o23_3_2 gn23 2f
XP23_3_3 o23_3_3 o23_2_3 ph23 ph23 sg13_lv_pmos w=1.12u l=0.13u
XN23_3_3 o23_3_3 o23_2_3 gn23 gn23 sg13_lv_nmos w=0.74u l=0.13u
CL23_3_3 o23_3_3 gn23 2f
XP23_3_4 o23_3_4 o23_2_4 ph23 ph23 sg13_lv_pmos w=1.12u l=0.13u
XN23_3_4 o23_3_4 o23_2_4 gn23 gn23 sg13_lv_nmos w=0.74u l=0.13u
CL23_3_4 o23_3_4 gn23 2f
XP23_3_5 o23_3_5 o23_2_5 ph23 ph23 sg13_lv_pmos w=1.12u l=0.13u
XN23_3_5 o23_3_5 o23_2_5 gn23 gn23 sg13_lv_nmos w=0.74u l=0.13u
CL23_3_5 o23_3_5 gn23 2f
XP23_3_6 o23_3_6 o23_2_6 ph23 ph23 sg13_lv_pmos w=1.12u l=0.13u
XN23_3_6 o23_3_6 o23_2_6 gn23 gn23 sg13_lv_nmos w=0.74u l=0.13u
CL23_3_6 o23_3_6 gn23 2f
XP23_3_7 o23_3_7 o23_2_7 ph23 ph23 sg13_lv_pmos w=1.12u l=0.13u
XN23_3_7 o23_3_7 o23_2_7 gn23 gn23 sg13_lv_nmos w=0.74u l=0.13u
CL23_3_7 o23_3_7 gn23 2f
VMG24 gn24 0 0
XP24_1_0 o24_1_0 o23_3_0 ph24 ph24 sg13_lv_pmos w=1.12u l=0.13u
XN24_1_0 o24_1_0 o23_3_0 gn24 gn24 sg13_lv_nmos w=0.74u l=0.13u
CL24_1_0 o24_1_0 gn24 2f
XP24_1_1 o24_1_1 o23_3_1 ph24 ph24 sg13_lv_pmos w=1.12u l=0.13u
XN24_1_1 o24_1_1 o23_3_1 gn24 gn24 sg13_lv_nmos w=0.74u l=0.13u
CL24_1_1 o24_1_1 gn24 2f
XP24_1_2 o24_1_2 o23_3_2 ph24 ph24 sg13_lv_pmos w=1.12u l=0.13u
XN24_1_2 o24_1_2 o23_3_2 gn24 gn24 sg13_lv_nmos w=0.74u l=0.13u
CL24_1_2 o24_1_2 gn24 2f
XP24_1_3 o24_1_3 o23_3_3 ph24 ph24 sg13_lv_pmos w=1.12u l=0.13u
XN24_1_3 o24_1_3 o23_3_3 gn24 gn24 sg13_lv_nmos w=0.74u l=0.13u
CL24_1_3 o24_1_3 gn24 2f
XP24_1_4 o24_1_4 o23_3_4 ph24 ph24 sg13_lv_pmos w=1.12u l=0.13u
XN24_1_4 o24_1_4 o23_3_4 gn24 gn24 sg13_lv_nmos w=0.74u l=0.13u
CL24_1_4 o24_1_4 gn24 2f
XP24_1_5 o24_1_5 o23_3_5 ph24 ph24 sg13_lv_pmos w=1.12u l=0.13u
XN24_1_5 o24_1_5 o23_3_5 gn24 gn24 sg13_lv_nmos w=0.74u l=0.13u
CL24_1_5 o24_1_5 gn24 2f
XP24_1_6 o24_1_6 o23_3_6 ph24 ph24 sg13_lv_pmos w=1.12u l=0.13u
XN24_1_6 o24_1_6 o23_3_6 gn24 gn24 sg13_lv_nmos w=0.74u l=0.13u
CL24_1_6 o24_1_6 gn24 2f
XP24_1_7 o24_1_7 o23_3_7 ph24 ph24 sg13_lv_pmos w=1.12u l=0.13u
XN24_1_7 o24_1_7 o23_3_7 gn24 gn24 sg13_lv_nmos w=0.74u l=0.13u
CL24_1_7 o24_1_7 gn24 2f
XP24_2_0 o24_2_0 o24_1_0 ph24 ph24 sg13_lv_pmos w=1.12u l=0.13u
XN24_2_0 o24_2_0 o24_1_0 gn24 gn24 sg13_lv_nmos w=0.74u l=0.13u
CL24_2_0 o24_2_0 gn24 2f
XP24_2_1 o24_2_1 o24_1_1 ph24 ph24 sg13_lv_pmos w=1.12u l=0.13u
XN24_2_1 o24_2_1 o24_1_1 gn24 gn24 sg13_lv_nmos w=0.74u l=0.13u
CL24_2_1 o24_2_1 gn24 2f
XP24_2_2 o24_2_2 o24_1_2 ph24 ph24 sg13_lv_pmos w=1.12u l=0.13u
XN24_2_2 o24_2_2 o24_1_2 gn24 gn24 sg13_lv_nmos w=0.74u l=0.13u
CL24_2_2 o24_2_2 gn24 2f
XP24_2_3 o24_2_3 o24_1_3 ph24 ph24 sg13_lv_pmos w=1.12u l=0.13u
XN24_2_3 o24_2_3 o24_1_3 gn24 gn24 sg13_lv_nmos w=0.74u l=0.13u
CL24_2_3 o24_2_3 gn24 2f
XP24_2_4 o24_2_4 o24_1_4 ph24 ph24 sg13_lv_pmos w=1.12u l=0.13u
XN24_2_4 o24_2_4 o24_1_4 gn24 gn24 sg13_lv_nmos w=0.74u l=0.13u
CL24_2_4 o24_2_4 gn24 2f
XP24_2_5 o24_2_5 o24_1_5 ph24 ph24 sg13_lv_pmos w=1.12u l=0.13u
XN24_2_5 o24_2_5 o24_1_5 gn24 gn24 sg13_lv_nmos w=0.74u l=0.13u
CL24_2_5 o24_2_5 gn24 2f
XP24_2_6 o24_2_6 o24_1_6 ph24 ph24 sg13_lv_pmos w=1.12u l=0.13u
XN24_2_6 o24_2_6 o24_1_6 gn24 gn24 sg13_lv_nmos w=0.74u l=0.13u
CL24_2_6 o24_2_6 gn24 2f
XP24_2_7 o24_2_7 o24_1_7 ph24 ph24 sg13_lv_pmos w=1.12u l=0.13u
XN24_2_7 o24_2_7 o24_1_7 gn24 gn24 sg13_lv_nmos w=0.74u l=0.13u
CL24_2_7 o24_2_7 gn24 2f
XP24_3_0 o24_3_0 o24_2_0 ph24 ph24 sg13_lv_pmos w=1.12u l=0.13u
XN24_3_0 o24_3_0 o24_2_0 gn24 gn24 sg13_lv_nmos w=0.74u l=0.13u
CL24_3_0 o24_3_0 gn24 2f
XP24_3_1 o24_3_1 o24_2_1 ph24 ph24 sg13_lv_pmos w=1.12u l=0.13u
XN24_3_1 o24_3_1 o24_2_1 gn24 gn24 sg13_lv_nmos w=0.74u l=0.13u
CL24_3_1 o24_3_1 gn24 2f
XP24_3_2 o24_3_2 o24_2_2 ph24 ph24 sg13_lv_pmos w=1.12u l=0.13u
XN24_3_2 o24_3_2 o24_2_2 gn24 gn24 sg13_lv_nmos w=0.74u l=0.13u
CL24_3_2 o24_3_2 gn24 2f
XP24_3_3 o24_3_3 o24_2_3 ph24 ph24 sg13_lv_pmos w=1.12u l=0.13u
XN24_3_3 o24_3_3 o24_2_3 gn24 gn24 sg13_lv_nmos w=0.74u l=0.13u
CL24_3_3 o24_3_3 gn24 2f
XP24_3_4 o24_3_4 o24_2_4 ph24 ph24 sg13_lv_pmos w=1.12u l=0.13u
XN24_3_4 o24_3_4 o24_2_4 gn24 gn24 sg13_lv_nmos w=0.74u l=0.13u
CL24_3_4 o24_3_4 gn24 2f
XP24_3_5 o24_3_5 o24_2_5 ph24 ph24 sg13_lv_pmos w=1.12u l=0.13u
XN24_3_5 o24_3_5 o24_2_5 gn24 gn24 sg13_lv_nmos w=0.74u l=0.13u
CL24_3_5 o24_3_5 gn24 2f
XP24_3_6 o24_3_6 o24_2_6 ph24 ph24 sg13_lv_pmos w=1.12u l=0.13u
XN24_3_6 o24_3_6 o24_2_6 gn24 gn24 sg13_lv_nmos w=0.74u l=0.13u
CL24_3_6 o24_3_6 gn24 2f
XP24_3_7 o24_3_7 o24_2_7 ph24 ph24 sg13_lv_pmos w=1.12u l=0.13u
XN24_3_7 o24_3_7 o24_2_7 gn24 gn24 sg13_lv_nmos w=0.74u l=0.13u
CL24_3_7 o24_3_7 gn24 2f
CXqdd xqdd 0 1
BXqdd 0 xqdd I={ -I(VDDH) }
RXqdd xqdd 0 0.01
CXqzr xqzr 0 1
BXqzr 0 xqzr I={ -I(VZR) }
RXqzr xqzr 0 0.01
CXerl xerl 0 1
BXerl 0 xerl I={ I(VML)*I(VML)*10 }
RXerl xerl 0 0.01
CXesw xesw 0 1
BXesw 0 xesw I={ (V(pA)-V(lin))*I(VSinA)+(V(pA)-V(lout))*I(VSoutA)+(V(pA)-V(vddh))*I(VSholdA)+(V(pA)-V(vzr))*I(VSzeroA)+(V(vddh)-V(lin))*I(VSindd)+(V(pB)-V(lin))*I(VSinB)+(V(pB)-V(lout))*I(VSoutB)+(V(pB)-V(vddh))*I(VSholdB)+(V(pB)-V(vzr))*I(VSzeroB)+(V(pC)-V(lin))*I(VSinC)+(V(pC)-V(lout))*I(VSoutC)+(V(pC)-V(vddh))*I(VSholdC)+(V(pC)-V(vzr))*I(VSzeroC) }
RXesw xesw 0 0.01
VI1_0 in1_0 0 PWL(0 1.65 275p 1.65 277p 0 551p 0 553p 1.65 827p 1.65 829p 0 1103p 0 1105p 1.65 1379p 1.65 1381p 0 1655p 0 1657p 1.65 1931p 1.65 1933p 0)
VI1_1 in1_1 0 PWL(0 1.65 275p 1.65 277p 0 551p 0 553p 1.65 827p 1.65 829p 0 1103p 0 1105p 1.65 1379p 1.65 1381p 0 1655p 0 1657p 1.65 1931p 1.65 1933p 0)
VI1_2 in1_2 0 PWL(0 1.65 275p 1.65 277p 0 551p 0 553p 1.65 827p 1.65 829p 0 1103p 0 1105p 1.65 1379p 1.65 1381p 0 1655p 0 1657p 1.65 1931p 1.65 1933p 0)
VI1_3 in1_3 0 PWL(0 0 275p 0 277p 1.65 551p 1.65 553p 0 827p 0 829p 1.65 1103p 1.65 1105p 0 1379p 0 1381p 1.65 1655p 1.65 1657p 0 1931p 0 1933p 1.65)
VI1_4 in1_4 0 PWL(0 1.65 275p 1.65 277p 0 551p 0 553p 1.65 827p 1.65 829p 0 1103p 0 1105p 1.65 1379p 1.65 1381p 0 1655p 0 1657p 1.65 1931p 1.65 1933p 0)
VI1_5 in1_5 0 PWL(0 0 275p 0 277p 1.65 551p 1.65 553p 0 827p 0 829p 1.65 1103p 1.65 1105p 0 1379p 0 1381p 1.65 1655p 1.65 1657p 0 1931p 0 1933p 1.65)
VI1_6 in1_6 0 PWL(0 0 275p 0 277p 1.65 551p 1.65 553p 0 827p 0 829p 1.65 1103p 1.65 1105p 0 1379p 0 1381p 1.65 1655p 1.65 1657p 0 1931p 0 1933p 1.65)
VI1_7 in1_7 0 PWL(0 1.65 275p 1.65 277p 0 551p 0 553p 1.65 827p 1.65 829p 0 1103p 0 1105p 1.65 1379p 1.65 1381p 0 1655p 0 1657p 1.65 1931p 1.65 1933p 0)
VMG1 gn1 0 0
XP1_1_0 o1_1_0 in1_0 ph1 ph1 sg13_lv_pmos w=1.12u l=0.13u
XN1_1_0 o1_1_0 in1_0 gn1 gn1 sg13_lv_nmos w=0.74u l=0.13u
CL1_1_0 o1_1_0 gn1 2f
XP1_1_1 o1_1_1 in1_1 ph1 ph1 sg13_lv_pmos w=1.12u l=0.13u
XN1_1_1 o1_1_1 in1_1 gn1 gn1 sg13_lv_nmos w=0.74u l=0.13u
CL1_1_1 o1_1_1 gn1 2f
XP1_1_2 o1_1_2 in1_2 ph1 ph1 sg13_lv_pmos w=1.12u l=0.13u
XN1_1_2 o1_1_2 in1_2 gn1 gn1 sg13_lv_nmos w=0.74u l=0.13u
CL1_1_2 o1_1_2 gn1 2f
XP1_1_3 o1_1_3 in1_3 ph1 ph1 sg13_lv_pmos w=1.12u l=0.13u
XN1_1_3 o1_1_3 in1_3 gn1 gn1 sg13_lv_nmos w=0.74u l=0.13u
CL1_1_3 o1_1_3 gn1 2f
XP1_1_4 o1_1_4 in1_4 ph1 ph1 sg13_lv_pmos w=1.12u l=0.13u
XN1_1_4 o1_1_4 in1_4 gn1 gn1 sg13_lv_nmos w=0.74u l=0.13u
CL1_1_4 o1_1_4 gn1 2f
XP1_1_5 o1_1_5 in1_5 ph1 ph1 sg13_lv_pmos w=1.12u l=0.13u
XN1_1_5 o1_1_5 in1_5 gn1 gn1 sg13_lv_nmos w=0.74u l=0.13u
CL1_1_5 o1_1_5 gn1 2f
XP1_1_6 o1_1_6 in1_6 ph1 ph1 sg13_lv_pmos w=1.12u l=0.13u
XN1_1_6 o1_1_6 in1_6 gn1 gn1 sg13_lv_nmos w=0.74u l=0.13u
CL1_1_6 o1_1_6 gn1 2f
XP1_1_7 o1_1_7 in1_7 ph1 ph1 sg13_lv_pmos w=1.12u l=0.13u
XN1_1_7 o1_1_7 in1_7 gn1 gn1 sg13_lv_nmos w=0.74u l=0.13u
CL1_1_7 o1_1_7 gn1 2f
XP1_2_0 o1_2_0 o1_1_0 ph1 ph1 sg13_lv_pmos w=1.12u l=0.13u
XN1_2_0 o1_2_0 o1_1_0 gn1 gn1 sg13_lv_nmos w=0.74u l=0.13u
CL1_2_0 o1_2_0 gn1 2f
XP1_2_1 o1_2_1 o1_1_1 ph1 ph1 sg13_lv_pmos w=1.12u l=0.13u
XN1_2_1 o1_2_1 o1_1_1 gn1 gn1 sg13_lv_nmos w=0.74u l=0.13u
CL1_2_1 o1_2_1 gn1 2f
XP1_2_2 o1_2_2 o1_1_2 ph1 ph1 sg13_lv_pmos w=1.12u l=0.13u
XN1_2_2 o1_2_2 o1_1_2 gn1 gn1 sg13_lv_nmos w=0.74u l=0.13u
CL1_2_2 o1_2_2 gn1 2f
XP1_2_3 o1_2_3 o1_1_3 ph1 ph1 sg13_lv_pmos w=1.12u l=0.13u
XN1_2_3 o1_2_3 o1_1_3 gn1 gn1 sg13_lv_nmos w=0.74u l=0.13u
CL1_2_3 o1_2_3 gn1 2f
XP1_2_4 o1_2_4 o1_1_4 ph1 ph1 sg13_lv_pmos w=1.12u l=0.13u
XN1_2_4 o1_2_4 o1_1_4 gn1 gn1 sg13_lv_nmos w=0.74u l=0.13u
CL1_2_4 o1_2_4 gn1 2f
XP1_2_5 o1_2_5 o1_1_5 ph1 ph1 sg13_lv_pmos w=1.12u l=0.13u
XN1_2_5 o1_2_5 o1_1_5 gn1 gn1 sg13_lv_nmos w=0.74u l=0.13u
CL1_2_5 o1_2_5 gn1 2f
XP1_2_6 o1_2_6 o1_1_6 ph1 ph1 sg13_lv_pmos w=1.12u l=0.13u
XN1_2_6 o1_2_6 o1_1_6 gn1 gn1 sg13_lv_nmos w=0.74u l=0.13u
CL1_2_6 o1_2_6 gn1 2f
XP1_2_7 o1_2_7 o1_1_7 ph1 ph1 sg13_lv_pmos w=1.12u l=0.13u
XN1_2_7 o1_2_7 o1_1_7 gn1 gn1 sg13_lv_nmos w=0.74u l=0.13u
CL1_2_7 o1_2_7 gn1 2f
XP1_3_0 o1_3_0 o1_2_0 ph1 ph1 sg13_lv_pmos w=1.12u l=0.13u
XN1_3_0 o1_3_0 o1_2_0 gn1 gn1 sg13_lv_nmos w=0.74u l=0.13u
CL1_3_0 o1_3_0 gn1 2f
XP1_3_1 o1_3_1 o1_2_1 ph1 ph1 sg13_lv_pmos w=1.12u l=0.13u
XN1_3_1 o1_3_1 o1_2_1 gn1 gn1 sg13_lv_nmos w=0.74u l=0.13u
CL1_3_1 o1_3_1 gn1 2f
XP1_3_2 o1_3_2 o1_2_2 ph1 ph1 sg13_lv_pmos w=1.12u l=0.13u
XN1_3_2 o1_3_2 o1_2_2 gn1 gn1 sg13_lv_nmos w=0.74u l=0.13u
CL1_3_2 o1_3_2 gn1 2f
XP1_3_3 o1_3_3 o1_2_3 ph1 ph1 sg13_lv_pmos w=1.12u l=0.13u
XN1_3_3 o1_3_3 o1_2_3 gn1 gn1 sg13_lv_nmos w=0.74u l=0.13u
CL1_3_3 o1_3_3 gn1 2f
XP1_3_4 o1_3_4 o1_2_4 ph1 ph1 sg13_lv_pmos w=1.12u l=0.13u
XN1_3_4 o1_3_4 o1_2_4 gn1 gn1 sg13_lv_nmos w=0.74u l=0.13u
CL1_3_4 o1_3_4 gn1 2f
XP1_3_5 o1_3_5 o1_2_5 ph1 ph1 sg13_lv_pmos w=1.12u l=0.13u
XN1_3_5 o1_3_5 o1_2_5 gn1 gn1 sg13_lv_nmos w=0.74u l=0.13u
CL1_3_5 o1_3_5 gn1 2f
XP1_3_6 o1_3_6 o1_2_6 ph1 ph1 sg13_lv_pmos w=1.12u l=0.13u
XN1_3_6 o1_3_6 o1_2_6 gn1 gn1 sg13_lv_nmos w=0.74u l=0.13u
CL1_3_6 o1_3_6 gn1 2f
XP1_3_7 o1_3_7 o1_2_7 ph1 ph1 sg13_lv_pmos w=1.12u l=0.13u
XN1_3_7 o1_3_7 o1_2_7 gn1 gn1 sg13_lv_nmos w=0.74u l=0.13u
CL1_3_7 o1_3_7 gn1 2f
VMG2 gn2 0 0
XP2_1_0 o2_1_0 o1_3_0 ph2 ph2 sg13_lv_pmos w=1.12u l=0.13u
XN2_1_0 o2_1_0 o1_3_0 gn2 gn2 sg13_lv_nmos w=0.74u l=0.13u
CL2_1_0 o2_1_0 gn2 2f
XP2_1_1 o2_1_1 o1_3_1 ph2 ph2 sg13_lv_pmos w=1.12u l=0.13u
XN2_1_1 o2_1_1 o1_3_1 gn2 gn2 sg13_lv_nmos w=0.74u l=0.13u
CL2_1_1 o2_1_1 gn2 2f
XP2_1_2 o2_1_2 o1_3_2 ph2 ph2 sg13_lv_pmos w=1.12u l=0.13u
XN2_1_2 o2_1_2 o1_3_2 gn2 gn2 sg13_lv_nmos w=0.74u l=0.13u
CL2_1_2 o2_1_2 gn2 2f
XP2_1_3 o2_1_3 o1_3_3 ph2 ph2 sg13_lv_pmos w=1.12u l=0.13u
XN2_1_3 o2_1_3 o1_3_3 gn2 gn2 sg13_lv_nmos w=0.74u l=0.13u
CL2_1_3 o2_1_3 gn2 2f
XP2_1_4 o2_1_4 o1_3_4 ph2 ph2 sg13_lv_pmos w=1.12u l=0.13u
XN2_1_4 o2_1_4 o1_3_4 gn2 gn2 sg13_lv_nmos w=0.74u l=0.13u
CL2_1_4 o2_1_4 gn2 2f
XP2_1_5 o2_1_5 o1_3_5 ph2 ph2 sg13_lv_pmos w=1.12u l=0.13u
XN2_1_5 o2_1_5 o1_3_5 gn2 gn2 sg13_lv_nmos w=0.74u l=0.13u
CL2_1_5 o2_1_5 gn2 2f
XP2_1_6 o2_1_6 o1_3_6 ph2 ph2 sg13_lv_pmos w=1.12u l=0.13u
XN2_1_6 o2_1_6 o1_3_6 gn2 gn2 sg13_lv_nmos w=0.74u l=0.13u
CL2_1_6 o2_1_6 gn2 2f
XP2_1_7 o2_1_7 o1_3_7 ph2 ph2 sg13_lv_pmos w=1.12u l=0.13u
XN2_1_7 o2_1_7 o1_3_7 gn2 gn2 sg13_lv_nmos w=0.74u l=0.13u
CL2_1_7 o2_1_7 gn2 2f
XP2_2_0 o2_2_0 o2_1_0 ph2 ph2 sg13_lv_pmos w=1.12u l=0.13u
XN2_2_0 o2_2_0 o2_1_0 gn2 gn2 sg13_lv_nmos w=0.74u l=0.13u
CL2_2_0 o2_2_0 gn2 2f
XP2_2_1 o2_2_1 o2_1_1 ph2 ph2 sg13_lv_pmos w=1.12u l=0.13u
XN2_2_1 o2_2_1 o2_1_1 gn2 gn2 sg13_lv_nmos w=0.74u l=0.13u
CL2_2_1 o2_2_1 gn2 2f
XP2_2_2 o2_2_2 o2_1_2 ph2 ph2 sg13_lv_pmos w=1.12u l=0.13u
XN2_2_2 o2_2_2 o2_1_2 gn2 gn2 sg13_lv_nmos w=0.74u l=0.13u
CL2_2_2 o2_2_2 gn2 2f
XP2_2_3 o2_2_3 o2_1_3 ph2 ph2 sg13_lv_pmos w=1.12u l=0.13u
XN2_2_3 o2_2_3 o2_1_3 gn2 gn2 sg13_lv_nmos w=0.74u l=0.13u
CL2_2_3 o2_2_3 gn2 2f
XP2_2_4 o2_2_4 o2_1_4 ph2 ph2 sg13_lv_pmos w=1.12u l=0.13u
XN2_2_4 o2_2_4 o2_1_4 gn2 gn2 sg13_lv_nmos w=0.74u l=0.13u
CL2_2_4 o2_2_4 gn2 2f
XP2_2_5 o2_2_5 o2_1_5 ph2 ph2 sg13_lv_pmos w=1.12u l=0.13u
XN2_2_5 o2_2_5 o2_1_5 gn2 gn2 sg13_lv_nmos w=0.74u l=0.13u
CL2_2_5 o2_2_5 gn2 2f
XP2_2_6 o2_2_6 o2_1_6 ph2 ph2 sg13_lv_pmos w=1.12u l=0.13u
XN2_2_6 o2_2_6 o2_1_6 gn2 gn2 sg13_lv_nmos w=0.74u l=0.13u
CL2_2_6 o2_2_6 gn2 2f
XP2_2_7 o2_2_7 o2_1_7 ph2 ph2 sg13_lv_pmos w=1.12u l=0.13u
XN2_2_7 o2_2_7 o2_1_7 gn2 gn2 sg13_lv_nmos w=0.74u l=0.13u
CL2_2_7 o2_2_7 gn2 2f
XP2_3_0 o2_3_0 o2_2_0 ph2 ph2 sg13_lv_pmos w=1.12u l=0.13u
XN2_3_0 o2_3_0 o2_2_0 gn2 gn2 sg13_lv_nmos w=0.74u l=0.13u
CL2_3_0 o2_3_0 gn2 2f
XP2_3_1 o2_3_1 o2_2_1 ph2 ph2 sg13_lv_pmos w=1.12u l=0.13u
XN2_3_1 o2_3_1 o2_2_1 gn2 gn2 sg13_lv_nmos w=0.74u l=0.13u
CL2_3_1 o2_3_1 gn2 2f
XP2_3_2 o2_3_2 o2_2_2 ph2 ph2 sg13_lv_pmos w=1.12u l=0.13u
XN2_3_2 o2_3_2 o2_2_2 gn2 gn2 sg13_lv_nmos w=0.74u l=0.13u
CL2_3_2 o2_3_2 gn2 2f
XP2_3_3 o2_3_3 o2_2_3 ph2 ph2 sg13_lv_pmos w=1.12u l=0.13u
XN2_3_3 o2_3_3 o2_2_3 gn2 gn2 sg13_lv_nmos w=0.74u l=0.13u
CL2_3_3 o2_3_3 gn2 2f
XP2_3_4 o2_3_4 o2_2_4 ph2 ph2 sg13_lv_pmos w=1.12u l=0.13u
XN2_3_4 o2_3_4 o2_2_4 gn2 gn2 sg13_lv_nmos w=0.74u l=0.13u
CL2_3_4 o2_3_4 gn2 2f
XP2_3_5 o2_3_5 o2_2_5 ph2 ph2 sg13_lv_pmos w=1.12u l=0.13u
XN2_3_5 o2_3_5 o2_2_5 gn2 gn2 sg13_lv_nmos w=0.74u l=0.13u
CL2_3_5 o2_3_5 gn2 2f
XP2_3_6 o2_3_6 o2_2_6 ph2 ph2 sg13_lv_pmos w=1.12u l=0.13u
XN2_3_6 o2_3_6 o2_2_6 gn2 gn2 sg13_lv_nmos w=0.74u l=0.13u
CL2_3_6 o2_3_6 gn2 2f
XP2_3_7 o2_3_7 o2_2_7 ph2 ph2 sg13_lv_pmos w=1.12u l=0.13u
XN2_3_7 o2_3_7 o2_2_7 gn2 gn2 sg13_lv_nmos w=0.74u l=0.13u
CL2_3_7 o2_3_7 gn2 2f
VMG3 gn3 0 0
XP3_1_0 o3_1_0 o2_3_0 ph3 ph3 sg13_lv_pmos w=1.12u l=0.13u
XN3_1_0 o3_1_0 o2_3_0 gn3 gn3 sg13_lv_nmos w=0.74u l=0.13u
CL3_1_0 o3_1_0 gn3 2f
XP3_1_1 o3_1_1 o2_3_1 ph3 ph3 sg13_lv_pmos w=1.12u l=0.13u
XN3_1_1 o3_1_1 o2_3_1 gn3 gn3 sg13_lv_nmos w=0.74u l=0.13u
CL3_1_1 o3_1_1 gn3 2f
XP3_1_2 o3_1_2 o2_3_2 ph3 ph3 sg13_lv_pmos w=1.12u l=0.13u
XN3_1_2 o3_1_2 o2_3_2 gn3 gn3 sg13_lv_nmos w=0.74u l=0.13u
CL3_1_2 o3_1_2 gn3 2f
XP3_1_3 o3_1_3 o2_3_3 ph3 ph3 sg13_lv_pmos w=1.12u l=0.13u
XN3_1_3 o3_1_3 o2_3_3 gn3 gn3 sg13_lv_nmos w=0.74u l=0.13u
CL3_1_3 o3_1_3 gn3 2f
XP3_1_4 o3_1_4 o2_3_4 ph3 ph3 sg13_lv_pmos w=1.12u l=0.13u
XN3_1_4 o3_1_4 o2_3_4 gn3 gn3 sg13_lv_nmos w=0.74u l=0.13u
CL3_1_4 o3_1_4 gn3 2f
XP3_1_5 o3_1_5 o2_3_5 ph3 ph3 sg13_lv_pmos w=1.12u l=0.13u
XN3_1_5 o3_1_5 o2_3_5 gn3 gn3 sg13_lv_nmos w=0.74u l=0.13u
CL3_1_5 o3_1_5 gn3 2f
XP3_1_6 o3_1_6 o2_3_6 ph3 ph3 sg13_lv_pmos w=1.12u l=0.13u
XN3_1_6 o3_1_6 o2_3_6 gn3 gn3 sg13_lv_nmos w=0.74u l=0.13u
CL3_1_6 o3_1_6 gn3 2f
XP3_1_7 o3_1_7 o2_3_7 ph3 ph3 sg13_lv_pmos w=1.12u l=0.13u
XN3_1_7 o3_1_7 o2_3_7 gn3 gn3 sg13_lv_nmos w=0.74u l=0.13u
CL3_1_7 o3_1_7 gn3 2f
XP3_2_0 o3_2_0 o3_1_0 ph3 ph3 sg13_lv_pmos w=1.12u l=0.13u
XN3_2_0 o3_2_0 o3_1_0 gn3 gn3 sg13_lv_nmos w=0.74u l=0.13u
CL3_2_0 o3_2_0 gn3 2f
XP3_2_1 o3_2_1 o3_1_1 ph3 ph3 sg13_lv_pmos w=1.12u l=0.13u
XN3_2_1 o3_2_1 o3_1_1 gn3 gn3 sg13_lv_nmos w=0.74u l=0.13u
CL3_2_1 o3_2_1 gn3 2f
XP3_2_2 o3_2_2 o3_1_2 ph3 ph3 sg13_lv_pmos w=1.12u l=0.13u
XN3_2_2 o3_2_2 o3_1_2 gn3 gn3 sg13_lv_nmos w=0.74u l=0.13u
CL3_2_2 o3_2_2 gn3 2f
XP3_2_3 o3_2_3 o3_1_3 ph3 ph3 sg13_lv_pmos w=1.12u l=0.13u
XN3_2_3 o3_2_3 o3_1_3 gn3 gn3 sg13_lv_nmos w=0.74u l=0.13u
CL3_2_3 o3_2_3 gn3 2f
XP3_2_4 o3_2_4 o3_1_4 ph3 ph3 sg13_lv_pmos w=1.12u l=0.13u
XN3_2_4 o3_2_4 o3_1_4 gn3 gn3 sg13_lv_nmos w=0.74u l=0.13u
CL3_2_4 o3_2_4 gn3 2f
XP3_2_5 o3_2_5 o3_1_5 ph3 ph3 sg13_lv_pmos w=1.12u l=0.13u
XN3_2_5 o3_2_5 o3_1_5 gn3 gn3 sg13_lv_nmos w=0.74u l=0.13u
CL3_2_5 o3_2_5 gn3 2f
XP3_2_6 o3_2_6 o3_1_6 ph3 ph3 sg13_lv_pmos w=1.12u l=0.13u
XN3_2_6 o3_2_6 o3_1_6 gn3 gn3 sg13_lv_nmos w=0.74u l=0.13u
CL3_2_6 o3_2_6 gn3 2f
XP3_2_7 o3_2_7 o3_1_7 ph3 ph3 sg13_lv_pmos w=1.12u l=0.13u
XN3_2_7 o3_2_7 o3_1_7 gn3 gn3 sg13_lv_nmos w=0.74u l=0.13u
CL3_2_7 o3_2_7 gn3 2f
XP3_3_0 o3_3_0 o3_2_0 ph3 ph3 sg13_lv_pmos w=1.12u l=0.13u
XN3_3_0 o3_3_0 o3_2_0 gn3 gn3 sg13_lv_nmos w=0.74u l=0.13u
CL3_3_0 o3_3_0 gn3 2f
XP3_3_1 o3_3_1 o3_2_1 ph3 ph3 sg13_lv_pmos w=1.12u l=0.13u
XN3_3_1 o3_3_1 o3_2_1 gn3 gn3 sg13_lv_nmos w=0.74u l=0.13u
CL3_3_1 o3_3_1 gn3 2f
XP3_3_2 o3_3_2 o3_2_2 ph3 ph3 sg13_lv_pmos w=1.12u l=0.13u
XN3_3_2 o3_3_2 o3_2_2 gn3 gn3 sg13_lv_nmos w=0.74u l=0.13u
CL3_3_2 o3_3_2 gn3 2f
XP3_3_3 o3_3_3 o3_2_3 ph3 ph3 sg13_lv_pmos w=1.12u l=0.13u
XN3_3_3 o3_3_3 o3_2_3 gn3 gn3 sg13_lv_nmos w=0.74u l=0.13u
CL3_3_3 o3_3_3 gn3 2f
XP3_3_4 o3_3_4 o3_2_4 ph3 ph3 sg13_lv_pmos w=1.12u l=0.13u
XN3_3_4 o3_3_4 o3_2_4 gn3 gn3 sg13_lv_nmos w=0.74u l=0.13u
CL3_3_4 o3_3_4 gn3 2f
XP3_3_5 o3_3_5 o3_2_5 ph3 ph3 sg13_lv_pmos w=1.12u l=0.13u
XN3_3_5 o3_3_5 o3_2_5 gn3 gn3 sg13_lv_nmos w=0.74u l=0.13u
CL3_3_5 o3_3_5 gn3 2f
XP3_3_6 o3_3_6 o3_2_6 ph3 ph3 sg13_lv_pmos w=1.12u l=0.13u
XN3_3_6 o3_3_6 o3_2_6 gn3 gn3 sg13_lv_nmos w=0.74u l=0.13u
CL3_3_6 o3_3_6 gn3 2f
XP3_3_7 o3_3_7 o3_2_7 ph3 ph3 sg13_lv_pmos w=1.12u l=0.13u
XN3_3_7 o3_3_7 o3_2_7 gn3 gn3 sg13_lv_nmos w=0.74u l=0.13u
CL3_3_7 o3_3_7 gn3 2f
VMG4 gn4 0 0
XP4_1_0 o4_1_0 o3_3_0 ph4 ph4 sg13_lv_pmos w=1.12u l=0.13u
XN4_1_0 o4_1_0 o3_3_0 gn4 gn4 sg13_lv_nmos w=0.74u l=0.13u
CL4_1_0 o4_1_0 gn4 2f
XP4_1_1 o4_1_1 o3_3_1 ph4 ph4 sg13_lv_pmos w=1.12u l=0.13u
XN4_1_1 o4_1_1 o3_3_1 gn4 gn4 sg13_lv_nmos w=0.74u l=0.13u
CL4_1_1 o4_1_1 gn4 2f
XP4_1_2 o4_1_2 o3_3_2 ph4 ph4 sg13_lv_pmos w=1.12u l=0.13u
XN4_1_2 o4_1_2 o3_3_2 gn4 gn4 sg13_lv_nmos w=0.74u l=0.13u
CL4_1_2 o4_1_2 gn4 2f
XP4_1_3 o4_1_3 o3_3_3 ph4 ph4 sg13_lv_pmos w=1.12u l=0.13u
XN4_1_3 o4_1_3 o3_3_3 gn4 gn4 sg13_lv_nmos w=0.74u l=0.13u
CL4_1_3 o4_1_3 gn4 2f
XP4_1_4 o4_1_4 o3_3_4 ph4 ph4 sg13_lv_pmos w=1.12u l=0.13u
XN4_1_4 o4_1_4 o3_3_4 gn4 gn4 sg13_lv_nmos w=0.74u l=0.13u
CL4_1_4 o4_1_4 gn4 2f
XP4_1_5 o4_1_5 o3_3_5 ph4 ph4 sg13_lv_pmos w=1.12u l=0.13u
XN4_1_5 o4_1_5 o3_3_5 gn4 gn4 sg13_lv_nmos w=0.74u l=0.13u
CL4_1_5 o4_1_5 gn4 2f
XP4_1_6 o4_1_6 o3_3_6 ph4 ph4 sg13_lv_pmos w=1.12u l=0.13u
XN4_1_6 o4_1_6 o3_3_6 gn4 gn4 sg13_lv_nmos w=0.74u l=0.13u
CL4_1_6 o4_1_6 gn4 2f
XP4_1_7 o4_1_7 o3_3_7 ph4 ph4 sg13_lv_pmos w=1.12u l=0.13u
XN4_1_7 o4_1_7 o3_3_7 gn4 gn4 sg13_lv_nmos w=0.74u l=0.13u
CL4_1_7 o4_1_7 gn4 2f
XP4_2_0 o4_2_0 o4_1_0 ph4 ph4 sg13_lv_pmos w=1.12u l=0.13u
XN4_2_0 o4_2_0 o4_1_0 gn4 gn4 sg13_lv_nmos w=0.74u l=0.13u
CL4_2_0 o4_2_0 gn4 2f
XP4_2_1 o4_2_1 o4_1_1 ph4 ph4 sg13_lv_pmos w=1.12u l=0.13u
XN4_2_1 o4_2_1 o4_1_1 gn4 gn4 sg13_lv_nmos w=0.74u l=0.13u
CL4_2_1 o4_2_1 gn4 2f
XP4_2_2 o4_2_2 o4_1_2 ph4 ph4 sg13_lv_pmos w=1.12u l=0.13u
XN4_2_2 o4_2_2 o4_1_2 gn4 gn4 sg13_lv_nmos w=0.74u l=0.13u
CL4_2_2 o4_2_2 gn4 2f
XP4_2_3 o4_2_3 o4_1_3 ph4 ph4 sg13_lv_pmos w=1.12u l=0.13u
XN4_2_3 o4_2_3 o4_1_3 gn4 gn4 sg13_lv_nmos w=0.74u l=0.13u
CL4_2_3 o4_2_3 gn4 2f
XP4_2_4 o4_2_4 o4_1_4 ph4 ph4 sg13_lv_pmos w=1.12u l=0.13u
XN4_2_4 o4_2_4 o4_1_4 gn4 gn4 sg13_lv_nmos w=0.74u l=0.13u
CL4_2_4 o4_2_4 gn4 2f
XP4_2_5 o4_2_5 o4_1_5 ph4 ph4 sg13_lv_pmos w=1.12u l=0.13u
XN4_2_5 o4_2_5 o4_1_5 gn4 gn4 sg13_lv_nmos w=0.74u l=0.13u
CL4_2_5 o4_2_5 gn4 2f
XP4_2_6 o4_2_6 o4_1_6 ph4 ph4 sg13_lv_pmos w=1.12u l=0.13u
XN4_2_6 o4_2_6 o4_1_6 gn4 gn4 sg13_lv_nmos w=0.74u l=0.13u
CL4_2_6 o4_2_6 gn4 2f
XP4_2_7 o4_2_7 o4_1_7 ph4 ph4 sg13_lv_pmos w=1.12u l=0.13u
XN4_2_7 o4_2_7 o4_1_7 gn4 gn4 sg13_lv_nmos w=0.74u l=0.13u
CL4_2_7 o4_2_7 gn4 2f
XP4_3_0 o4_3_0 o4_2_0 ph4 ph4 sg13_lv_pmos w=1.12u l=0.13u
XN4_3_0 o4_3_0 o4_2_0 gn4 gn4 sg13_lv_nmos w=0.74u l=0.13u
CL4_3_0 o4_3_0 gn4 2f
XP4_3_1 o4_3_1 o4_2_1 ph4 ph4 sg13_lv_pmos w=1.12u l=0.13u
XN4_3_1 o4_3_1 o4_2_1 gn4 gn4 sg13_lv_nmos w=0.74u l=0.13u
CL4_3_1 o4_3_1 gn4 2f
XP4_3_2 o4_3_2 o4_2_2 ph4 ph4 sg13_lv_pmos w=1.12u l=0.13u
XN4_3_2 o4_3_2 o4_2_2 gn4 gn4 sg13_lv_nmos w=0.74u l=0.13u
CL4_3_2 o4_3_2 gn4 2f
XP4_3_3 o4_3_3 o4_2_3 ph4 ph4 sg13_lv_pmos w=1.12u l=0.13u
XN4_3_3 o4_3_3 o4_2_3 gn4 gn4 sg13_lv_nmos w=0.74u l=0.13u
CL4_3_3 o4_3_3 gn4 2f
XP4_3_4 o4_3_4 o4_2_4 ph4 ph4 sg13_lv_pmos w=1.12u l=0.13u
XN4_3_4 o4_3_4 o4_2_4 gn4 gn4 sg13_lv_nmos w=0.74u l=0.13u
CL4_3_4 o4_3_4 gn4 2f
XP4_3_5 o4_3_5 o4_2_5 ph4 ph4 sg13_lv_pmos w=1.12u l=0.13u
XN4_3_5 o4_3_5 o4_2_5 gn4 gn4 sg13_lv_nmos w=0.74u l=0.13u
CL4_3_5 o4_3_5 gn4 2f
XP4_3_6 o4_3_6 o4_2_6 ph4 ph4 sg13_lv_pmos w=1.12u l=0.13u
XN4_3_6 o4_3_6 o4_2_6 gn4 gn4 sg13_lv_nmos w=0.74u l=0.13u
CL4_3_6 o4_3_6 gn4 2f
XP4_3_7 o4_3_7 o4_2_7 ph4 ph4 sg13_lv_pmos w=1.12u l=0.13u
XN4_3_7 o4_3_7 o4_2_7 gn4 gn4 sg13_lv_nmos w=0.74u l=0.13u
CL4_3_7 o4_3_7 gn4 2f
VMG5 gn5 0 0
XP5_1_0 o5_1_0 o4_3_0 ph5 ph5 sg13_lv_pmos w=1.12u l=0.13u
XN5_1_0 o5_1_0 o4_3_0 gn5 gn5 sg13_lv_nmos w=0.74u l=0.13u
CL5_1_0 o5_1_0 gn5 2f
XP5_1_1 o5_1_1 o4_3_1 ph5 ph5 sg13_lv_pmos w=1.12u l=0.13u
XN5_1_1 o5_1_1 o4_3_1 gn5 gn5 sg13_lv_nmos w=0.74u l=0.13u
CL5_1_1 o5_1_1 gn5 2f
XP5_1_2 o5_1_2 o4_3_2 ph5 ph5 sg13_lv_pmos w=1.12u l=0.13u
XN5_1_2 o5_1_2 o4_3_2 gn5 gn5 sg13_lv_nmos w=0.74u l=0.13u
CL5_1_2 o5_1_2 gn5 2f
XP5_1_3 o5_1_3 o4_3_3 ph5 ph5 sg13_lv_pmos w=1.12u l=0.13u
XN5_1_3 o5_1_3 o4_3_3 gn5 gn5 sg13_lv_nmos w=0.74u l=0.13u
CL5_1_3 o5_1_3 gn5 2f
XP5_1_4 o5_1_4 o4_3_4 ph5 ph5 sg13_lv_pmos w=1.12u l=0.13u
XN5_1_4 o5_1_4 o4_3_4 gn5 gn5 sg13_lv_nmos w=0.74u l=0.13u
CL5_1_4 o5_1_4 gn5 2f
XP5_1_5 o5_1_5 o4_3_5 ph5 ph5 sg13_lv_pmos w=1.12u l=0.13u
XN5_1_5 o5_1_5 o4_3_5 gn5 gn5 sg13_lv_nmos w=0.74u l=0.13u
CL5_1_5 o5_1_5 gn5 2f
XP5_1_6 o5_1_6 o4_3_6 ph5 ph5 sg13_lv_pmos w=1.12u l=0.13u
XN5_1_6 o5_1_6 o4_3_6 gn5 gn5 sg13_lv_nmos w=0.74u l=0.13u
CL5_1_6 o5_1_6 gn5 2f
XP5_1_7 o5_1_7 o4_3_7 ph5 ph5 sg13_lv_pmos w=1.12u l=0.13u
XN5_1_7 o5_1_7 o4_3_7 gn5 gn5 sg13_lv_nmos w=0.74u l=0.13u
CL5_1_7 o5_1_7 gn5 2f
XP5_2_0 o5_2_0 o5_1_0 ph5 ph5 sg13_lv_pmos w=1.12u l=0.13u
XN5_2_0 o5_2_0 o5_1_0 gn5 gn5 sg13_lv_nmos w=0.74u l=0.13u
CL5_2_0 o5_2_0 gn5 2f
XP5_2_1 o5_2_1 o5_1_1 ph5 ph5 sg13_lv_pmos w=1.12u l=0.13u
XN5_2_1 o5_2_1 o5_1_1 gn5 gn5 sg13_lv_nmos w=0.74u l=0.13u
CL5_2_1 o5_2_1 gn5 2f
XP5_2_2 o5_2_2 o5_1_2 ph5 ph5 sg13_lv_pmos w=1.12u l=0.13u
XN5_2_2 o5_2_2 o5_1_2 gn5 gn5 sg13_lv_nmos w=0.74u l=0.13u
CL5_2_2 o5_2_2 gn5 2f
XP5_2_3 o5_2_3 o5_1_3 ph5 ph5 sg13_lv_pmos w=1.12u l=0.13u
XN5_2_3 o5_2_3 o5_1_3 gn5 gn5 sg13_lv_nmos w=0.74u l=0.13u
CL5_2_3 o5_2_3 gn5 2f
XP5_2_4 o5_2_4 o5_1_4 ph5 ph5 sg13_lv_pmos w=1.12u l=0.13u
XN5_2_4 o5_2_4 o5_1_4 gn5 gn5 sg13_lv_nmos w=0.74u l=0.13u
CL5_2_4 o5_2_4 gn5 2f
XP5_2_5 o5_2_5 o5_1_5 ph5 ph5 sg13_lv_pmos w=1.12u l=0.13u
XN5_2_5 o5_2_5 o5_1_5 gn5 gn5 sg13_lv_nmos w=0.74u l=0.13u
CL5_2_5 o5_2_5 gn5 2f
XP5_2_6 o5_2_6 o5_1_6 ph5 ph5 sg13_lv_pmos w=1.12u l=0.13u
XN5_2_6 o5_2_6 o5_1_6 gn5 gn5 sg13_lv_nmos w=0.74u l=0.13u
CL5_2_6 o5_2_6 gn5 2f
XP5_2_7 o5_2_7 o5_1_7 ph5 ph5 sg13_lv_pmos w=1.12u l=0.13u
XN5_2_7 o5_2_7 o5_1_7 gn5 gn5 sg13_lv_nmos w=0.74u l=0.13u
CL5_2_7 o5_2_7 gn5 2f
XP5_3_0 o5_3_0 o5_2_0 ph5 ph5 sg13_lv_pmos w=1.12u l=0.13u
XN5_3_0 o5_3_0 o5_2_0 gn5 gn5 sg13_lv_nmos w=0.74u l=0.13u
CL5_3_0 o5_3_0 gn5 2f
XP5_3_1 o5_3_1 o5_2_1 ph5 ph5 sg13_lv_pmos w=1.12u l=0.13u
XN5_3_1 o5_3_1 o5_2_1 gn5 gn5 sg13_lv_nmos w=0.74u l=0.13u
CL5_3_1 o5_3_1 gn5 2f
XP5_3_2 o5_3_2 o5_2_2 ph5 ph5 sg13_lv_pmos w=1.12u l=0.13u
XN5_3_2 o5_3_2 o5_2_2 gn5 gn5 sg13_lv_nmos w=0.74u l=0.13u
CL5_3_2 o5_3_2 gn5 2f
XP5_3_3 o5_3_3 o5_2_3 ph5 ph5 sg13_lv_pmos w=1.12u l=0.13u
XN5_3_3 o5_3_3 o5_2_3 gn5 gn5 sg13_lv_nmos w=0.74u l=0.13u
CL5_3_3 o5_3_3 gn5 2f
XP5_3_4 o5_3_4 o5_2_4 ph5 ph5 sg13_lv_pmos w=1.12u l=0.13u
XN5_3_4 o5_3_4 o5_2_4 gn5 gn5 sg13_lv_nmos w=0.74u l=0.13u
CL5_3_4 o5_3_4 gn5 2f
XP5_3_5 o5_3_5 o5_2_5 ph5 ph5 sg13_lv_pmos w=1.12u l=0.13u
XN5_3_5 o5_3_5 o5_2_5 gn5 gn5 sg13_lv_nmos w=0.74u l=0.13u
CL5_3_5 o5_3_5 gn5 2f
XP5_3_6 o5_3_6 o5_2_6 ph5 ph5 sg13_lv_pmos w=1.12u l=0.13u
XN5_3_6 o5_3_6 o5_2_6 gn5 gn5 sg13_lv_nmos w=0.74u l=0.13u
CL5_3_6 o5_3_6 gn5 2f
XP5_3_7 o5_3_7 o5_2_7 ph5 ph5 sg13_lv_pmos w=1.12u l=0.13u
XN5_3_7 o5_3_7 o5_2_7 gn5 gn5 sg13_lv_nmos w=0.74u l=0.13u
CL5_3_7 o5_3_7 gn5 2f
VMG6 gn6 0 0
XP6_1_0 o6_1_0 o5_3_0 ph6 ph6 sg13_lv_pmos w=1.12u l=0.13u
XN6_1_0 o6_1_0 o5_3_0 gn6 gn6 sg13_lv_nmos w=0.74u l=0.13u
CL6_1_0 o6_1_0 gn6 2f
XP6_1_1 o6_1_1 o5_3_1 ph6 ph6 sg13_lv_pmos w=1.12u l=0.13u
XN6_1_1 o6_1_1 o5_3_1 gn6 gn6 sg13_lv_nmos w=0.74u l=0.13u
CL6_1_1 o6_1_1 gn6 2f
XP6_1_2 o6_1_2 o5_3_2 ph6 ph6 sg13_lv_pmos w=1.12u l=0.13u
XN6_1_2 o6_1_2 o5_3_2 gn6 gn6 sg13_lv_nmos w=0.74u l=0.13u
CL6_1_2 o6_1_2 gn6 2f
XP6_1_3 o6_1_3 o5_3_3 ph6 ph6 sg13_lv_pmos w=1.12u l=0.13u
XN6_1_3 o6_1_3 o5_3_3 gn6 gn6 sg13_lv_nmos w=0.74u l=0.13u
CL6_1_3 o6_1_3 gn6 2f
XP6_1_4 o6_1_4 o5_3_4 ph6 ph6 sg13_lv_pmos w=1.12u l=0.13u
XN6_1_4 o6_1_4 o5_3_4 gn6 gn6 sg13_lv_nmos w=0.74u l=0.13u
CL6_1_4 o6_1_4 gn6 2f
XP6_1_5 o6_1_5 o5_3_5 ph6 ph6 sg13_lv_pmos w=1.12u l=0.13u
XN6_1_5 o6_1_5 o5_3_5 gn6 gn6 sg13_lv_nmos w=0.74u l=0.13u
CL6_1_5 o6_1_5 gn6 2f
XP6_1_6 o6_1_6 o5_3_6 ph6 ph6 sg13_lv_pmos w=1.12u l=0.13u
XN6_1_6 o6_1_6 o5_3_6 gn6 gn6 sg13_lv_nmos w=0.74u l=0.13u
CL6_1_6 o6_1_6 gn6 2f
XP6_1_7 o6_1_7 o5_3_7 ph6 ph6 sg13_lv_pmos w=1.12u l=0.13u
XN6_1_7 o6_1_7 o5_3_7 gn6 gn6 sg13_lv_nmos w=0.74u l=0.13u
CL6_1_7 o6_1_7 gn6 2f
XP6_2_0 o6_2_0 o6_1_0 ph6 ph6 sg13_lv_pmos w=1.12u l=0.13u
XN6_2_0 o6_2_0 o6_1_0 gn6 gn6 sg13_lv_nmos w=0.74u l=0.13u
CL6_2_0 o6_2_0 gn6 2f
XP6_2_1 o6_2_1 o6_1_1 ph6 ph6 sg13_lv_pmos w=1.12u l=0.13u
XN6_2_1 o6_2_1 o6_1_1 gn6 gn6 sg13_lv_nmos w=0.74u l=0.13u
CL6_2_1 o6_2_1 gn6 2f
XP6_2_2 o6_2_2 o6_1_2 ph6 ph6 sg13_lv_pmos w=1.12u l=0.13u
XN6_2_2 o6_2_2 o6_1_2 gn6 gn6 sg13_lv_nmos w=0.74u l=0.13u
CL6_2_2 o6_2_2 gn6 2f
XP6_2_3 o6_2_3 o6_1_3 ph6 ph6 sg13_lv_pmos w=1.12u l=0.13u
XN6_2_3 o6_2_3 o6_1_3 gn6 gn6 sg13_lv_nmos w=0.74u l=0.13u
CL6_2_3 o6_2_3 gn6 2f
XP6_2_4 o6_2_4 o6_1_4 ph6 ph6 sg13_lv_pmos w=1.12u l=0.13u
XN6_2_4 o6_2_4 o6_1_4 gn6 gn6 sg13_lv_nmos w=0.74u l=0.13u
CL6_2_4 o6_2_4 gn6 2f
XP6_2_5 o6_2_5 o6_1_5 ph6 ph6 sg13_lv_pmos w=1.12u l=0.13u
XN6_2_5 o6_2_5 o6_1_5 gn6 gn6 sg13_lv_nmos w=0.74u l=0.13u
CL6_2_5 o6_2_5 gn6 2f
XP6_2_6 o6_2_6 o6_1_6 ph6 ph6 sg13_lv_pmos w=1.12u l=0.13u
XN6_2_6 o6_2_6 o6_1_6 gn6 gn6 sg13_lv_nmos w=0.74u l=0.13u
CL6_2_6 o6_2_6 gn6 2f
XP6_2_7 o6_2_7 o6_1_7 ph6 ph6 sg13_lv_pmos w=1.12u l=0.13u
XN6_2_7 o6_2_7 o6_1_7 gn6 gn6 sg13_lv_nmos w=0.74u l=0.13u
CL6_2_7 o6_2_7 gn6 2f
XP6_3_0 o6_3_0 o6_2_0 ph6 ph6 sg13_lv_pmos w=1.12u l=0.13u
XN6_3_0 o6_3_0 o6_2_0 gn6 gn6 sg13_lv_nmos w=0.74u l=0.13u
CL6_3_0 o6_3_0 gn6 2f
XP6_3_1 o6_3_1 o6_2_1 ph6 ph6 sg13_lv_pmos w=1.12u l=0.13u
XN6_3_1 o6_3_1 o6_2_1 gn6 gn6 sg13_lv_nmos w=0.74u l=0.13u
CL6_3_1 o6_3_1 gn6 2f
XP6_3_2 o6_3_2 o6_2_2 ph6 ph6 sg13_lv_pmos w=1.12u l=0.13u
XN6_3_2 o6_3_2 o6_2_2 gn6 gn6 sg13_lv_nmos w=0.74u l=0.13u
CL6_3_2 o6_3_2 gn6 2f
XP6_3_3 o6_3_3 o6_2_3 ph6 ph6 sg13_lv_pmos w=1.12u l=0.13u
XN6_3_3 o6_3_3 o6_2_3 gn6 gn6 sg13_lv_nmos w=0.74u l=0.13u
CL6_3_3 o6_3_3 gn6 2f
XP6_3_4 o6_3_4 o6_2_4 ph6 ph6 sg13_lv_pmos w=1.12u l=0.13u
XN6_3_4 o6_3_4 o6_2_4 gn6 gn6 sg13_lv_nmos w=0.74u l=0.13u
CL6_3_4 o6_3_4 gn6 2f
XP6_3_5 o6_3_5 o6_2_5 ph6 ph6 sg13_lv_pmos w=1.12u l=0.13u
XN6_3_5 o6_3_5 o6_2_5 gn6 gn6 sg13_lv_nmos w=0.74u l=0.13u
CL6_3_5 o6_3_5 gn6 2f
XP6_3_6 o6_3_6 o6_2_6 ph6 ph6 sg13_lv_pmos w=1.12u l=0.13u
XN6_3_6 o6_3_6 o6_2_6 gn6 gn6 sg13_lv_nmos w=0.74u l=0.13u
CL6_3_6 o6_3_6 gn6 2f
XP6_3_7 o6_3_7 o6_2_7 ph6 ph6 sg13_lv_pmos w=1.12u l=0.13u
XN6_3_7 o6_3_7 o6_2_7 gn6 gn6 sg13_lv_nmos w=0.74u l=0.13u
CL6_3_7 o6_3_7 gn6 2f
CXqph1 xqph1 0 1
BXqph1 0 xqph1 I={ -I(VPH1) }
RXqph1 xqph1 0 0.01
CXeph1 xeph1 0 1
BXeph1 0 xeph1 I={ -V(ph1)*I(VPH1) }
RXeph1 xeph1 0 0.01
CXqg1 xqg1 0 1
BXqg1 0 xqg1 I={ I(VMG1) }
RXqg1 xqg1 0 0.01
CXqph2 xqph2 0 1
BXqph2 0 xqph2 I={ -I(VPH2) }
RXqph2 xqph2 0 0.01
CXeph2 xeph2 0 1
BXeph2 0 xeph2 I={ -V(ph2)*I(VPH2) }
RXeph2 xeph2 0 0.01
CXqg2 xqg2 0 1
BXqg2 0 xqg2 I={ I(VMG2) }
RXqg2 xqg2 0 0.01
CXqph3 xqph3 0 1
BXqph3 0 xqph3 I={ -I(VPH3) }
RXqph3 xqph3 0 0.01
CXeph3 xeph3 0 1
BXeph3 0 xeph3 I={ -V(ph3)*I(VPH3) }
RXeph3 xeph3 0 0.01
CXqg3 xqg3 0 1
BXqg3 0 xqg3 I={ I(VMG3) }
RXqg3 xqg3 0 0.01
CXqph4 xqph4 0 1
BXqph4 0 xqph4 I={ -I(VPH4) }
RXqph4 xqph4 0 0.01
CXeph4 xeph4 0 1
BXeph4 0 xeph4 I={ -V(ph4)*I(VPH4) }
RXeph4 xeph4 0 0.01
CXqg4 xqg4 0 1
BXqg4 0 xqg4 I={ I(VMG4) }
RXqg4 xqg4 0 0.01
CXqph5 xqph5 0 1
BXqph5 0 xqph5 I={ -I(VPH5) }
RXqph5 xqph5 0 0.01
CXeph5 xeph5 0 1
BXeph5 0 xeph5 I={ -V(ph5)*I(VPH5) }
RXeph5 xeph5 0 0.01
CXqg5 xqg5 0 1
BXqg5 0 xqg5 I={ I(VMG5) }
RXqg5 xqg5 0 0.01
CXqph6 xqph6 0 1
BXqph6 0 xqph6 I={ -I(VPH6) }
RXqph6 xqph6 0 0.01
CXeph6 xeph6 0 1
BXeph6 0 xeph6 I={ -V(ph6)*I(VPH6) }
RXeph6 xeph6 0 0.01
CXqg6 xqg6 0 1
BXqg6 0 xqg6 I={ I(VMG6) }
RXqg6 xqg6 0 0.01
.ic V(pA)=0 V(pB)=1.65 V(pC)=1.65 V(vddh)=1.65 V(lin)=0.8 V(lmid)=0.8 V(lx)=0.8 V(lout)=0.8 V(ph1)=0 V(ph2)=1.65 V(ph3)=1.65 V(ph4)=0 V(ph5)=1.65 V(ph6)=1.65 V(ph7)=0 V(ph8)=1.65 V(ph9)=1.65 V(ph10)=0 V(ph11)=1.65 V(ph12)=1.65 V(ph13)=0 V(ph14)=1.65 V(ph15)=1.65 V(ph16)=0 V(ph17)=1.65 V(ph18)=1.65 V(ph19)=0 V(ph20)=1.65 V(ph21)=1.65 V(ph22)=0 V(ph23)=1.65 V(ph24)=1.65
.tran 0.1p 1932p 0 0.25p UIC
.measure tran VRK1W2 FIND V(ph1) AT=691.000000p
.measure tran VK1_1_0W2 FIND V(o1_1_0) AT=691.000000p
.measure tran VK1_1_1W2 FIND V(o1_1_1) AT=691.000000p
.measure tran VK1_1_2W2 FIND V(o1_1_2) AT=691.000000p
.measure tran VK1_1_3W2 FIND V(o1_1_3) AT=691.000000p
.measure tran VK1_1_4W2 FIND V(o1_1_4) AT=691.000000p
.measure tran VK1_1_5W2 FIND V(o1_1_5) AT=691.000000p
.measure tran VK1_1_6W2 FIND V(o1_1_6) AT=691.000000p
.measure tran VK1_1_7W2 FIND V(o1_1_7) AT=691.000000p
.measure tran VK1_2_0W2 FIND V(o1_2_0) AT=691.000000p
.measure tran VK1_2_1W2 FIND V(o1_2_1) AT=691.000000p
.measure tran VK1_2_2W2 FIND V(o1_2_2) AT=691.000000p
.measure tran VK1_2_3W2 FIND V(o1_2_3) AT=691.000000p
.measure tran VK1_2_4W2 FIND V(o1_2_4) AT=691.000000p
.measure tran VK1_2_5W2 FIND V(o1_2_5) AT=691.000000p
.measure tran VK1_2_6W2 FIND V(o1_2_6) AT=691.000000p
.measure tran VK1_2_7W2 FIND V(o1_2_7) AT=691.000000p
.measure tran VK1_3_0W2 FIND V(o1_3_0) AT=691.000000p
.measure tran VK1_3_1W2 FIND V(o1_3_1) AT=691.000000p
.measure tran VK1_3_2W2 FIND V(o1_3_2) AT=691.000000p
.measure tran VK1_3_3W2 FIND V(o1_3_3) AT=691.000000p
.measure tran VK1_3_4W2 FIND V(o1_3_4) AT=691.000000p
.measure tran VK1_3_5W2 FIND V(o1_3_5) AT=691.000000p
.measure tran VK1_3_6W2 FIND V(o1_3_6) AT=691.000000p
.measure tran VK1_3_7W2 FIND V(o1_3_7) AT=691.000000p
.measure tran VRK2W2 FIND V(ph2) AT=783.000000p
.measure tran VK2_1_0W2 FIND V(o2_1_0) AT=783.000000p
.measure tran VK2_1_1W2 FIND V(o2_1_1) AT=783.000000p
.measure tran VK2_1_2W2 FIND V(o2_1_2) AT=783.000000p
.measure tran VK2_1_3W2 FIND V(o2_1_3) AT=783.000000p
.measure tran VK2_1_4W2 FIND V(o2_1_4) AT=783.000000p
.measure tran VK2_1_5W2 FIND V(o2_1_5) AT=783.000000p
.measure tran VK2_1_6W2 FIND V(o2_1_6) AT=783.000000p
.measure tran VK2_1_7W2 FIND V(o2_1_7) AT=783.000000p
.measure tran VK2_2_0W2 FIND V(o2_2_0) AT=783.000000p
.measure tran VK2_2_1W2 FIND V(o2_2_1) AT=783.000000p
.measure tran VK2_2_2W2 FIND V(o2_2_2) AT=783.000000p
.measure tran VK2_2_3W2 FIND V(o2_2_3) AT=783.000000p
.measure tran VK2_2_4W2 FIND V(o2_2_4) AT=783.000000p
.measure tran VK2_2_5W2 FIND V(o2_2_5) AT=783.000000p
.measure tran VK2_2_6W2 FIND V(o2_2_6) AT=783.000000p
.measure tran VK2_2_7W2 FIND V(o2_2_7) AT=783.000000p
.measure tran VK2_3_0W2 FIND V(o2_3_0) AT=783.000000p
.measure tran VK2_3_1W2 FIND V(o2_3_1) AT=783.000000p
.measure tran VK2_3_2W2 FIND V(o2_3_2) AT=783.000000p
.measure tran VK2_3_3W2 FIND V(o2_3_3) AT=783.000000p
.measure tran VK2_3_4W2 FIND V(o2_3_4) AT=783.000000p
.measure tran VK2_3_5W2 FIND V(o2_3_5) AT=783.000000p
.measure tran VK2_3_6W2 FIND V(o2_3_6) AT=783.000000p
.measure tran VK2_3_7W2 FIND V(o2_3_7) AT=783.000000p
.measure tran VRK3W2 FIND V(ph3) AT=875.000000p
.measure tran VK3_1_0W2 FIND V(o3_1_0) AT=875.000000p
.measure tran VK3_1_1W2 FIND V(o3_1_1) AT=875.000000p
.measure tran VK3_1_2W2 FIND V(o3_1_2) AT=875.000000p
.measure tran VK3_1_3W2 FIND V(o3_1_3) AT=875.000000p
.measure tran VK3_1_4W2 FIND V(o3_1_4) AT=875.000000p
.measure tran VK3_1_5W2 FIND V(o3_1_5) AT=875.000000p
.measure tran VK3_1_6W2 FIND V(o3_1_6) AT=875.000000p
.measure tran VK3_1_7W2 FIND V(o3_1_7) AT=875.000000p
.measure tran VK3_2_0W2 FIND V(o3_2_0) AT=875.000000p
.measure tran VK3_2_1W2 FIND V(o3_2_1) AT=875.000000p
.measure tran VK3_2_2W2 FIND V(o3_2_2) AT=875.000000p
.measure tran VK3_2_3W2 FIND V(o3_2_3) AT=875.000000p
.measure tran VK3_2_4W2 FIND V(o3_2_4) AT=875.000000p
.measure tran VK3_2_5W2 FIND V(o3_2_5) AT=875.000000p
.measure tran VK3_2_6W2 FIND V(o3_2_6) AT=875.000000p
.measure tran VK3_2_7W2 FIND V(o3_2_7) AT=875.000000p
.measure tran VK3_3_0W2 FIND V(o3_3_0) AT=875.000000p
.measure tran VK3_3_1W2 FIND V(o3_3_1) AT=875.000000p
.measure tran VK3_3_2W2 FIND V(o3_3_2) AT=875.000000p
.measure tran VK3_3_3W2 FIND V(o3_3_3) AT=875.000000p
.measure tran VK3_3_4W2 FIND V(o3_3_4) AT=875.000000p
.measure tran VK3_3_5W2 FIND V(o3_3_5) AT=875.000000p
.measure tran VK3_3_6W2 FIND V(o3_3_6) AT=875.000000p
.measure tran VK3_3_7W2 FIND V(o3_3_7) AT=875.000000p
.measure tran VRK4W2 FIND V(ph4) AT=967.000000p
.measure tran VK4_1_0W2 FIND V(o4_1_0) AT=967.000000p
.measure tran VK4_1_1W2 FIND V(o4_1_1) AT=967.000000p
.measure tran VK4_1_2W2 FIND V(o4_1_2) AT=967.000000p
.measure tran VK4_1_3W2 FIND V(o4_1_3) AT=967.000000p
.measure tran VK4_1_4W2 FIND V(o4_1_4) AT=967.000000p
.measure tran VK4_1_5W2 FIND V(o4_1_5) AT=967.000000p
.measure tran VK4_1_6W2 FIND V(o4_1_6) AT=967.000000p
.measure tran VK4_1_7W2 FIND V(o4_1_7) AT=967.000000p
.measure tran VK4_2_0W2 FIND V(o4_2_0) AT=967.000000p
.measure tran VK4_2_1W2 FIND V(o4_2_1) AT=967.000000p
.measure tran VK4_2_2W2 FIND V(o4_2_2) AT=967.000000p
.measure tran VK4_2_3W2 FIND V(o4_2_3) AT=967.000000p
.measure tran VK4_2_4W2 FIND V(o4_2_4) AT=967.000000p
.measure tran VK4_2_5W2 FIND V(o4_2_5) AT=967.000000p
.measure tran VK4_2_6W2 FIND V(o4_2_6) AT=967.000000p
.measure tran VK4_2_7W2 FIND V(o4_2_7) AT=967.000000p
.measure tran VK4_3_0W2 FIND V(o4_3_0) AT=967.000000p
.measure tran VK4_3_1W2 FIND V(o4_3_1) AT=967.000000p
.measure tran VK4_3_2W2 FIND V(o4_3_2) AT=967.000000p
.measure tran VK4_3_3W2 FIND V(o4_3_3) AT=967.000000p
.measure tran VK4_3_4W2 FIND V(o4_3_4) AT=967.000000p
.measure tran VK4_3_5W2 FIND V(o4_3_5) AT=967.000000p
.measure tran VK4_3_6W2 FIND V(o4_3_6) AT=967.000000p
.measure tran VK4_3_7W2 FIND V(o4_3_7) AT=967.000000p
.measure tran VRK5W2 FIND V(ph5) AT=1059.000000p
.measure tran VK5_1_0W2 FIND V(o5_1_0) AT=1059.000000p
.measure tran VK5_1_1W2 FIND V(o5_1_1) AT=1059.000000p
.measure tran VK5_1_2W2 FIND V(o5_1_2) AT=1059.000000p
.measure tran VK5_1_3W2 FIND V(o5_1_3) AT=1059.000000p
.measure tran VK5_1_4W2 FIND V(o5_1_4) AT=1059.000000p
.measure tran VK5_1_5W2 FIND V(o5_1_5) AT=1059.000000p
.measure tran VK5_1_6W2 FIND V(o5_1_6) AT=1059.000000p
.measure tran VK5_1_7W2 FIND V(o5_1_7) AT=1059.000000p
.measure tran VK5_2_0W2 FIND V(o5_2_0) AT=1059.000000p
.measure tran VK5_2_1W2 FIND V(o5_2_1) AT=1059.000000p
.measure tran VK5_2_2W2 FIND V(o5_2_2) AT=1059.000000p
.measure tran VK5_2_3W2 FIND V(o5_2_3) AT=1059.000000p
.measure tran VK5_2_4W2 FIND V(o5_2_4) AT=1059.000000p
.measure tran VK5_2_5W2 FIND V(o5_2_5) AT=1059.000000p
.measure tran VK5_2_6W2 FIND V(o5_2_6) AT=1059.000000p
.measure tran VK5_2_7W2 FIND V(o5_2_7) AT=1059.000000p
.measure tran VK5_3_0W2 FIND V(o5_3_0) AT=1059.000000p
.measure tran VK5_3_1W2 FIND V(o5_3_1) AT=1059.000000p
.measure tran VK5_3_2W2 FIND V(o5_3_2) AT=1059.000000p
.measure tran VK5_3_3W2 FIND V(o5_3_3) AT=1059.000000p
.measure tran VK5_3_4W2 FIND V(o5_3_4) AT=1059.000000p
.measure tran VK5_3_5W2 FIND V(o5_3_5) AT=1059.000000p
.measure tran VK5_3_6W2 FIND V(o5_3_6) AT=1059.000000p
.measure tran VK5_3_7W2 FIND V(o5_3_7) AT=1059.000000p
.measure tran VRK6W2 FIND V(ph6) AT=1151.000000p
.measure tran VK6_1_0W2 FIND V(o6_1_0) AT=1151.000000p
.measure tran VK6_1_1W2 FIND V(o6_1_1) AT=1151.000000p
.measure tran VK6_1_2W2 FIND V(o6_1_2) AT=1151.000000p
.measure tran VK6_1_3W2 FIND V(o6_1_3) AT=1151.000000p
.measure tran VK6_1_4W2 FIND V(o6_1_4) AT=1151.000000p
.measure tran VK6_1_5W2 FIND V(o6_1_5) AT=1151.000000p
.measure tran VK6_1_6W2 FIND V(o6_1_6) AT=1151.000000p
.measure tran VK6_1_7W2 FIND V(o6_1_7) AT=1151.000000p
.measure tran VK6_2_0W2 FIND V(o6_2_0) AT=1151.000000p
.measure tran VK6_2_1W2 FIND V(o6_2_1) AT=1151.000000p
.measure tran VK6_2_2W2 FIND V(o6_2_2) AT=1151.000000p
.measure tran VK6_2_3W2 FIND V(o6_2_3) AT=1151.000000p
.measure tran VK6_2_4W2 FIND V(o6_2_4) AT=1151.000000p
.measure tran VK6_2_5W2 FIND V(o6_2_5) AT=1151.000000p
.measure tran VK6_2_6W2 FIND V(o6_2_6) AT=1151.000000p
.measure tran VK6_2_7W2 FIND V(o6_2_7) AT=1151.000000p
.measure tran VK6_3_0W2 FIND V(o6_3_0) AT=1151.000000p
.measure tran VK6_3_1W2 FIND V(o6_3_1) AT=1151.000000p
.measure tran VK6_3_2W2 FIND V(o6_3_2) AT=1151.000000p
.measure tran VK6_3_3W2 FIND V(o6_3_3) AT=1151.000000p
.measure tran VK6_3_4W2 FIND V(o6_3_4) AT=1151.000000p
.measure tran VK6_3_5W2 FIND V(o6_3_5) AT=1151.000000p
.measure tran VK6_3_6W2 FIND V(o6_3_6) AT=1151.000000p
.measure tran VK6_3_7W2 FIND V(o6_3_7) AT=1151.000000p
.measure tran VRK1W3 FIND V(ph1) AT=967.000000p
.measure tran VK1_1_0W3 FIND V(o1_1_0) AT=967.000000p
.measure tran VK1_1_1W3 FIND V(o1_1_1) AT=967.000000p
.measure tran VK1_1_2W3 FIND V(o1_1_2) AT=967.000000p
.measure tran VK1_1_3W3 FIND V(o1_1_3) AT=967.000000p
.measure tran VK1_1_4W3 FIND V(o1_1_4) AT=967.000000p
.measure tran VK1_1_5W3 FIND V(o1_1_5) AT=967.000000p
.measure tran VK1_1_6W3 FIND V(o1_1_6) AT=967.000000p
.measure tran VK1_1_7W3 FIND V(o1_1_7) AT=967.000000p
.measure tran VK1_2_0W3 FIND V(o1_2_0) AT=967.000000p
.measure tran VK1_2_1W3 FIND V(o1_2_1) AT=967.000000p
.measure tran VK1_2_2W3 FIND V(o1_2_2) AT=967.000000p
.measure tran VK1_2_3W3 FIND V(o1_2_3) AT=967.000000p
.measure tran VK1_2_4W3 FIND V(o1_2_4) AT=967.000000p
.measure tran VK1_2_5W3 FIND V(o1_2_5) AT=967.000000p
.measure tran VK1_2_6W3 FIND V(o1_2_6) AT=967.000000p
.measure tran VK1_2_7W3 FIND V(o1_2_7) AT=967.000000p
.measure tran VK1_3_0W3 FIND V(o1_3_0) AT=967.000000p
.measure tran VK1_3_1W3 FIND V(o1_3_1) AT=967.000000p
.measure tran VK1_3_2W3 FIND V(o1_3_2) AT=967.000000p
.measure tran VK1_3_3W3 FIND V(o1_3_3) AT=967.000000p
.measure tran VK1_3_4W3 FIND V(o1_3_4) AT=967.000000p
.measure tran VK1_3_5W3 FIND V(o1_3_5) AT=967.000000p
.measure tran VK1_3_6W3 FIND V(o1_3_6) AT=967.000000p
.measure tran VK1_3_7W3 FIND V(o1_3_7) AT=967.000000p
.measure tran VRK2W3 FIND V(ph2) AT=1059.000000p
.measure tran VK2_1_0W3 FIND V(o2_1_0) AT=1059.000000p
.measure tran VK2_1_1W3 FIND V(o2_1_1) AT=1059.000000p
.measure tran VK2_1_2W3 FIND V(o2_1_2) AT=1059.000000p
.measure tran VK2_1_3W3 FIND V(o2_1_3) AT=1059.000000p
.measure tran VK2_1_4W3 FIND V(o2_1_4) AT=1059.000000p
.measure tran VK2_1_5W3 FIND V(o2_1_5) AT=1059.000000p
.measure tran VK2_1_6W3 FIND V(o2_1_6) AT=1059.000000p
.measure tran VK2_1_7W3 FIND V(o2_1_7) AT=1059.000000p
.measure tran VK2_2_0W3 FIND V(o2_2_0) AT=1059.000000p
.measure tran VK2_2_1W3 FIND V(o2_2_1) AT=1059.000000p
.measure tran VK2_2_2W3 FIND V(o2_2_2) AT=1059.000000p
.measure tran VK2_2_3W3 FIND V(o2_2_3) AT=1059.000000p
.measure tran VK2_2_4W3 FIND V(o2_2_4) AT=1059.000000p
.measure tran VK2_2_5W3 FIND V(o2_2_5) AT=1059.000000p
.measure tran VK2_2_6W3 FIND V(o2_2_6) AT=1059.000000p
.measure tran VK2_2_7W3 FIND V(o2_2_7) AT=1059.000000p
.measure tran VK2_3_0W3 FIND V(o2_3_0) AT=1059.000000p
.measure tran VK2_3_1W3 FIND V(o2_3_1) AT=1059.000000p
.measure tran VK2_3_2W3 FIND V(o2_3_2) AT=1059.000000p
.measure tran VK2_3_3W3 FIND V(o2_3_3) AT=1059.000000p
.measure tran VK2_3_4W3 FIND V(o2_3_4) AT=1059.000000p
.measure tran VK2_3_5W3 FIND V(o2_3_5) AT=1059.000000p
.measure tran VK2_3_6W3 FIND V(o2_3_6) AT=1059.000000p
.measure tran VK2_3_7W3 FIND V(o2_3_7) AT=1059.000000p
.measure tran VRK3W3 FIND V(ph3) AT=1151.000000p
.measure tran VK3_1_0W3 FIND V(o3_1_0) AT=1151.000000p
.measure tran VK3_1_1W3 FIND V(o3_1_1) AT=1151.000000p
.measure tran VK3_1_2W3 FIND V(o3_1_2) AT=1151.000000p
.measure tran VK3_1_3W3 FIND V(o3_1_3) AT=1151.000000p
.measure tran VK3_1_4W3 FIND V(o3_1_4) AT=1151.000000p
.measure tran VK3_1_5W3 FIND V(o3_1_5) AT=1151.000000p
.measure tran VK3_1_6W3 FIND V(o3_1_6) AT=1151.000000p
.measure tran VK3_1_7W3 FIND V(o3_1_7) AT=1151.000000p
.measure tran VK3_2_0W3 FIND V(o3_2_0) AT=1151.000000p
.measure tran VK3_2_1W3 FIND V(o3_2_1) AT=1151.000000p
.measure tran VK3_2_2W3 FIND V(o3_2_2) AT=1151.000000p
.measure tran VK3_2_3W3 FIND V(o3_2_3) AT=1151.000000p
.measure tran VK3_2_4W3 FIND V(o3_2_4) AT=1151.000000p
.measure tran VK3_2_5W3 FIND V(o3_2_5) AT=1151.000000p
.measure tran VK3_2_6W3 FIND V(o3_2_6) AT=1151.000000p
.measure tran VK3_2_7W3 FIND V(o3_2_7) AT=1151.000000p
.measure tran VK3_3_0W3 FIND V(o3_3_0) AT=1151.000000p
.measure tran VK3_3_1W3 FIND V(o3_3_1) AT=1151.000000p
.measure tran VK3_3_2W3 FIND V(o3_3_2) AT=1151.000000p
.measure tran VK3_3_3W3 FIND V(o3_3_3) AT=1151.000000p
.measure tran VK3_3_4W3 FIND V(o3_3_4) AT=1151.000000p
.measure tran VK3_3_5W3 FIND V(o3_3_5) AT=1151.000000p
.measure tran VK3_3_6W3 FIND V(o3_3_6) AT=1151.000000p
.measure tran VK3_3_7W3 FIND V(o3_3_7) AT=1151.000000p
.measure tran VRK4W3 FIND V(ph4) AT=1243.000000p
.measure tran VK4_1_0W3 FIND V(o4_1_0) AT=1243.000000p
.measure tran VK4_1_1W3 FIND V(o4_1_1) AT=1243.000000p
.measure tran VK4_1_2W3 FIND V(o4_1_2) AT=1243.000000p
.measure tran VK4_1_3W3 FIND V(o4_1_3) AT=1243.000000p
.measure tran VK4_1_4W3 FIND V(o4_1_4) AT=1243.000000p
.measure tran VK4_1_5W3 FIND V(o4_1_5) AT=1243.000000p
.measure tran VK4_1_6W3 FIND V(o4_1_6) AT=1243.000000p
.measure tran VK4_1_7W3 FIND V(o4_1_7) AT=1243.000000p
.measure tran VK4_2_0W3 FIND V(o4_2_0) AT=1243.000000p
.measure tran VK4_2_1W3 FIND V(o4_2_1) AT=1243.000000p
.measure tran VK4_2_2W3 FIND V(o4_2_2) AT=1243.000000p
.measure tran VK4_2_3W3 FIND V(o4_2_3) AT=1243.000000p
.measure tran VK4_2_4W3 FIND V(o4_2_4) AT=1243.000000p
.measure tran VK4_2_5W3 FIND V(o4_2_5) AT=1243.000000p
.measure tran VK4_2_6W3 FIND V(o4_2_6) AT=1243.000000p
.measure tran VK4_2_7W3 FIND V(o4_2_7) AT=1243.000000p
.measure tran VK4_3_0W3 FIND V(o4_3_0) AT=1243.000000p
.measure tran VK4_3_1W3 FIND V(o4_3_1) AT=1243.000000p
.measure tran VK4_3_2W3 FIND V(o4_3_2) AT=1243.000000p
.measure tran VK4_3_3W3 FIND V(o4_3_3) AT=1243.000000p
.measure tran VK4_3_4W3 FIND V(o4_3_4) AT=1243.000000p
.measure tran VK4_3_5W3 FIND V(o4_3_5) AT=1243.000000p
.measure tran VK4_3_6W3 FIND V(o4_3_6) AT=1243.000000p
.measure tran VK4_3_7W3 FIND V(o4_3_7) AT=1243.000000p
.measure tran VRK5W3 FIND V(ph5) AT=1335.000000p
.measure tran VK5_1_0W3 FIND V(o5_1_0) AT=1335.000000p
.measure tran VK5_1_1W3 FIND V(o5_1_1) AT=1335.000000p
.measure tran VK5_1_2W3 FIND V(o5_1_2) AT=1335.000000p
.measure tran VK5_1_3W3 FIND V(o5_1_3) AT=1335.000000p
.measure tran VK5_1_4W3 FIND V(o5_1_4) AT=1335.000000p
.measure tran VK5_1_5W3 FIND V(o5_1_5) AT=1335.000000p
.measure tran VK5_1_6W3 FIND V(o5_1_6) AT=1335.000000p
.measure tran VK5_1_7W3 FIND V(o5_1_7) AT=1335.000000p
.measure tran VK5_2_0W3 FIND V(o5_2_0) AT=1335.000000p
.measure tran VK5_2_1W3 FIND V(o5_2_1) AT=1335.000000p
.measure tran VK5_2_2W3 FIND V(o5_2_2) AT=1335.000000p
.measure tran VK5_2_3W3 FIND V(o5_2_3) AT=1335.000000p
.measure tran VK5_2_4W3 FIND V(o5_2_4) AT=1335.000000p
.measure tran VK5_2_5W3 FIND V(o5_2_5) AT=1335.000000p
.measure tran VK5_2_6W3 FIND V(o5_2_6) AT=1335.000000p
.measure tran VK5_2_7W3 FIND V(o5_2_7) AT=1335.000000p
.measure tran VK5_3_0W3 FIND V(o5_3_0) AT=1335.000000p
.measure tran VK5_3_1W3 FIND V(o5_3_1) AT=1335.000000p
.measure tran VK5_3_2W3 FIND V(o5_3_2) AT=1335.000000p
.measure tran VK5_3_3W3 FIND V(o5_3_3) AT=1335.000000p
.measure tran VK5_3_4W3 FIND V(o5_3_4) AT=1335.000000p
.measure tran VK5_3_5W3 FIND V(o5_3_5) AT=1335.000000p
.measure tran VK5_3_6W3 FIND V(o5_3_6) AT=1335.000000p
.measure tran VK5_3_7W3 FIND V(o5_3_7) AT=1335.000000p
.measure tran VRK6W3 FIND V(ph6) AT=1427.000000p
.measure tran VK6_1_0W3 FIND V(o6_1_0) AT=1427.000000p
.measure tran VK6_1_1W3 FIND V(o6_1_1) AT=1427.000000p
.measure tran VK6_1_2W3 FIND V(o6_1_2) AT=1427.000000p
.measure tran VK6_1_3W3 FIND V(o6_1_3) AT=1427.000000p
.measure tran VK6_1_4W3 FIND V(o6_1_4) AT=1427.000000p
.measure tran VK6_1_5W3 FIND V(o6_1_5) AT=1427.000000p
.measure tran VK6_1_6W3 FIND V(o6_1_6) AT=1427.000000p
.measure tran VK6_1_7W3 FIND V(o6_1_7) AT=1427.000000p
.measure tran VK6_2_0W3 FIND V(o6_2_0) AT=1427.000000p
.measure tran VK6_2_1W3 FIND V(o6_2_1) AT=1427.000000p
.measure tran VK6_2_2W3 FIND V(o6_2_2) AT=1427.000000p
.measure tran VK6_2_3W3 FIND V(o6_2_3) AT=1427.000000p
.measure tran VK6_2_4W3 FIND V(o6_2_4) AT=1427.000000p
.measure tran VK6_2_5W3 FIND V(o6_2_5) AT=1427.000000p
.measure tran VK6_2_6W3 FIND V(o6_2_6) AT=1427.000000p
.measure tran VK6_2_7W3 FIND V(o6_2_7) AT=1427.000000p
.measure tran VK6_3_0W3 FIND V(o6_3_0) AT=1427.000000p
.measure tran VK6_3_1W3 FIND V(o6_3_1) AT=1427.000000p
.measure tran VK6_3_2W3 FIND V(o6_3_2) AT=1427.000000p
.measure tran VK6_3_3W3 FIND V(o6_3_3) AT=1427.000000p
.measure tran VK6_3_4W3 FIND V(o6_3_4) AT=1427.000000p
.measure tran VK6_3_5W3 FIND V(o6_3_5) AT=1427.000000p
.measure tran VK6_3_6W3 FIND V(o6_3_6) AT=1427.000000p
.measure tran VK6_3_7W3 FIND V(o6_3_7) AT=1427.000000p
.measure tran VRK1W4 FIND V(ph1) AT=1243.000000p
.measure tran VK1_1_0W4 FIND V(o1_1_0) AT=1243.000000p
.measure tran VK1_1_1W4 FIND V(o1_1_1) AT=1243.000000p
.measure tran VK1_1_2W4 FIND V(o1_1_2) AT=1243.000000p
.measure tran VK1_1_3W4 FIND V(o1_1_3) AT=1243.000000p
.measure tran VK1_1_4W4 FIND V(o1_1_4) AT=1243.000000p
.measure tran VK1_1_5W4 FIND V(o1_1_5) AT=1243.000000p
.measure tran VK1_1_6W4 FIND V(o1_1_6) AT=1243.000000p
.measure tran VK1_1_7W4 FIND V(o1_1_7) AT=1243.000000p
.measure tran VK1_2_0W4 FIND V(o1_2_0) AT=1243.000000p
.measure tran VK1_2_1W4 FIND V(o1_2_1) AT=1243.000000p
.measure tran VK1_2_2W4 FIND V(o1_2_2) AT=1243.000000p
.measure tran VK1_2_3W4 FIND V(o1_2_3) AT=1243.000000p
.measure tran VK1_2_4W4 FIND V(o1_2_4) AT=1243.000000p
.measure tran VK1_2_5W4 FIND V(o1_2_5) AT=1243.000000p
.measure tran VK1_2_6W4 FIND V(o1_2_6) AT=1243.000000p
.measure tran VK1_2_7W4 FIND V(o1_2_7) AT=1243.000000p
.measure tran VK1_3_0W4 FIND V(o1_3_0) AT=1243.000000p
.measure tran VK1_3_1W4 FIND V(o1_3_1) AT=1243.000000p
.measure tran VK1_3_2W4 FIND V(o1_3_2) AT=1243.000000p
.measure tran VK1_3_3W4 FIND V(o1_3_3) AT=1243.000000p
.measure tran VK1_3_4W4 FIND V(o1_3_4) AT=1243.000000p
.measure tran VK1_3_5W4 FIND V(o1_3_5) AT=1243.000000p
.measure tran VK1_3_6W4 FIND V(o1_3_6) AT=1243.000000p
.measure tran VK1_3_7W4 FIND V(o1_3_7) AT=1243.000000p
.measure tran VRK2W4 FIND V(ph2) AT=1335.000000p
.measure tran VK2_1_0W4 FIND V(o2_1_0) AT=1335.000000p
.measure tran VK2_1_1W4 FIND V(o2_1_1) AT=1335.000000p
.measure tran VK2_1_2W4 FIND V(o2_1_2) AT=1335.000000p
.measure tran VK2_1_3W4 FIND V(o2_1_3) AT=1335.000000p
.measure tran VK2_1_4W4 FIND V(o2_1_4) AT=1335.000000p
.measure tran VK2_1_5W4 FIND V(o2_1_5) AT=1335.000000p
.measure tran VK2_1_6W4 FIND V(o2_1_6) AT=1335.000000p
.measure tran VK2_1_7W4 FIND V(o2_1_7) AT=1335.000000p
.measure tran VK2_2_0W4 FIND V(o2_2_0) AT=1335.000000p
.measure tran VK2_2_1W4 FIND V(o2_2_1) AT=1335.000000p
.measure tran VK2_2_2W4 FIND V(o2_2_2) AT=1335.000000p
.measure tran VK2_2_3W4 FIND V(o2_2_3) AT=1335.000000p
.measure tran VK2_2_4W4 FIND V(o2_2_4) AT=1335.000000p
.measure tran VK2_2_5W4 FIND V(o2_2_5) AT=1335.000000p
.measure tran VK2_2_6W4 FIND V(o2_2_6) AT=1335.000000p
.measure tran VK2_2_7W4 FIND V(o2_2_7) AT=1335.000000p
.measure tran VK2_3_0W4 FIND V(o2_3_0) AT=1335.000000p
.measure tran VK2_3_1W4 FIND V(o2_3_1) AT=1335.000000p
.measure tran VK2_3_2W4 FIND V(o2_3_2) AT=1335.000000p
.measure tran VK2_3_3W4 FIND V(o2_3_3) AT=1335.000000p
.measure tran VK2_3_4W4 FIND V(o2_3_4) AT=1335.000000p
.measure tran VK2_3_5W4 FIND V(o2_3_5) AT=1335.000000p
.measure tran VK2_3_6W4 FIND V(o2_3_6) AT=1335.000000p
.measure tran VK2_3_7W4 FIND V(o2_3_7) AT=1335.000000p
.measure tran VRK3W4 FIND V(ph3) AT=1427.000000p
.measure tran VK3_1_0W4 FIND V(o3_1_0) AT=1427.000000p
.measure tran VK3_1_1W4 FIND V(o3_1_1) AT=1427.000000p
.measure tran VK3_1_2W4 FIND V(o3_1_2) AT=1427.000000p
.measure tran VK3_1_3W4 FIND V(o3_1_3) AT=1427.000000p
.measure tran VK3_1_4W4 FIND V(o3_1_4) AT=1427.000000p
.measure tran VK3_1_5W4 FIND V(o3_1_5) AT=1427.000000p
.measure tran VK3_1_6W4 FIND V(o3_1_6) AT=1427.000000p
.measure tran VK3_1_7W4 FIND V(o3_1_7) AT=1427.000000p
.measure tran VK3_2_0W4 FIND V(o3_2_0) AT=1427.000000p
.measure tran VK3_2_1W4 FIND V(o3_2_1) AT=1427.000000p
.measure tran VK3_2_2W4 FIND V(o3_2_2) AT=1427.000000p
.measure tran VK3_2_3W4 FIND V(o3_2_3) AT=1427.000000p
.measure tran VK3_2_4W4 FIND V(o3_2_4) AT=1427.000000p
.measure tran VK3_2_5W4 FIND V(o3_2_5) AT=1427.000000p
.measure tran VK3_2_6W4 FIND V(o3_2_6) AT=1427.000000p
.measure tran VK3_2_7W4 FIND V(o3_2_7) AT=1427.000000p
.measure tran VK3_3_0W4 FIND V(o3_3_0) AT=1427.000000p
.measure tran VK3_3_1W4 FIND V(o3_3_1) AT=1427.000000p
.measure tran VK3_3_2W4 FIND V(o3_3_2) AT=1427.000000p
.measure tran VK3_3_3W4 FIND V(o3_3_3) AT=1427.000000p
.measure tran VK3_3_4W4 FIND V(o3_3_4) AT=1427.000000p
.measure tran VK3_3_5W4 FIND V(o3_3_5) AT=1427.000000p
.measure tran VK3_3_6W4 FIND V(o3_3_6) AT=1427.000000p
.measure tran VK3_3_7W4 FIND V(o3_3_7) AT=1427.000000p
.measure tran VRK4W4 FIND V(ph4) AT=1519.000000p
.measure tran VK4_1_0W4 FIND V(o4_1_0) AT=1519.000000p
.measure tran VK4_1_1W4 FIND V(o4_1_1) AT=1519.000000p
.measure tran VK4_1_2W4 FIND V(o4_1_2) AT=1519.000000p
.measure tran VK4_1_3W4 FIND V(o4_1_3) AT=1519.000000p
.measure tran VK4_1_4W4 FIND V(o4_1_4) AT=1519.000000p
.measure tran VK4_1_5W4 FIND V(o4_1_5) AT=1519.000000p
.measure tran VK4_1_6W4 FIND V(o4_1_6) AT=1519.000000p
.measure tran VK4_1_7W4 FIND V(o4_1_7) AT=1519.000000p
.measure tran VK4_2_0W4 FIND V(o4_2_0) AT=1519.000000p
.measure tran VK4_2_1W4 FIND V(o4_2_1) AT=1519.000000p
.measure tran VK4_2_2W4 FIND V(o4_2_2) AT=1519.000000p
.measure tran VK4_2_3W4 FIND V(o4_2_3) AT=1519.000000p
.measure tran VK4_2_4W4 FIND V(o4_2_4) AT=1519.000000p
.measure tran VK4_2_5W4 FIND V(o4_2_5) AT=1519.000000p
.measure tran VK4_2_6W4 FIND V(o4_2_6) AT=1519.000000p
.measure tran VK4_2_7W4 FIND V(o4_2_7) AT=1519.000000p
.measure tran VK4_3_0W4 FIND V(o4_3_0) AT=1519.000000p
.measure tran VK4_3_1W4 FIND V(o4_3_1) AT=1519.000000p
.measure tran VK4_3_2W4 FIND V(o4_3_2) AT=1519.000000p
.measure tran VK4_3_3W4 FIND V(o4_3_3) AT=1519.000000p
.measure tran VK4_3_4W4 FIND V(o4_3_4) AT=1519.000000p
.measure tran VK4_3_5W4 FIND V(o4_3_5) AT=1519.000000p
.measure tran VK4_3_6W4 FIND V(o4_3_6) AT=1519.000000p
.measure tran VK4_3_7W4 FIND V(o4_3_7) AT=1519.000000p
.measure tran VRK5W4 FIND V(ph5) AT=1611.000000p
.measure tran VK5_1_0W4 FIND V(o5_1_0) AT=1611.000000p
.measure tran VK5_1_1W4 FIND V(o5_1_1) AT=1611.000000p
.measure tran VK5_1_2W4 FIND V(o5_1_2) AT=1611.000000p
.measure tran VK5_1_3W4 FIND V(o5_1_3) AT=1611.000000p
.measure tran VK5_1_4W4 FIND V(o5_1_4) AT=1611.000000p
.measure tran VK5_1_5W4 FIND V(o5_1_5) AT=1611.000000p
.measure tran VK5_1_6W4 FIND V(o5_1_6) AT=1611.000000p
.measure tran VK5_1_7W4 FIND V(o5_1_7) AT=1611.000000p
.measure tran VK5_2_0W4 FIND V(o5_2_0) AT=1611.000000p
.measure tran VK5_2_1W4 FIND V(o5_2_1) AT=1611.000000p
.measure tran VK5_2_2W4 FIND V(o5_2_2) AT=1611.000000p
.measure tran VK5_2_3W4 FIND V(o5_2_3) AT=1611.000000p
.measure tran VK5_2_4W4 FIND V(o5_2_4) AT=1611.000000p
.measure tran VK5_2_5W4 FIND V(o5_2_5) AT=1611.000000p
.measure tran VK5_2_6W4 FIND V(o5_2_6) AT=1611.000000p
.measure tran VK5_2_7W4 FIND V(o5_2_7) AT=1611.000000p
.measure tran VK5_3_0W4 FIND V(o5_3_0) AT=1611.000000p
.measure tran VK5_3_1W4 FIND V(o5_3_1) AT=1611.000000p
.measure tran VK5_3_2W4 FIND V(o5_3_2) AT=1611.000000p
.measure tran VK5_3_3W4 FIND V(o5_3_3) AT=1611.000000p
.measure tran VK5_3_4W4 FIND V(o5_3_4) AT=1611.000000p
.measure tran VK5_3_5W4 FIND V(o5_3_5) AT=1611.000000p
.measure tran VK5_3_6W4 FIND V(o5_3_6) AT=1611.000000p
.measure tran VK5_3_7W4 FIND V(o5_3_7) AT=1611.000000p
.measure tran VRK6W4 FIND V(ph6) AT=1703.000000p
.measure tran VK6_1_0W4 FIND V(o6_1_0) AT=1703.000000p
.measure tran VK6_1_1W4 FIND V(o6_1_1) AT=1703.000000p
.measure tran VK6_1_2W4 FIND V(o6_1_2) AT=1703.000000p
.measure tran VK6_1_3W4 FIND V(o6_1_3) AT=1703.000000p
.measure tran VK6_1_4W4 FIND V(o6_1_4) AT=1703.000000p
.measure tran VK6_1_5W4 FIND V(o6_1_5) AT=1703.000000p
.measure tran VK6_1_6W4 FIND V(o6_1_6) AT=1703.000000p
.measure tran VK6_1_7W4 FIND V(o6_1_7) AT=1703.000000p
.measure tran VK6_2_0W4 FIND V(o6_2_0) AT=1703.000000p
.measure tran VK6_2_1W4 FIND V(o6_2_1) AT=1703.000000p
.measure tran VK6_2_2W4 FIND V(o6_2_2) AT=1703.000000p
.measure tran VK6_2_3W4 FIND V(o6_2_3) AT=1703.000000p
.measure tran VK6_2_4W4 FIND V(o6_2_4) AT=1703.000000p
.measure tran VK6_2_5W4 FIND V(o6_2_5) AT=1703.000000p
.measure tran VK6_2_6W4 FIND V(o6_2_6) AT=1703.000000p
.measure tran VK6_2_7W4 FIND V(o6_2_7) AT=1703.000000p
.measure tran VK6_3_0W4 FIND V(o6_3_0) AT=1703.000000p
.measure tran VK6_3_1W4 FIND V(o6_3_1) AT=1703.000000p
.measure tran VK6_3_2W4 FIND V(o6_3_2) AT=1703.000000p
.measure tran VK6_3_3W4 FIND V(o6_3_3) AT=1703.000000p
.measure tran VK6_3_4W4 FIND V(o6_3_4) AT=1703.000000p
.measure tran VK6_3_5W4 FIND V(o6_3_5) AT=1703.000000p
.measure tran VK6_3_6W4 FIND V(o6_3_6) AT=1703.000000p
.measure tran VK6_3_7W4 FIND V(o6_3_7) AT=1703.000000p
.measure tran QPH1T2 FIND V(xqph1) AT=553.000000p
.measure tran EPH1T2 FIND V(xeph1) AT=553.000000p
.measure tran QPH1R2 FIND V(xqph1) AT=645.000000p
.measure tran EPH1R2 FIND V(xeph1) AT=645.000000p
.measure tran QPH1H2 FIND V(xqph1) AT=737.000000p
.measure tran EPH1H2 FIND V(xeph1) AT=737.000000p
.measure tran QPH1T3 FIND V(xqph1) AT=829.000000p
.measure tran EPH1T3 FIND V(xeph1) AT=829.000000p
.measure tran QPH1R3 FIND V(xqph1) AT=921.000000p
.measure tran EPH1R3 FIND V(xeph1) AT=921.000000p
.measure tran QPH1H3 FIND V(xqph1) AT=1013.000000p
.measure tran EPH1H3 FIND V(xeph1) AT=1013.000000p
.measure tran QPH1T4 FIND V(xqph1) AT=1105.000000p
.measure tran EPH1T4 FIND V(xeph1) AT=1105.000000p
.measure tran QPH1R4 FIND V(xqph1) AT=1197.000000p
.measure tran EPH1R4 FIND V(xeph1) AT=1197.000000p
.measure tran QPH1H4 FIND V(xqph1) AT=1289.000000p
.measure tran EPH1H4 FIND V(xeph1) AT=1289.000000p
.measure tran QPH1T5 FIND V(xqph1) AT=1381.000000p
.measure tran EPH1T5 FIND V(xeph1) AT=1381.000000p
.measure tran QPH2T2 FIND V(xqph2) AT=645.000000p
.measure tran EPH2T2 FIND V(xeph2) AT=645.000000p
.measure tran QPH2R2 FIND V(xqph2) AT=737.000000p
.measure tran EPH2R2 FIND V(xeph2) AT=737.000000p
.measure tran QPH2H2 FIND V(xqph2) AT=829.000000p
.measure tran EPH2H2 FIND V(xeph2) AT=829.000000p
.measure tran QPH2T3 FIND V(xqph2) AT=921.000000p
.measure tran EPH2T3 FIND V(xeph2) AT=921.000000p
.measure tran QPH2R3 FIND V(xqph2) AT=1013.000000p
.measure tran EPH2R3 FIND V(xeph2) AT=1013.000000p
.measure tran QPH2H3 FIND V(xqph2) AT=1105.000000p
.measure tran EPH2H3 FIND V(xeph2) AT=1105.000000p
.measure tran QPH2T4 FIND V(xqph2) AT=1197.000000p
.measure tran EPH2T4 FIND V(xeph2) AT=1197.000000p
.measure tran QPH2R4 FIND V(xqph2) AT=1289.000000p
.measure tran EPH2R4 FIND V(xeph2) AT=1289.000000p
.measure tran QPH2H4 FIND V(xqph2) AT=1381.000000p
.measure tran EPH2H4 FIND V(xeph2) AT=1381.000000p
.measure tran QPH2T5 FIND V(xqph2) AT=1473.000000p
.measure tran EPH2T5 FIND V(xeph2) AT=1473.000000p
.measure tran QPH3T2 FIND V(xqph3) AT=737.000000p
.measure tran EPH3T2 FIND V(xeph3) AT=737.000000p
.measure tran QPH3R2 FIND V(xqph3) AT=829.000000p
.measure tran EPH3R2 FIND V(xeph3) AT=829.000000p
.measure tran QPH3H2 FIND V(xqph3) AT=921.000000p
.measure tran EPH3H2 FIND V(xeph3) AT=921.000000p
.measure tran QPH3T3 FIND V(xqph3) AT=1013.000000p
.measure tran EPH3T3 FIND V(xeph3) AT=1013.000000p
.measure tran QPH3R3 FIND V(xqph3) AT=1105.000000p
.measure tran EPH3R3 FIND V(xeph3) AT=1105.000000p
.measure tran QPH3H3 FIND V(xqph3) AT=1197.000000p
.measure tran EPH3H3 FIND V(xeph3) AT=1197.000000p
.measure tran QPH3T4 FIND V(xqph3) AT=1289.000000p
.measure tran EPH3T4 FIND V(xeph3) AT=1289.000000p
.measure tran QPH3R4 FIND V(xqph3) AT=1381.000000p
.measure tran EPH3R4 FIND V(xeph3) AT=1381.000000p
.measure tran QPH3H4 FIND V(xqph3) AT=1473.000000p
.measure tran EPH3H4 FIND V(xeph3) AT=1473.000000p
.measure tran QPH3T5 FIND V(xqph3) AT=1565.000000p
.measure tran EPH3T5 FIND V(xeph3) AT=1565.000000p
.measure tran QPH4T2 FIND V(xqph4) AT=829.000000p
.measure tran EPH4T2 FIND V(xeph4) AT=829.000000p
.measure tran QPH4R2 FIND V(xqph4) AT=921.000000p
.measure tran EPH4R2 FIND V(xeph4) AT=921.000000p
.measure tran QPH4H2 FIND V(xqph4) AT=1013.000000p
.measure tran EPH4H2 FIND V(xeph4) AT=1013.000000p
.measure tran QPH4T3 FIND V(xqph4) AT=1105.000000p
.measure tran EPH4T3 FIND V(xeph4) AT=1105.000000p
.measure tran QPH4R3 FIND V(xqph4) AT=1197.000000p
.measure tran EPH4R3 FIND V(xeph4) AT=1197.000000p
.measure tran QPH4H3 FIND V(xqph4) AT=1289.000000p
.measure tran EPH4H3 FIND V(xeph4) AT=1289.000000p
.measure tran QPH4T4 FIND V(xqph4) AT=1381.000000p
.measure tran EPH4T4 FIND V(xeph4) AT=1381.000000p
.measure tran QPH4R4 FIND V(xqph4) AT=1473.000000p
.measure tran EPH4R4 FIND V(xeph4) AT=1473.000000p
.measure tran QPH4H4 FIND V(xqph4) AT=1565.000000p
.measure tran EPH4H4 FIND V(xeph4) AT=1565.000000p
.measure tran QPH4T5 FIND V(xqph4) AT=1657.000000p
.measure tran EPH4T5 FIND V(xeph4) AT=1657.000000p
.measure tran QPH5T2 FIND V(xqph5) AT=921.000000p
.measure tran EPH5T2 FIND V(xeph5) AT=921.000000p
.measure tran QPH5R2 FIND V(xqph5) AT=1013.000000p
.measure tran EPH5R2 FIND V(xeph5) AT=1013.000000p
.measure tran QPH5H2 FIND V(xqph5) AT=1105.000000p
.measure tran EPH5H2 FIND V(xeph5) AT=1105.000000p
.measure tran QPH5T3 FIND V(xqph5) AT=1197.000000p
.measure tran EPH5T3 FIND V(xeph5) AT=1197.000000p
.measure tran QPH5R3 FIND V(xqph5) AT=1289.000000p
.measure tran EPH5R3 FIND V(xeph5) AT=1289.000000p
.measure tran QPH5H3 FIND V(xqph5) AT=1381.000000p
.measure tran EPH5H3 FIND V(xeph5) AT=1381.000000p
.measure tran QPH5T4 FIND V(xqph5) AT=1473.000000p
.measure tran EPH5T4 FIND V(xeph5) AT=1473.000000p
.measure tran QPH5R4 FIND V(xqph5) AT=1565.000000p
.measure tran EPH5R4 FIND V(xeph5) AT=1565.000000p
.measure tran QPH5H4 FIND V(xqph5) AT=1657.000000p
.measure tran EPH5H4 FIND V(xeph5) AT=1657.000000p
.measure tran QPH5T5 FIND V(xqph5) AT=1749.000000p
.measure tran EPH5T5 FIND V(xeph5) AT=1749.000000p
.measure tran QPH6T2 FIND V(xqph6) AT=1013.000000p
.measure tran EPH6T2 FIND V(xeph6) AT=1013.000000p
.measure tran QPH6R2 FIND V(xqph6) AT=1105.000000p
.measure tran EPH6R2 FIND V(xeph6) AT=1105.000000p
.measure tran QPH6H2 FIND V(xqph6) AT=1197.000000p
.measure tran EPH6H2 FIND V(xeph6) AT=1197.000000p
.measure tran QPH6T3 FIND V(xqph6) AT=1289.000000p
.measure tran EPH6T3 FIND V(xeph6) AT=1289.000000p
.measure tran QPH6R3 FIND V(xqph6) AT=1381.000000p
.measure tran EPH6R3 FIND V(xeph6) AT=1381.000000p
.measure tran QPH6H3 FIND V(xqph6) AT=1473.000000p
.measure tran EPH6H3 FIND V(xeph6) AT=1473.000000p
.measure tran QPH6T4 FIND V(xqph6) AT=1565.000000p
.measure tran EPH6T4 FIND V(xeph6) AT=1565.000000p
.measure tran QPH6R4 FIND V(xqph6) AT=1657.000000p
.measure tran EPH6R4 FIND V(xeph6) AT=1657.000000p
.measure tran QPH6H4 FIND V(xqph6) AT=1749.000000p
.measure tran EPH6H4 FIND V(xeph6) AT=1749.000000p
.measure tran QPH6T5 FIND V(xqph6) AT=1841.000000p
.measure tran EPH6T5 FIND V(xeph6) AT=1841.000000p
.measure tran IL_T2 FIND I(L1) AT=553.000000p
.measure tran QDD_T2 FIND V(xqdd) AT=553.000000p
.measure tran QZR_T2 FIND V(xqzr) AT=553.000000p
.measure tran ERL_T2 FIND V(xerl) AT=553.000000p
.measure tran ESW_T2 FIND V(xesw) AT=553.000000p
.measure tran IL_T3 FIND I(L1) AT=829.000000p
.measure tran QDD_T3 FIND V(xqdd) AT=829.000000p
.measure tran QZR_T3 FIND V(xqzr) AT=829.000000p
.measure tran ERL_T3 FIND V(xerl) AT=829.000000p
.measure tran ESW_T3 FIND V(xesw) AT=829.000000p
.measure tran IL_T4 FIND I(L1) AT=1105.000000p
.measure tran QDD_T4 FIND V(xqdd) AT=1105.000000p
.measure tran QZR_T4 FIND V(xqzr) AT=1105.000000p
.measure tran ERL_T4 FIND V(xerl) AT=1105.000000p
.measure tran ESW_T4 FIND V(xesw) AT=1105.000000p
.measure tran IL_T5 FIND I(L1) AT=1381.000000p
.measure tran QDD_T5 FIND V(xqdd) AT=1381.000000p
.measure tran QZR_T5 FIND V(xqzr) AT=1381.000000p
.measure tran ERL_T5 FIND V(xerl) AT=1381.000000p
.measure tran ESW_T5 FIND V(xesw) AT=1381.000000p
.measure tran VRK7W2 FIND V(ph7) AT=691.000000p
.measure tran VK7_3_0W2 FIND V(o7_3_0) AT=691.000000p
.measure tran VK7_3_1W2 FIND V(o7_3_1) AT=691.000000p
.measure tran VK7_3_2W2 FIND V(o7_3_2) AT=691.000000p
.measure tran VK7_3_3W2 FIND V(o7_3_3) AT=691.000000p
.measure tran VK7_3_4W2 FIND V(o7_3_4) AT=691.000000p
.measure tran VK7_3_5W2 FIND V(o7_3_5) AT=691.000000p
.measure tran VK7_3_6W2 FIND V(o7_3_6) AT=691.000000p
.measure tran VK7_3_7W2 FIND V(o7_3_7) AT=691.000000p
.measure tran VRK7W3 FIND V(ph7) AT=967.000000p
.measure tran VK7_3_0W3 FIND V(o7_3_0) AT=967.000000p
.measure tran VK7_3_1W3 FIND V(o7_3_1) AT=967.000000p
.measure tran VK7_3_2W3 FIND V(o7_3_2) AT=967.000000p
.measure tran VK7_3_3W3 FIND V(o7_3_3) AT=967.000000p
.measure tran VK7_3_4W3 FIND V(o7_3_4) AT=967.000000p
.measure tran VK7_3_5W3 FIND V(o7_3_5) AT=967.000000p
.measure tran VK7_3_6W3 FIND V(o7_3_6) AT=967.000000p
.measure tran VK7_3_7W3 FIND V(o7_3_7) AT=967.000000p
.measure tran VRK7W4 FIND V(ph7) AT=1243.000000p
.measure tran VK7_3_0W4 FIND V(o7_3_0) AT=1243.000000p
.measure tran VK7_3_1W4 FIND V(o7_3_1) AT=1243.000000p
.measure tran VK7_3_2W4 FIND V(o7_3_2) AT=1243.000000p
.measure tran VK7_3_3W4 FIND V(o7_3_3) AT=1243.000000p
.measure tran VK7_3_4W4 FIND V(o7_3_4) AT=1243.000000p
.measure tran VK7_3_5W4 FIND V(o7_3_5) AT=1243.000000p
.measure tran VK7_3_6W4 FIND V(o7_3_6) AT=1243.000000p
.measure tran VK7_3_7W4 FIND V(o7_3_7) AT=1243.000000p
.measure tran VRK8W2 FIND V(ph8) AT=783.000000p
.measure tran VK8_3_0W2 FIND V(o8_3_0) AT=783.000000p
.measure tran VK8_3_1W2 FIND V(o8_3_1) AT=783.000000p
.measure tran VK8_3_2W2 FIND V(o8_3_2) AT=783.000000p
.measure tran VK8_3_3W2 FIND V(o8_3_3) AT=783.000000p
.measure tran VK8_3_4W2 FIND V(o8_3_4) AT=783.000000p
.measure tran VK8_3_5W2 FIND V(o8_3_5) AT=783.000000p
.measure tran VK8_3_6W2 FIND V(o8_3_6) AT=783.000000p
.measure tran VK8_3_7W2 FIND V(o8_3_7) AT=783.000000p
.measure tran VRK8W3 FIND V(ph8) AT=1059.000000p
.measure tran VK8_3_0W3 FIND V(o8_3_0) AT=1059.000000p
.measure tran VK8_3_1W3 FIND V(o8_3_1) AT=1059.000000p
.measure tran VK8_3_2W3 FIND V(o8_3_2) AT=1059.000000p
.measure tran VK8_3_3W3 FIND V(o8_3_3) AT=1059.000000p
.measure tran VK8_3_4W3 FIND V(o8_3_4) AT=1059.000000p
.measure tran VK8_3_5W3 FIND V(o8_3_5) AT=1059.000000p
.measure tran VK8_3_6W3 FIND V(o8_3_6) AT=1059.000000p
.measure tran VK8_3_7W3 FIND V(o8_3_7) AT=1059.000000p
.measure tran VRK8W4 FIND V(ph8) AT=1335.000000p
.measure tran VK8_3_0W4 FIND V(o8_3_0) AT=1335.000000p
.measure tran VK8_3_1W4 FIND V(o8_3_1) AT=1335.000000p
.measure tran VK8_3_2W4 FIND V(o8_3_2) AT=1335.000000p
.measure tran VK8_3_3W4 FIND V(o8_3_3) AT=1335.000000p
.measure tran VK8_3_4W4 FIND V(o8_3_4) AT=1335.000000p
.measure tran VK8_3_5W4 FIND V(o8_3_5) AT=1335.000000p
.measure tran VK8_3_6W4 FIND V(o8_3_6) AT=1335.000000p
.measure tran VK8_3_7W4 FIND V(o8_3_7) AT=1335.000000p
.measure tran VRK9W2 FIND V(ph9) AT=875.000000p
.measure tran VK9_3_0W2 FIND V(o9_3_0) AT=875.000000p
.measure tran VK9_3_1W2 FIND V(o9_3_1) AT=875.000000p
.measure tran VK9_3_2W2 FIND V(o9_3_2) AT=875.000000p
.measure tran VK9_3_3W2 FIND V(o9_3_3) AT=875.000000p
.measure tran VK9_3_4W2 FIND V(o9_3_4) AT=875.000000p
.measure tran VK9_3_5W2 FIND V(o9_3_5) AT=875.000000p
.measure tran VK9_3_6W2 FIND V(o9_3_6) AT=875.000000p
.measure tran VK9_3_7W2 FIND V(o9_3_7) AT=875.000000p
.measure tran VRK9W3 FIND V(ph9) AT=1151.000000p
.measure tran VK9_3_0W3 FIND V(o9_3_0) AT=1151.000000p
.measure tran VK9_3_1W3 FIND V(o9_3_1) AT=1151.000000p
.measure tran VK9_3_2W3 FIND V(o9_3_2) AT=1151.000000p
.measure tran VK9_3_3W3 FIND V(o9_3_3) AT=1151.000000p
.measure tran VK9_3_4W3 FIND V(o9_3_4) AT=1151.000000p
.measure tran VK9_3_5W3 FIND V(o9_3_5) AT=1151.000000p
.measure tran VK9_3_6W3 FIND V(o9_3_6) AT=1151.000000p
.measure tran VK9_3_7W3 FIND V(o9_3_7) AT=1151.000000p
.measure tran VRK9W4 FIND V(ph9) AT=1427.000000p
.measure tran VK9_3_0W4 FIND V(o9_3_0) AT=1427.000000p
.measure tran VK9_3_1W4 FIND V(o9_3_1) AT=1427.000000p
.measure tran VK9_3_2W4 FIND V(o9_3_2) AT=1427.000000p
.measure tran VK9_3_3W4 FIND V(o9_3_3) AT=1427.000000p
.measure tran VK9_3_4W4 FIND V(o9_3_4) AT=1427.000000p
.measure tran VK9_3_5W4 FIND V(o9_3_5) AT=1427.000000p
.measure tran VK9_3_6W4 FIND V(o9_3_6) AT=1427.000000p
.measure tran VK9_3_7W4 FIND V(o9_3_7) AT=1427.000000p
.measure tran VRK10W2 FIND V(ph10) AT=967.000000p
.measure tran VK10_3_0W2 FIND V(o10_3_0) AT=967.000000p
.measure tran VK10_3_1W2 FIND V(o10_3_1) AT=967.000000p
.measure tran VK10_3_2W2 FIND V(o10_3_2) AT=967.000000p
.measure tran VK10_3_3W2 FIND V(o10_3_3) AT=967.000000p
.measure tran VK10_3_4W2 FIND V(o10_3_4) AT=967.000000p
.measure tran VK10_3_5W2 FIND V(o10_3_5) AT=967.000000p
.measure tran VK10_3_6W2 FIND V(o10_3_6) AT=967.000000p
.measure tran VK10_3_7W2 FIND V(o10_3_7) AT=967.000000p
.measure tran VRK10W3 FIND V(ph10) AT=1243.000000p
.measure tran VK10_3_0W3 FIND V(o10_3_0) AT=1243.000000p
.measure tran VK10_3_1W3 FIND V(o10_3_1) AT=1243.000000p
.measure tran VK10_3_2W3 FIND V(o10_3_2) AT=1243.000000p
.measure tran VK10_3_3W3 FIND V(o10_3_3) AT=1243.000000p
.measure tran VK10_3_4W3 FIND V(o10_3_4) AT=1243.000000p
.measure tran VK10_3_5W3 FIND V(o10_3_5) AT=1243.000000p
.measure tran VK10_3_6W3 FIND V(o10_3_6) AT=1243.000000p
.measure tran VK10_3_7W3 FIND V(o10_3_7) AT=1243.000000p
.measure tran VRK10W4 FIND V(ph10) AT=1519.000000p
.measure tran VK10_3_0W4 FIND V(o10_3_0) AT=1519.000000p
.measure tran VK10_3_1W4 FIND V(o10_3_1) AT=1519.000000p
.measure tran VK10_3_2W4 FIND V(o10_3_2) AT=1519.000000p
.measure tran VK10_3_3W4 FIND V(o10_3_3) AT=1519.000000p
.measure tran VK10_3_4W4 FIND V(o10_3_4) AT=1519.000000p
.measure tran VK10_3_5W4 FIND V(o10_3_5) AT=1519.000000p
.measure tran VK10_3_6W4 FIND V(o10_3_6) AT=1519.000000p
.measure tran VK10_3_7W4 FIND V(o10_3_7) AT=1519.000000p
.measure tran VRK11W2 FIND V(ph11) AT=1059.000000p
.measure tran VK11_3_0W2 FIND V(o11_3_0) AT=1059.000000p
.measure tran VK11_3_1W2 FIND V(o11_3_1) AT=1059.000000p
.measure tran VK11_3_2W2 FIND V(o11_3_2) AT=1059.000000p
.measure tran VK11_3_3W2 FIND V(o11_3_3) AT=1059.000000p
.measure tran VK11_3_4W2 FIND V(o11_3_4) AT=1059.000000p
.measure tran VK11_3_5W2 FIND V(o11_3_5) AT=1059.000000p
.measure tran VK11_3_6W2 FIND V(o11_3_6) AT=1059.000000p
.measure tran VK11_3_7W2 FIND V(o11_3_7) AT=1059.000000p
.measure tran VRK11W3 FIND V(ph11) AT=1335.000000p
.measure tran VK11_3_0W3 FIND V(o11_3_0) AT=1335.000000p
.measure tran VK11_3_1W3 FIND V(o11_3_1) AT=1335.000000p
.measure tran VK11_3_2W3 FIND V(o11_3_2) AT=1335.000000p
.measure tran VK11_3_3W3 FIND V(o11_3_3) AT=1335.000000p
.measure tran VK11_3_4W3 FIND V(o11_3_4) AT=1335.000000p
.measure tran VK11_3_5W3 FIND V(o11_3_5) AT=1335.000000p
.measure tran VK11_3_6W3 FIND V(o11_3_6) AT=1335.000000p
.measure tran VK11_3_7W3 FIND V(o11_3_7) AT=1335.000000p
.measure tran VRK11W4 FIND V(ph11) AT=1611.000000p
.measure tran VK11_3_0W4 FIND V(o11_3_0) AT=1611.000000p
.measure tran VK11_3_1W4 FIND V(o11_3_1) AT=1611.000000p
.measure tran VK11_3_2W4 FIND V(o11_3_2) AT=1611.000000p
.measure tran VK11_3_3W4 FIND V(o11_3_3) AT=1611.000000p
.measure tran VK11_3_4W4 FIND V(o11_3_4) AT=1611.000000p
.measure tran VK11_3_5W4 FIND V(o11_3_5) AT=1611.000000p
.measure tran VK11_3_6W4 FIND V(o11_3_6) AT=1611.000000p
.measure tran VK11_3_7W4 FIND V(o11_3_7) AT=1611.000000p
.measure tran VRK12W2 FIND V(ph12) AT=1151.000000p
.measure tran VK12_3_0W2 FIND V(o12_3_0) AT=1151.000000p
.measure tran VK12_3_1W2 FIND V(o12_3_1) AT=1151.000000p
.measure tran VK12_3_2W2 FIND V(o12_3_2) AT=1151.000000p
.measure tran VK12_3_3W2 FIND V(o12_3_3) AT=1151.000000p
.measure tran VK12_3_4W2 FIND V(o12_3_4) AT=1151.000000p
.measure tran VK12_3_5W2 FIND V(o12_3_5) AT=1151.000000p
.measure tran VK12_3_6W2 FIND V(o12_3_6) AT=1151.000000p
.measure tran VK12_3_7W2 FIND V(o12_3_7) AT=1151.000000p
.measure tran VRK12W3 FIND V(ph12) AT=1427.000000p
.measure tran VK12_3_0W3 FIND V(o12_3_0) AT=1427.000000p
.measure tran VK12_3_1W3 FIND V(o12_3_1) AT=1427.000000p
.measure tran VK12_3_2W3 FIND V(o12_3_2) AT=1427.000000p
.measure tran VK12_3_3W3 FIND V(o12_3_3) AT=1427.000000p
.measure tran VK12_3_4W3 FIND V(o12_3_4) AT=1427.000000p
.measure tran VK12_3_5W3 FIND V(o12_3_5) AT=1427.000000p
.measure tran VK12_3_6W3 FIND V(o12_3_6) AT=1427.000000p
.measure tran VK12_3_7W3 FIND V(o12_3_7) AT=1427.000000p
.measure tran VRK12W4 FIND V(ph12) AT=1703.000000p
.measure tran VK12_3_0W4 FIND V(o12_3_0) AT=1703.000000p
.measure tran VK12_3_1W4 FIND V(o12_3_1) AT=1703.000000p
.measure tran VK12_3_2W4 FIND V(o12_3_2) AT=1703.000000p
.measure tran VK12_3_3W4 FIND V(o12_3_3) AT=1703.000000p
.measure tran VK12_3_4W4 FIND V(o12_3_4) AT=1703.000000p
.measure tran VK12_3_5W4 FIND V(o12_3_5) AT=1703.000000p
.measure tran VK12_3_6W4 FIND V(o12_3_6) AT=1703.000000p
.measure tran VK12_3_7W4 FIND V(o12_3_7) AT=1703.000000p
.measure tran VRK13W2 FIND V(ph13) AT=691.000000p
.measure tran VK13_3_0W2 FIND V(o13_3_0) AT=691.000000p
.measure tran VK13_3_1W2 FIND V(o13_3_1) AT=691.000000p
.measure tran VK13_3_2W2 FIND V(o13_3_2) AT=691.000000p
.measure tran VK13_3_3W2 FIND V(o13_3_3) AT=691.000000p
.measure tran VK13_3_4W2 FIND V(o13_3_4) AT=691.000000p
.measure tran VK13_3_5W2 FIND V(o13_3_5) AT=691.000000p
.measure tran VK13_3_6W2 FIND V(o13_3_6) AT=691.000000p
.measure tran VK13_3_7W2 FIND V(o13_3_7) AT=691.000000p
.measure tran VRK13W3 FIND V(ph13) AT=967.000000p
.measure tran VK13_3_0W3 FIND V(o13_3_0) AT=967.000000p
.measure tran VK13_3_1W3 FIND V(o13_3_1) AT=967.000000p
.measure tran VK13_3_2W3 FIND V(o13_3_2) AT=967.000000p
.measure tran VK13_3_3W3 FIND V(o13_3_3) AT=967.000000p
.measure tran VK13_3_4W3 FIND V(o13_3_4) AT=967.000000p
.measure tran VK13_3_5W3 FIND V(o13_3_5) AT=967.000000p
.measure tran VK13_3_6W3 FIND V(o13_3_6) AT=967.000000p
.measure tran VK13_3_7W3 FIND V(o13_3_7) AT=967.000000p
.measure tran VRK13W4 FIND V(ph13) AT=1243.000000p
.measure tran VK13_3_0W4 FIND V(o13_3_0) AT=1243.000000p
.measure tran VK13_3_1W4 FIND V(o13_3_1) AT=1243.000000p
.measure tran VK13_3_2W4 FIND V(o13_3_2) AT=1243.000000p
.measure tran VK13_3_3W4 FIND V(o13_3_3) AT=1243.000000p
.measure tran VK13_3_4W4 FIND V(o13_3_4) AT=1243.000000p
.measure tran VK13_3_5W4 FIND V(o13_3_5) AT=1243.000000p
.measure tran VK13_3_6W4 FIND V(o13_3_6) AT=1243.000000p
.measure tran VK13_3_7W4 FIND V(o13_3_7) AT=1243.000000p
.measure tran VRK14W2 FIND V(ph14) AT=783.000000p
.measure tran VK14_3_0W2 FIND V(o14_3_0) AT=783.000000p
.measure tran VK14_3_1W2 FIND V(o14_3_1) AT=783.000000p
.measure tran VK14_3_2W2 FIND V(o14_3_2) AT=783.000000p
.measure tran VK14_3_3W2 FIND V(o14_3_3) AT=783.000000p
.measure tran VK14_3_4W2 FIND V(o14_3_4) AT=783.000000p
.measure tran VK14_3_5W2 FIND V(o14_3_5) AT=783.000000p
.measure tran VK14_3_6W2 FIND V(o14_3_6) AT=783.000000p
.measure tran VK14_3_7W2 FIND V(o14_3_7) AT=783.000000p
.measure tran VRK14W3 FIND V(ph14) AT=1059.000000p
.measure tran VK14_3_0W3 FIND V(o14_3_0) AT=1059.000000p
.measure tran VK14_3_1W3 FIND V(o14_3_1) AT=1059.000000p
.measure tran VK14_3_2W3 FIND V(o14_3_2) AT=1059.000000p
.measure tran VK14_3_3W3 FIND V(o14_3_3) AT=1059.000000p
.measure tran VK14_3_4W3 FIND V(o14_3_4) AT=1059.000000p
.measure tran VK14_3_5W3 FIND V(o14_3_5) AT=1059.000000p
.measure tran VK14_3_6W3 FIND V(o14_3_6) AT=1059.000000p
.measure tran VK14_3_7W3 FIND V(o14_3_7) AT=1059.000000p
.measure tran VRK14W4 FIND V(ph14) AT=1335.000000p
.measure tran VK14_3_0W4 FIND V(o14_3_0) AT=1335.000000p
.measure tran VK14_3_1W4 FIND V(o14_3_1) AT=1335.000000p
.measure tran VK14_3_2W4 FIND V(o14_3_2) AT=1335.000000p
.measure tran VK14_3_3W4 FIND V(o14_3_3) AT=1335.000000p
.measure tran VK14_3_4W4 FIND V(o14_3_4) AT=1335.000000p
.measure tran VK14_3_5W4 FIND V(o14_3_5) AT=1335.000000p
.measure tran VK14_3_6W4 FIND V(o14_3_6) AT=1335.000000p
.measure tran VK14_3_7W4 FIND V(o14_3_7) AT=1335.000000p
.measure tran VRK15W2 FIND V(ph15) AT=875.000000p
.measure tran VK15_3_0W2 FIND V(o15_3_0) AT=875.000000p
.measure tran VK15_3_1W2 FIND V(o15_3_1) AT=875.000000p
.measure tran VK15_3_2W2 FIND V(o15_3_2) AT=875.000000p
.measure tran VK15_3_3W2 FIND V(o15_3_3) AT=875.000000p
.measure tran VK15_3_4W2 FIND V(o15_3_4) AT=875.000000p
.measure tran VK15_3_5W2 FIND V(o15_3_5) AT=875.000000p
.measure tran VK15_3_6W2 FIND V(o15_3_6) AT=875.000000p
.measure tran VK15_3_7W2 FIND V(o15_3_7) AT=875.000000p
.measure tran VRK15W3 FIND V(ph15) AT=1151.000000p
.measure tran VK15_3_0W3 FIND V(o15_3_0) AT=1151.000000p
.measure tran VK15_3_1W3 FIND V(o15_3_1) AT=1151.000000p
.measure tran VK15_3_2W3 FIND V(o15_3_2) AT=1151.000000p
.measure tran VK15_3_3W3 FIND V(o15_3_3) AT=1151.000000p
.measure tran VK15_3_4W3 FIND V(o15_3_4) AT=1151.000000p
.measure tran VK15_3_5W3 FIND V(o15_3_5) AT=1151.000000p
.measure tran VK15_3_6W3 FIND V(o15_3_6) AT=1151.000000p
.measure tran VK15_3_7W3 FIND V(o15_3_7) AT=1151.000000p
.measure tran VRK15W4 FIND V(ph15) AT=1427.000000p
.measure tran VK15_3_0W4 FIND V(o15_3_0) AT=1427.000000p
.measure tran VK15_3_1W4 FIND V(o15_3_1) AT=1427.000000p
.measure tran VK15_3_2W4 FIND V(o15_3_2) AT=1427.000000p
.measure tran VK15_3_3W4 FIND V(o15_3_3) AT=1427.000000p
.measure tran VK15_3_4W4 FIND V(o15_3_4) AT=1427.000000p
.measure tran VK15_3_5W4 FIND V(o15_3_5) AT=1427.000000p
.measure tran VK15_3_6W4 FIND V(o15_3_6) AT=1427.000000p
.measure tran VK15_3_7W4 FIND V(o15_3_7) AT=1427.000000p
.measure tran VRK16W2 FIND V(ph16) AT=967.000000p
.measure tran VK16_3_0W2 FIND V(o16_3_0) AT=967.000000p
.measure tran VK16_3_1W2 FIND V(o16_3_1) AT=967.000000p
.measure tran VK16_3_2W2 FIND V(o16_3_2) AT=967.000000p
.measure tran VK16_3_3W2 FIND V(o16_3_3) AT=967.000000p
.measure tran VK16_3_4W2 FIND V(o16_3_4) AT=967.000000p
.measure tran VK16_3_5W2 FIND V(o16_3_5) AT=967.000000p
.measure tran VK16_3_6W2 FIND V(o16_3_6) AT=967.000000p
.measure tran VK16_3_7W2 FIND V(o16_3_7) AT=967.000000p
.measure tran VRK16W3 FIND V(ph16) AT=1243.000000p
.measure tran VK16_3_0W3 FIND V(o16_3_0) AT=1243.000000p
.measure tran VK16_3_1W3 FIND V(o16_3_1) AT=1243.000000p
.measure tran VK16_3_2W3 FIND V(o16_3_2) AT=1243.000000p
.measure tran VK16_3_3W3 FIND V(o16_3_3) AT=1243.000000p
.measure tran VK16_3_4W3 FIND V(o16_3_4) AT=1243.000000p
.measure tran VK16_3_5W3 FIND V(o16_3_5) AT=1243.000000p
.measure tran VK16_3_6W3 FIND V(o16_3_6) AT=1243.000000p
.measure tran VK16_3_7W3 FIND V(o16_3_7) AT=1243.000000p
.measure tran VRK16W4 FIND V(ph16) AT=1519.000000p
.measure tran VK16_3_0W4 FIND V(o16_3_0) AT=1519.000000p
.measure tran VK16_3_1W4 FIND V(o16_3_1) AT=1519.000000p
.measure tran VK16_3_2W4 FIND V(o16_3_2) AT=1519.000000p
.measure tran VK16_3_3W4 FIND V(o16_3_3) AT=1519.000000p
.measure tran VK16_3_4W4 FIND V(o16_3_4) AT=1519.000000p
.measure tran VK16_3_5W4 FIND V(o16_3_5) AT=1519.000000p
.measure tran VK16_3_6W4 FIND V(o16_3_6) AT=1519.000000p
.measure tran VK16_3_7W4 FIND V(o16_3_7) AT=1519.000000p
.measure tran VRK17W2 FIND V(ph17) AT=1059.000000p
.measure tran VK17_3_0W2 FIND V(o17_3_0) AT=1059.000000p
.measure tran VK17_3_1W2 FIND V(o17_3_1) AT=1059.000000p
.measure tran VK17_3_2W2 FIND V(o17_3_2) AT=1059.000000p
.measure tran VK17_3_3W2 FIND V(o17_3_3) AT=1059.000000p
.measure tran VK17_3_4W2 FIND V(o17_3_4) AT=1059.000000p
.measure tran VK17_3_5W2 FIND V(o17_3_5) AT=1059.000000p
.measure tran VK17_3_6W2 FIND V(o17_3_6) AT=1059.000000p
.measure tran VK17_3_7W2 FIND V(o17_3_7) AT=1059.000000p
.measure tran VRK17W3 FIND V(ph17) AT=1335.000000p
.measure tran VK17_3_0W3 FIND V(o17_3_0) AT=1335.000000p
.measure tran VK17_3_1W3 FIND V(o17_3_1) AT=1335.000000p
.measure tran VK17_3_2W3 FIND V(o17_3_2) AT=1335.000000p
.measure tran VK17_3_3W3 FIND V(o17_3_3) AT=1335.000000p
.measure tran VK17_3_4W3 FIND V(o17_3_4) AT=1335.000000p
.measure tran VK17_3_5W3 FIND V(o17_3_5) AT=1335.000000p
.measure tran VK17_3_6W3 FIND V(o17_3_6) AT=1335.000000p
.measure tran VK17_3_7W3 FIND V(o17_3_7) AT=1335.000000p
.measure tran VRK17W4 FIND V(ph17) AT=1611.000000p
.measure tran VK17_3_0W4 FIND V(o17_3_0) AT=1611.000000p
.measure tran VK17_3_1W4 FIND V(o17_3_1) AT=1611.000000p
.measure tran VK17_3_2W4 FIND V(o17_3_2) AT=1611.000000p
.measure tran VK17_3_3W4 FIND V(o17_3_3) AT=1611.000000p
.measure tran VK17_3_4W4 FIND V(o17_3_4) AT=1611.000000p
.measure tran VK17_3_5W4 FIND V(o17_3_5) AT=1611.000000p
.measure tran VK17_3_6W4 FIND V(o17_3_6) AT=1611.000000p
.measure tran VK17_3_7W4 FIND V(o17_3_7) AT=1611.000000p
.measure tran VRK18W2 FIND V(ph18) AT=1151.000000p
.measure tran VK18_3_0W2 FIND V(o18_3_0) AT=1151.000000p
.measure tran VK18_3_1W2 FIND V(o18_3_1) AT=1151.000000p
.measure tran VK18_3_2W2 FIND V(o18_3_2) AT=1151.000000p
.measure tran VK18_3_3W2 FIND V(o18_3_3) AT=1151.000000p
.measure tran VK18_3_4W2 FIND V(o18_3_4) AT=1151.000000p
.measure tran VK18_3_5W2 FIND V(o18_3_5) AT=1151.000000p
.measure tran VK18_3_6W2 FIND V(o18_3_6) AT=1151.000000p
.measure tran VK18_3_7W2 FIND V(o18_3_7) AT=1151.000000p
.measure tran VRK18W3 FIND V(ph18) AT=1427.000000p
.measure tran VK18_3_0W3 FIND V(o18_3_0) AT=1427.000000p
.measure tran VK18_3_1W3 FIND V(o18_3_1) AT=1427.000000p
.measure tran VK18_3_2W3 FIND V(o18_3_2) AT=1427.000000p
.measure tran VK18_3_3W3 FIND V(o18_3_3) AT=1427.000000p
.measure tran VK18_3_4W3 FIND V(o18_3_4) AT=1427.000000p
.measure tran VK18_3_5W3 FIND V(o18_3_5) AT=1427.000000p
.measure tran VK18_3_6W3 FIND V(o18_3_6) AT=1427.000000p
.measure tran VK18_3_7W3 FIND V(o18_3_7) AT=1427.000000p
.measure tran VRK18W4 FIND V(ph18) AT=1703.000000p
.measure tran VK18_3_0W4 FIND V(o18_3_0) AT=1703.000000p
.measure tran VK18_3_1W4 FIND V(o18_3_1) AT=1703.000000p
.measure tran VK18_3_2W4 FIND V(o18_3_2) AT=1703.000000p
.measure tran VK18_3_3W4 FIND V(o18_3_3) AT=1703.000000p
.measure tran VK18_3_4W4 FIND V(o18_3_4) AT=1703.000000p
.measure tran VK18_3_5W4 FIND V(o18_3_5) AT=1703.000000p
.measure tran VK18_3_6W4 FIND V(o18_3_6) AT=1703.000000p
.measure tran VK18_3_7W4 FIND V(o18_3_7) AT=1703.000000p
.measure tran VRK19W2 FIND V(ph19) AT=691.000000p
.measure tran VK19_3_0W2 FIND V(o19_3_0) AT=691.000000p
.measure tran VK19_3_1W2 FIND V(o19_3_1) AT=691.000000p
.measure tran VK19_3_2W2 FIND V(o19_3_2) AT=691.000000p
.measure tran VK19_3_3W2 FIND V(o19_3_3) AT=691.000000p
.measure tran VK19_3_4W2 FIND V(o19_3_4) AT=691.000000p
.measure tran VK19_3_5W2 FIND V(o19_3_5) AT=691.000000p
.measure tran VK19_3_6W2 FIND V(o19_3_6) AT=691.000000p
.measure tran VK19_3_7W2 FIND V(o19_3_7) AT=691.000000p
.measure tran VRK19W3 FIND V(ph19) AT=967.000000p
.measure tran VK19_3_0W3 FIND V(o19_3_0) AT=967.000000p
.measure tran VK19_3_1W3 FIND V(o19_3_1) AT=967.000000p
.measure tran VK19_3_2W3 FIND V(o19_3_2) AT=967.000000p
.measure tran VK19_3_3W3 FIND V(o19_3_3) AT=967.000000p
.measure tran VK19_3_4W3 FIND V(o19_3_4) AT=967.000000p
.measure tran VK19_3_5W3 FIND V(o19_3_5) AT=967.000000p
.measure tran VK19_3_6W3 FIND V(o19_3_6) AT=967.000000p
.measure tran VK19_3_7W3 FIND V(o19_3_7) AT=967.000000p
.measure tran VRK19W4 FIND V(ph19) AT=1243.000000p
.measure tran VK19_3_0W4 FIND V(o19_3_0) AT=1243.000000p
.measure tran VK19_3_1W4 FIND V(o19_3_1) AT=1243.000000p
.measure tran VK19_3_2W4 FIND V(o19_3_2) AT=1243.000000p
.measure tran VK19_3_3W4 FIND V(o19_3_3) AT=1243.000000p
.measure tran VK19_3_4W4 FIND V(o19_3_4) AT=1243.000000p
.measure tran VK19_3_5W4 FIND V(o19_3_5) AT=1243.000000p
.measure tran VK19_3_6W4 FIND V(o19_3_6) AT=1243.000000p
.measure tran VK19_3_7W4 FIND V(o19_3_7) AT=1243.000000p
.measure tran VRK20W2 FIND V(ph20) AT=783.000000p
.measure tran VK20_3_0W2 FIND V(o20_3_0) AT=783.000000p
.measure tran VK20_3_1W2 FIND V(o20_3_1) AT=783.000000p
.measure tran VK20_3_2W2 FIND V(o20_3_2) AT=783.000000p
.measure tran VK20_3_3W2 FIND V(o20_3_3) AT=783.000000p
.measure tran VK20_3_4W2 FIND V(o20_3_4) AT=783.000000p
.measure tran VK20_3_5W2 FIND V(o20_3_5) AT=783.000000p
.measure tran VK20_3_6W2 FIND V(o20_3_6) AT=783.000000p
.measure tran VK20_3_7W2 FIND V(o20_3_7) AT=783.000000p
.measure tran VRK20W3 FIND V(ph20) AT=1059.000000p
.measure tran VK20_3_0W3 FIND V(o20_3_0) AT=1059.000000p
.measure tran VK20_3_1W3 FIND V(o20_3_1) AT=1059.000000p
.measure tran VK20_3_2W3 FIND V(o20_3_2) AT=1059.000000p
.measure tran VK20_3_3W3 FIND V(o20_3_3) AT=1059.000000p
.measure tran VK20_3_4W3 FIND V(o20_3_4) AT=1059.000000p
.measure tran VK20_3_5W3 FIND V(o20_3_5) AT=1059.000000p
.measure tran VK20_3_6W3 FIND V(o20_3_6) AT=1059.000000p
.measure tran VK20_3_7W3 FIND V(o20_3_7) AT=1059.000000p
.measure tran VRK20W4 FIND V(ph20) AT=1335.000000p
.measure tran VK20_3_0W4 FIND V(o20_3_0) AT=1335.000000p
.measure tran VK20_3_1W4 FIND V(o20_3_1) AT=1335.000000p
.measure tran VK20_3_2W4 FIND V(o20_3_2) AT=1335.000000p
.measure tran VK20_3_3W4 FIND V(o20_3_3) AT=1335.000000p
.measure tran VK20_3_4W4 FIND V(o20_3_4) AT=1335.000000p
.measure tran VK20_3_5W4 FIND V(o20_3_5) AT=1335.000000p
.measure tran VK20_3_6W4 FIND V(o20_3_6) AT=1335.000000p
.measure tran VK20_3_7W4 FIND V(o20_3_7) AT=1335.000000p
.measure tran VRK21W2 FIND V(ph21) AT=875.000000p
.measure tran VK21_3_0W2 FIND V(o21_3_0) AT=875.000000p
.measure tran VK21_3_1W2 FIND V(o21_3_1) AT=875.000000p
.measure tran VK21_3_2W2 FIND V(o21_3_2) AT=875.000000p
.measure tran VK21_3_3W2 FIND V(o21_3_3) AT=875.000000p
.measure tran VK21_3_4W2 FIND V(o21_3_4) AT=875.000000p
.measure tran VK21_3_5W2 FIND V(o21_3_5) AT=875.000000p
.measure tran VK21_3_6W2 FIND V(o21_3_6) AT=875.000000p
.measure tran VK21_3_7W2 FIND V(o21_3_7) AT=875.000000p
.measure tran VRK21W3 FIND V(ph21) AT=1151.000000p
.measure tran VK21_3_0W3 FIND V(o21_3_0) AT=1151.000000p
.measure tran VK21_3_1W3 FIND V(o21_3_1) AT=1151.000000p
.measure tran VK21_3_2W3 FIND V(o21_3_2) AT=1151.000000p
.measure tran VK21_3_3W3 FIND V(o21_3_3) AT=1151.000000p
.measure tran VK21_3_4W3 FIND V(o21_3_4) AT=1151.000000p
.measure tran VK21_3_5W3 FIND V(o21_3_5) AT=1151.000000p
.measure tran VK21_3_6W3 FIND V(o21_3_6) AT=1151.000000p
.measure tran VK21_3_7W3 FIND V(o21_3_7) AT=1151.000000p
.measure tran VRK21W4 FIND V(ph21) AT=1427.000000p
.measure tran VK21_3_0W4 FIND V(o21_3_0) AT=1427.000000p
.measure tran VK21_3_1W4 FIND V(o21_3_1) AT=1427.000000p
.measure tran VK21_3_2W4 FIND V(o21_3_2) AT=1427.000000p
.measure tran VK21_3_3W4 FIND V(o21_3_3) AT=1427.000000p
.measure tran VK21_3_4W4 FIND V(o21_3_4) AT=1427.000000p
.measure tran VK21_3_5W4 FIND V(o21_3_5) AT=1427.000000p
.measure tran VK21_3_6W4 FIND V(o21_3_6) AT=1427.000000p
.measure tran VK21_3_7W4 FIND V(o21_3_7) AT=1427.000000p
.measure tran VRK22W2 FIND V(ph22) AT=967.000000p
.measure tran VK22_3_0W2 FIND V(o22_3_0) AT=967.000000p
.measure tran VK22_3_1W2 FIND V(o22_3_1) AT=967.000000p
.measure tran VK22_3_2W2 FIND V(o22_3_2) AT=967.000000p
.measure tran VK22_3_3W2 FIND V(o22_3_3) AT=967.000000p
.measure tran VK22_3_4W2 FIND V(o22_3_4) AT=967.000000p
.measure tran VK22_3_5W2 FIND V(o22_3_5) AT=967.000000p
.measure tran VK22_3_6W2 FIND V(o22_3_6) AT=967.000000p
.measure tran VK22_3_7W2 FIND V(o22_3_7) AT=967.000000p
.measure tran VRK22W3 FIND V(ph22) AT=1243.000000p
.measure tran VK22_3_0W3 FIND V(o22_3_0) AT=1243.000000p
.measure tran VK22_3_1W3 FIND V(o22_3_1) AT=1243.000000p
.measure tran VK22_3_2W3 FIND V(o22_3_2) AT=1243.000000p
.measure tran VK22_3_3W3 FIND V(o22_3_3) AT=1243.000000p
.measure tran VK22_3_4W3 FIND V(o22_3_4) AT=1243.000000p
.measure tran VK22_3_5W3 FIND V(o22_3_5) AT=1243.000000p
.measure tran VK22_3_6W3 FIND V(o22_3_6) AT=1243.000000p
.measure tran VK22_3_7W3 FIND V(o22_3_7) AT=1243.000000p
.measure tran VRK22W4 FIND V(ph22) AT=1519.000000p
.measure tran VK22_3_0W4 FIND V(o22_3_0) AT=1519.000000p
.measure tran VK22_3_1W4 FIND V(o22_3_1) AT=1519.000000p
.measure tran VK22_3_2W4 FIND V(o22_3_2) AT=1519.000000p
.measure tran VK22_3_3W4 FIND V(o22_3_3) AT=1519.000000p
.measure tran VK22_3_4W4 FIND V(o22_3_4) AT=1519.000000p
.measure tran VK22_3_5W4 FIND V(o22_3_5) AT=1519.000000p
.measure tran VK22_3_6W4 FIND V(o22_3_6) AT=1519.000000p
.measure tran VK22_3_7W4 FIND V(o22_3_7) AT=1519.000000p
.measure tran VRK23W2 FIND V(ph23) AT=1059.000000p
.measure tran VK23_3_0W2 FIND V(o23_3_0) AT=1059.000000p
.measure tran VK23_3_1W2 FIND V(o23_3_1) AT=1059.000000p
.measure tran VK23_3_2W2 FIND V(o23_3_2) AT=1059.000000p
.measure tran VK23_3_3W2 FIND V(o23_3_3) AT=1059.000000p
.measure tran VK23_3_4W2 FIND V(o23_3_4) AT=1059.000000p
.measure tran VK23_3_5W2 FIND V(o23_3_5) AT=1059.000000p
.measure tran VK23_3_6W2 FIND V(o23_3_6) AT=1059.000000p
.measure tran VK23_3_7W2 FIND V(o23_3_7) AT=1059.000000p
.measure tran VRK23W3 FIND V(ph23) AT=1335.000000p
.measure tran VK23_3_0W3 FIND V(o23_3_0) AT=1335.000000p
.measure tran VK23_3_1W3 FIND V(o23_3_1) AT=1335.000000p
.measure tran VK23_3_2W3 FIND V(o23_3_2) AT=1335.000000p
.measure tran VK23_3_3W3 FIND V(o23_3_3) AT=1335.000000p
.measure tran VK23_3_4W3 FIND V(o23_3_4) AT=1335.000000p
.measure tran VK23_3_5W3 FIND V(o23_3_5) AT=1335.000000p
.measure tran VK23_3_6W3 FIND V(o23_3_6) AT=1335.000000p
.measure tran VK23_3_7W3 FIND V(o23_3_7) AT=1335.000000p
.measure tran VRK23W4 FIND V(ph23) AT=1611.000000p
.measure tran VK23_3_0W4 FIND V(o23_3_0) AT=1611.000000p
.measure tran VK23_3_1W4 FIND V(o23_3_1) AT=1611.000000p
.measure tran VK23_3_2W4 FIND V(o23_3_2) AT=1611.000000p
.measure tran VK23_3_3W4 FIND V(o23_3_3) AT=1611.000000p
.measure tran VK23_3_4W4 FIND V(o23_3_4) AT=1611.000000p
.measure tran VK23_3_5W4 FIND V(o23_3_5) AT=1611.000000p
.measure tran VK23_3_6W4 FIND V(o23_3_6) AT=1611.000000p
.measure tran VK23_3_7W4 FIND V(o23_3_7) AT=1611.000000p
.measure tran VRK24W2 FIND V(ph24) AT=1151.000000p
.measure tran VK24_3_0W2 FIND V(o24_3_0) AT=1151.000000p
.measure tran VK24_3_1W2 FIND V(o24_3_1) AT=1151.000000p
.measure tran VK24_3_2W2 FIND V(o24_3_2) AT=1151.000000p
.measure tran VK24_3_3W2 FIND V(o24_3_3) AT=1151.000000p
.measure tran VK24_3_4W2 FIND V(o24_3_4) AT=1151.000000p
.measure tran VK24_3_5W2 FIND V(o24_3_5) AT=1151.000000p
.measure tran VK24_3_6W2 FIND V(o24_3_6) AT=1151.000000p
.measure tran VK24_3_7W2 FIND V(o24_3_7) AT=1151.000000p
.measure tran VRK24W3 FIND V(ph24) AT=1427.000000p
.measure tran VK24_3_0W3 FIND V(o24_3_0) AT=1427.000000p
.measure tran VK24_3_1W3 FIND V(o24_3_1) AT=1427.000000p
.measure tran VK24_3_2W3 FIND V(o24_3_2) AT=1427.000000p
.measure tran VK24_3_3W3 FIND V(o24_3_3) AT=1427.000000p
.measure tran VK24_3_4W3 FIND V(o24_3_4) AT=1427.000000p
.measure tran VK24_3_5W3 FIND V(o24_3_5) AT=1427.000000p
.measure tran VK24_3_6W3 FIND V(o24_3_6) AT=1427.000000p
.measure tran VK24_3_7W3 FIND V(o24_3_7) AT=1427.000000p
.measure tran VRK24W4 FIND V(ph24) AT=1703.000000p
.measure tran VK24_3_0W4 FIND V(o24_3_0) AT=1703.000000p
.measure tran VK24_3_1W4 FIND V(o24_3_1) AT=1703.000000p
.measure tran VK24_3_2W4 FIND V(o24_3_2) AT=1703.000000p
.measure tran VK24_3_3W4 FIND V(o24_3_3) AT=1703.000000p
.measure tran VK24_3_4W4 FIND V(o24_3_4) AT=1703.000000p
.measure tran VK24_3_5W4 FIND V(o24_3_5) AT=1703.000000p
.measure tran VK24_3_6W4 FIND V(o24_3_6) AT=1703.000000p
.measure tran VK24_3_7W4 FIND V(o24_3_7) AT=1703.000000p
.print tran V(ph1) V(ph2) V(ph3) V(ph4) V(ph5) V(ph6) V(o1_1_0) V(o1_1_1) V(o1_1_2) V(o1_1_3) V(o1_1_4) V(o1_1_5) V(o1_1_6) V(o1_1_7) V(o1_2_0) V(o1_2_1) V(o1_2_2) V(o1_2_3) V(o1_2_4) V(o1_2_5) V(o1_2_6) V(o1_2_7) V(o1_3_0) V(o1_3_1) V(o1_3_2) V(o1_3_3) V(o1_3_4) V(o1_3_5) V(o1_3_6) V(o1_3_7) V(o2_1_0) V(o2_1_1) V(o2_1_2) V(o2_1_3) V(o2_1_4) V(o2_1_5) V(o2_1_6) V(o2_1_7) V(o2_2_0) V(o2_2_1) V(o2_2_2) V(o2_2_3) V(o2_2_4) V(o2_2_5) V(o2_2_6) V(o2_2_7) V(o2_3_0) V(o2_3_1) V(o2_3_2) V(o2_3_3) V(o2_3_4) V(o2_3_5) V(o2_3_6) V(o2_3_7) V(o3_1_0) V(o3_1_1) V(o3_1_2) V(o3_1_3) V(o3_1_4) V(o3_1_5) V(o3_1_6) V(o3_1_7) V(o3_2_0) V(o3_2_1) V(o3_2_2) V(o3_2_3) V(o3_2_4) V(o3_2_5) V(o3_2_6) V(o3_2_7) V(o3_3_0) V(o3_3_1) V(o3_3_2) V(o3_3_3) V(o3_3_4) V(o3_3_5) V(o3_3_6) V(o3_3_7) V(o4_1_0) V(o4_1_1) V(o4_1_2) V(o4_1_3) V(o4_1_4) V(o4_1_5) V(o4_1_6) V(o4_1_7) V(o4_2_0) V(o4_2_1) V(o4_2_2) V(o4_2_3) V(o4_2_4) V(o4_2_5) V(o4_2_6) V(o4_2_7) V(o4_3_0) V(o4_3_1) V(o4_3_2) V(o4_3_3) V(o4_3_4) V(o4_3_5) V(o4_3_6) V(o4_3_7) V(o5_1_0) V(o5_1_1) V(o5_1_2) V(o5_1_3) V(o5_1_4) V(o5_1_5) V(o5_1_6) V(o5_1_7) V(o5_2_0) V(o5_2_1) V(o5_2_2) V(o5_2_3) V(o5_2_4) V(o5_2_5) V(o5_2_6) V(o5_2_7) V(o5_3_0) V(o5_3_1) V(o5_3_2) V(o5_3_3) V(o5_3_4) V(o5_3_5) V(o5_3_6) V(o5_3_7) V(o6_1_0) V(o6_1_1) V(o6_1_2) V(o6_1_3) V(o6_1_4) V(o6_1_5) V(o6_1_6) V(o6_1_7) V(o6_2_0) V(o6_2_1) V(o6_2_2) V(o6_2_3) V(o6_2_4) V(o6_2_5) V(o6_2_6) V(o6_2_7) V(o6_3_0) V(o6_3_1) V(o6_3_2) V(o6_3_3) V(o6_3_4) V(o6_3_5) V(o6_3_6) V(o6_3_7) I(VPH1) I(VPH2) I(VPH3) I(VPH4) I(VPH5) I(VPH6) I(VMG1) I(VMG2) I(VMG3) I(VMG4) I(VMG5) I(VMG6) I(L1) V(lin) V(lout) I(VDDH) I(VZR) I(VML) V(pA) V(pB) V(pC)
.end
