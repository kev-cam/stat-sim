.hdl "/usr/local/share/xyce/verilog-a/psp103/psp103.va"
.include "/usr/local/src/kestrel/sim/models/sg13g2_psp103_tt.lib"
.include "/usr/local/src/stat-sim/qal/sg13lv_compat.sp"
.OPTIONS TIMEINT METHOD=GEAR RELTOL=1e-6 ABSTOL=1e-15 CHGTOL=1e-17
* ---- qal/lsteer steered-inductor network (replaces VPHk/RSk) ----
VDDH vddh 0 1.65
VZR vzr 0 0
VPH1 ph1 pA 0
VPH2 ph2 pB 0
VPH3 ph3 pC 0
VPH4 ph4 pA 0
VPH5 ph5 pB 0
VPH6 ph6 pC 0
Ctin lin 0 50f
Ctout lout 0 50f
VML lin lmid 0
RL1 lmid lx 10
L1 lx lout 120n IC=3.58143m
.model SWI VSWITCH RON=0.05 ROFF=1e8 VON=0.7 VOFF=0.3
Vcss css 0 PWL(0 1 275.5p 1 275.8p 0)
Sfw lin lout css 0 SWI
VTRA trA 0 PWL(0 0 92p 1.65 184p 1.65 276p 0 368p 1.65 460p 1.65 552p 0 644p 1.65 736p 1.65)
StrA trA pA css 0 SWI
VTRB trB 0 PWL(0 1.65 92p 0 184p 1.65 276p 1.65 368p 0 460p 1.65 552p 1.65)
StrB trB pB css 0 SWI
VTRC trC 0 PWL(0 1.65 92p 1.65 184p 0 276p 1.65 368p 1.65 460p 0 552p 1.65 644p 1.65)
StrC trC pC css 0 SWI
VSinA pA sinA 0
VPGinA ginA_s 0 PWL(0 0 460.5p 0 462.5p 2.174 531.1p 2.174 533.1p 0 736.5p 0 738.5p 2.174 807.1p 2.174 809.1p 0 1012.5p 0 1014.5p 2.174 1083.1p 2.174 1085.1p 0 1288.5p 0 1290.5p 2.174 1359.1p 2.174 1361.1p 0 1564.5p 0 1566.5p 2.174 1635.1p 2.174 1637.1p 0 1840.5p 0 1842.5p 2.174 1911.1p 2.174 1913.1p 0 2116.5p 0 2118.5p 2.174 2187.1p 2.174 2189.1p 0)
VGinA ginA_s ginA 0
XSinA sinA ginA lin 0 sg13_lv_nmos w=30u l=0.13u
VPGPinA gpinA_s 0 PWL(0 1.65 460.5p 1.65 462.5p 0 531.1p 0 533.1p 1.65 736.5p 1.65 738.5p 0 807.1p 0 809.1p 1.65 1012.5p 1.65 1014.5p 0 1083.1p 0 1085.1p 1.65 1288.5p 1.65 1290.5p 0 1359.1p 0 1361.1p 1.65 1564.5p 1.65 1566.5p 0 1635.1p 0 1637.1p 1.65 1840.5p 1.65 1842.5p 0 1911.1p 0 1913.1p 1.65 2116.5p 1.65 2118.5p 0 2187.1p 0 2189.1p 1.65)
VGPinA gpinA_s gpinA 0
XSPinA sinA gpinA lin vddh sg13_lv_pmos w=30u l=0.13u
VSoutA pA soutA 0
VPGoutA goutA_s 0 PWL(0 0 276.5p 0 278.5p 2.174 365.5p 2.174 367.5p 0 552.5p 0 554.5p 2.174 641.5p 2.174 643.5p 0 828.5p 0 830.5p 2.174 917.5p 2.174 919.5p 0 1104.5p 0 1106.5p 2.174 1193.5p 2.174 1195.5p 0 1380.5p 0 1382.5p 2.174 1469.5p 2.174 1471.5p 0 1656.5p 0 1658.5p 2.174 1745.5p 2.174 1747.5p 0 1932.5p 0 1934.5p 2.174 2021.5p 2.174 2023.5p 0)
VGoutA goutA_s goutA 0
XSoutA soutA goutA lout 0 sg13_lv_nmos w=30u l=0.13u
VPGPoutA gpoutA_s 0 PWL(0 1.65 276.5p 1.65 278.5p 0 365.5p 0 367.5p 1.65 552.5p 1.65 554.5p 0 641.5p 0 643.5p 1.65 828.5p 1.65 830.5p 0 917.5p 0 919.5p 1.65 1104.5p 1.65 1106.5p 0 1193.5p 0 1195.5p 1.65 1380.5p 1.65 1382.5p 0 1469.5p 0 1471.5p 1.65 1656.5p 1.65 1658.5p 0 1745.5p 0 1747.5p 1.65 1932.5p 1.65 1934.5p 0 2021.5p 0 2023.5p 1.65)
VGPoutA gpoutA_s gpoutA 0
XSPoutA soutA gpoutA lout vddh sg13_lv_pmos w=30u l=0.13u
VSholdA pA sholdA 0
VPGholdA gholdA_s 0 PWL(0 1.65 368.5p 1.65 370.5p 0 457.5p 0 459.5p 1.65 644.5p 1.65 646.5p 0 733.5p 0 735.5p 1.65 920.5p 1.65 922.5p 0 1009.5p 0 1011.5p 1.65 1196.5p 1.65 1198.5p 0 1285.5p 0 1287.5p 1.65 1472.5p 1.65 1474.5p 0 1561.5p 0 1563.5p 1.65 1748.5p 1.65 1750.5p 0 1837.5p 0 1839.5p 1.65 2024.5p 1.65 2026.5p 0 2113.5p 0 2115.5p 1.65)
VGholdA gholdA_s gholdA 0
XSholdA sholdA gholdA vddh vddh sg13_lv_pmos w=60u l=0.13u
VSzeroA pA szeroA 0
VPGzeroA gzeroA_s 0 PWL(0 0 534.1p 0 536.1p 1.65 549.5p 1.65 551.5p 0 810.1p 0 812.1p 1.65 825.5p 1.65 827.5p 0 1086.1p 0 1088.1p 1.65 1101.5p 1.65 1103.5p 0 1362.1p 0 1364.1p 1.65 1377.5p 1.65 1379.5p 0 1638.1p 0 1640.1p 1.65 1653.5p 1.65 1655.5p 0 1914.1p 0 1916.1p 1.65 1929.5p 1.65 1931.5p 0 2190.1p 0 2192.1p 1.65 2205.5p 1.65 2207.5p 0)
VGzeroA gzeroA_s gzeroA 0
XSzeroA szeroA gzeroA vzr 0 sg13_lv_nmos w=10u l=0.13u
VSindd vddh sindd 0
VPGindd gindd_s 0 PWL(0 0 350.1p 0 352.1p 2.174 365.5p 2.174 367.5p 0 442.1p 0 444.1p 2.174 457.5p 2.174 459.5p 0 534.1p 0 536.1p 2.174 549.5p 2.174 551.5p 0 626.1p 0 628.1p 2.174 641.5p 2.174 643.5p 0 718.1p 0 720.1p 2.174 733.5p 2.174 735.5p 0 810.1p 0 812.1p 2.174 825.5p 2.174 827.5p 0 902.1p 0 904.1p 2.174 917.5p 2.174 919.5p 0 994.1p 0 996.1p 2.174 1009.5p 2.174 1011.5p 0 1086.1p 0 1088.1p 2.174 1101.5p 2.174 1103.5p 0 1178.1p 0 1180.1p 2.174 1193.5p 2.174 1195.5p 0 1270.1p 0 1272.1p 2.174 1285.5p 2.174 1287.5p 0 1362.1p 0 1364.1p 2.174 1377.5p 2.174 1379.5p 0 1454.1p 0 1456.1p 2.174 1469.5p 2.174 1471.5p 0 1546.1p 0 1548.1p 2.174 1561.5p 2.174 1563.5p 0 1638.1p 0 1640.1p 2.174 1653.5p 2.174 1655.5p 0 1730.1p 0 1732.1p 2.174 1745.5p 2.174 1747.5p 0 1822.1p 0 1824.1p 2.174 1837.5p 2.174 1839.5p 0 1914.1p 0 1916.1p 2.174 1929.5p 2.174 1931.5p 0 2006.1p 0 2008.1p 2.174 2021.5p 2.174 2023.5p 0 2098.1p 0 2100.1p 2.174 2113.5p 2.174 2115.5p 0 2190.1p 0 2192.1p 2.174 2205.5p 2.174 2207.5p 0)
VGindd gindd_s gindd 0
XSindd sindd gindd lin 0 sg13_lv_nmos w=30u l=0.13u
VPGPindd gpindd_s 0 PWL(0 1.65 350.1p 1.65 352.1p 0 365.5p 0 367.5p 1.65 442.1p 1.65 444.1p 0 457.5p 0 459.5p 1.65 534.1p 1.65 536.1p 0 549.5p 0 551.5p 1.65 626.1p 1.65 628.1p 0 641.5p 0 643.5p 1.65 718.1p 1.65 720.1p 0 733.5p 0 735.5p 1.65 810.1p 1.65 812.1p 0 825.5p 0 827.5p 1.65 902.1p 1.65 904.1p 0 917.5p 0 919.5p 1.65 994.1p 1.65 996.1p 0 1009.5p 0 1011.5p 1.65 1086.1p 1.65 1088.1p 0 1101.5p 0 1103.5p 1.65 1178.1p 1.65 1180.1p 0 1193.5p 0 1195.5p 1.65 1270.1p 1.65 1272.1p 0 1285.5p 0 1287.5p 1.65 1362.1p 1.65 1364.1p 0 1377.5p 0 1379.5p 1.65 1454.1p 1.65 1456.1p 0 1469.5p 0 1471.5p 1.65 1546.1p 1.65 1548.1p 0 1561.5p 0 1563.5p 1.65 1638.1p 1.65 1640.1p 0 1653.5p 0 1655.5p 1.65 1730.1p 1.65 1732.1p 0 1745.5p 0 1747.5p 1.65 1822.1p 1.65 1824.1p 0 1837.5p 0 1839.5p 1.65 1914.1p 1.65 1916.1p 0 1929.5p 0 1931.5p 1.65 2006.1p 1.65 2008.1p 0 2021.5p 0 2023.5p 1.65 2098.1p 1.65 2100.1p 0 2113.5p 0 2115.5p 1.65 2190.1p 1.65 2192.1p 0 2205.5p 0 2207.5p 1.65)
VGPindd gpindd_s gpindd 0
XSPindd sindd gpindd lin vddh sg13_lv_pmos w=30u l=0.13u
VSinB pB sinB 0
VPGinB ginB_s 0 PWL(0 0 276.5p 0 278.5p 2.174 347.1p 2.174 349.1p 0 552.5p 0 554.5p 2.174 623.1p 2.174 625.1p 0 828.5p 0 830.5p 2.174 899.1p 2.174 901.1p 0 1104.5p 0 1106.5p 2.174 1175.1p 2.174 1177.1p 0 1380.5p 0 1382.5p 2.174 1451.1p 2.174 1453.1p 0 1656.5p 0 1658.5p 2.174 1727.1p 2.174 1729.1p 0 1932.5p 0 1934.5p 2.174 2003.1p 2.174 2005.1p 0)
VGinB ginB_s ginB 0
XSinB sinB ginB lin 0 sg13_lv_nmos w=30u l=0.13u
VPGPinB gpinB_s 0 PWL(0 1.65 276.5p 1.65 278.5p 0 347.1p 0 349.1p 1.65 552.5p 1.65 554.5p 0 623.1p 0 625.1p 1.65 828.5p 1.65 830.5p 0 899.1p 0 901.1p 1.65 1104.5p 1.65 1106.5p 0 1175.1p 0 1177.1p 1.65 1380.5p 1.65 1382.5p 0 1451.1p 0 1453.1p 1.65 1656.5p 1.65 1658.5p 0 1727.1p 0 1729.1p 1.65 1932.5p 1.65 1934.5p 0 2003.1p 0 2005.1p 1.65)
VGPinB gpinB_s gpinB 0
XSPinB sinB gpinB lin vddh sg13_lv_pmos w=30u l=0.13u
VSoutB pB soutB 0
VPGoutB goutB_s 0 PWL(0 0 368.5p 0 370.5p 2.174 457.5p 2.174 459.5p 0 644.5p 0 646.5p 2.174 733.5p 2.174 735.5p 0 920.5p 0 922.5p 2.174 1009.5p 2.174 1011.5p 0 1196.5p 0 1198.5p 2.174 1285.5p 2.174 1287.5p 0 1472.5p 0 1474.5p 2.174 1561.5p 2.174 1563.5p 0 1748.5p 0 1750.5p 2.174 1837.5p 2.174 1839.5p 0 2024.5p 0 2026.5p 2.174 2113.5p 2.174 2115.5p 0)
VGoutB goutB_s goutB 0
XSoutB soutB goutB lout 0 sg13_lv_nmos w=30u l=0.13u
VPGPoutB gpoutB_s 0 PWL(0 1.65 368.5p 1.65 370.5p 0 457.5p 0 459.5p 1.65 644.5p 1.65 646.5p 0 733.5p 0 735.5p 1.65 920.5p 1.65 922.5p 0 1009.5p 0 1011.5p 1.65 1196.5p 1.65 1198.5p 0 1285.5p 0 1287.5p 1.65 1472.5p 1.65 1474.5p 0 1561.5p 0 1563.5p 1.65 1748.5p 1.65 1750.5p 0 1837.5p 0 1839.5p 1.65 2024.5p 1.65 2026.5p 0 2113.5p 0 2115.5p 1.65)
VGPoutB gpoutB_s gpoutB 0
XSPoutB soutB gpoutB lout vddh sg13_lv_pmos w=30u l=0.13u
VSholdB pB sholdB 0
VPGholdB gholdB_s 0 PWL(0 1.65 460.5p 1.65 462.5p 0 549.5p 0 551.5p 1.65 736.5p 1.65 738.5p 0 825.5p 0 827.5p 1.65 1012.5p 1.65 1014.5p 0 1101.5p 0 1103.5p 1.65 1288.5p 1.65 1290.5p 0 1377.5p 0 1379.5p 1.65 1564.5p 1.65 1566.5p 0 1653.5p 0 1655.5p 1.65 1840.5p 1.65 1842.5p 0 1929.5p 0 1931.5p 1.65 2116.5p 1.65 2118.5p 0 2205.5p 0 2207.5p 1.65)
VGholdB gholdB_s gholdB 0
XSholdB sholdB gholdB vddh vddh sg13_lv_pmos w=60u l=0.13u
VSzeroB pB szeroB 0
VPGzeroB gzeroB_s 0 PWL(0 0 350.1p 0 352.1p 1.65 365.5p 1.65 367.5p 0 626.1p 0 628.1p 1.65 641.5p 1.65 643.5p 0 902.1p 0 904.1p 1.65 917.5p 1.65 919.5p 0 1178.1p 0 1180.1p 1.65 1193.5p 1.65 1195.5p 0 1454.1p 0 1456.1p 1.65 1469.5p 1.65 1471.5p 0 1730.1p 0 1732.1p 1.65 1745.5p 1.65 1747.5p 0 2006.1p 0 2008.1p 1.65 2021.5p 1.65 2023.5p 0)
VGzeroB gzeroB_s gzeroB 0
XSzeroB szeroB gzeroB vzr 0 sg13_lv_nmos w=10u l=0.13u
VSinC pC sinC 0
VPGinC ginC_s 0 PWL(0 0 368.5p 0 370.5p 2.174 439.1p 2.174 441.1p 0 644.5p 0 646.5p 2.174 715.1p 2.174 717.1p 0 920.5p 0 922.5p 2.174 991.1p 2.174 993.1p 0 1196.5p 0 1198.5p 2.174 1267.1p 2.174 1269.1p 0 1472.5p 0 1474.5p 2.174 1543.1p 2.174 1545.1p 0 1748.5p 0 1750.5p 2.174 1819.1p 2.174 1821.1p 0 2024.5p 0 2026.5p 2.174 2095.1p 2.174 2097.1p 0)
VGinC ginC_s ginC 0
XSinC sinC ginC lin 0 sg13_lv_nmos w=30u l=0.13u
VPGPinC gpinC_s 0 PWL(0 1.65 368.5p 1.65 370.5p 0 439.1p 0 441.1p 1.65 644.5p 1.65 646.5p 0 715.1p 0 717.1p 1.65 920.5p 1.65 922.5p 0 991.1p 0 993.1p 1.65 1196.5p 1.65 1198.5p 0 1267.1p 0 1269.1p 1.65 1472.5p 1.65 1474.5p 0 1543.1p 0 1545.1p 1.65 1748.5p 1.65 1750.5p 0 1819.1p 0 1821.1p 1.65 2024.5p 1.65 2026.5p 0 2095.1p 0 2097.1p 1.65)
VGPinC gpinC_s gpinC 0
XSPinC sinC gpinC lin vddh sg13_lv_pmos w=30u l=0.13u
VSoutC pC soutC 0
VPGoutC goutC_s 0 PWL(0 0 460.5p 0 462.5p 2.174 549.5p 2.174 551.5p 0 736.5p 0 738.5p 2.174 825.5p 2.174 827.5p 0 1012.5p 0 1014.5p 2.174 1101.5p 2.174 1103.5p 0 1288.5p 0 1290.5p 2.174 1377.5p 2.174 1379.5p 0 1564.5p 0 1566.5p 2.174 1653.5p 2.174 1655.5p 0 1840.5p 0 1842.5p 2.174 1929.5p 2.174 1931.5p 0 2116.5p 0 2118.5p 2.174 2205.5p 2.174 2207.5p 0)
VGoutC goutC_s goutC 0
XSoutC soutC goutC lout 0 sg13_lv_nmos w=30u l=0.13u
VPGPoutC gpoutC_s 0 PWL(0 1.65 460.5p 1.65 462.5p 0 549.5p 0 551.5p 1.65 736.5p 1.65 738.5p 0 825.5p 0 827.5p 1.65 1012.5p 1.65 1014.5p 0 1101.5p 0 1103.5p 1.65 1288.5p 1.65 1290.5p 0 1377.5p 0 1379.5p 1.65 1564.5p 1.65 1566.5p 0 1653.5p 0 1655.5p 1.65 1840.5p 1.65 1842.5p 0 1929.5p 0 1931.5p 1.65 2116.5p 1.65 2118.5p 0 2205.5p 0 2207.5p 1.65)
VGPoutC gpoutC_s gpoutC 0
XSPoutC soutC gpoutC lout vddh sg13_lv_pmos w=30u l=0.13u
VSholdC pC sholdC 0
VPGholdC gholdC_s 0 PWL(0 1.65 276.5p 1.65 278.5p 0 365.5p 0 367.5p 1.65 552.5p 1.65 554.5p 0 641.5p 0 643.5p 1.65 828.5p 1.65 830.5p 0 917.5p 0 919.5p 1.65 1104.5p 1.65 1106.5p 0 1193.5p 0 1195.5p 1.65 1380.5p 1.65 1382.5p 0 1469.5p 0 1471.5p 1.65 1656.5p 1.65 1658.5p 0 1745.5p 0 1747.5p 1.65 1932.5p 1.65 1934.5p 0 2021.5p 0 2023.5p 1.65)
VGholdC gholdC_s gholdC 0
XSholdC sholdC gholdC vddh vddh sg13_lv_pmos w=60u l=0.13u
VSzeroC pC szeroC 0
VPGzeroC gzeroC_s 0 PWL(0 0 442.1p 0 444.1p 1.65 457.5p 1.65 459.5p 0 718.1p 0 720.1p 1.65 733.5p 1.65 735.5p 0 994.1p 0 996.1p 1.65 1009.5p 1.65 1011.5p 0 1270.1p 0 1272.1p 1.65 1285.5p 1.65 1287.5p 0 1546.1p 0 1548.1p 1.65 1561.5p 1.65 1563.5p 0 1822.1p 0 1824.1p 1.65 1837.5p 1.65 1839.5p 0 2098.1p 0 2100.1p 1.65 2113.5p 1.65 2115.5p 0)
VGzeroC gzeroC_s gzeroC 0
XSzeroC szeroC gzeroC vzr 0 sg13_lv_nmos w=10u l=0.13u
CXqdd xqdd 0 1
BXqdd 0 xqdd I={ -I(VDDH) }
RXqdd xqdd 0 0.01
CXqzr xqzr 0 1
BXqzr 0 xqzr I={ -I(VZR) }
RXqzr xqzr 0 0.01
CXerl xerl 0 1
BXerl 0 xerl I={ I(VML)*I(VML)*10 }
RXerl xerl 0 0.01
CXesw xesw 0 1
BXesw 0 xesw I={ (V(pA)-V(lin))*I(VSinA)+(V(pA)-V(lout))*I(VSoutA)+(V(pA)-V(vddh))*I(VSholdA)+(V(pA)-V(vzr))*I(VSzeroA)+(V(vddh)-V(lin))*I(VSindd)+(V(pB)-V(lin))*I(VSinB)+(V(pB)-V(lout))*I(VSoutB)+(V(pB)-V(vddh))*I(VSholdB)+(V(pB)-V(vzr))*I(VSzeroB)+(V(pC)-V(lin))*I(VSinC)+(V(pC)-V(lout))*I(VSoutC)+(V(pC)-V(vddh))*I(VSholdC)+(V(pC)-V(vzr))*I(VSzeroC) }
RXesw xesw 0 0.01
CXqg_inA xqg_inA 0 1
BXqg_inA 0 xqg_inA I={ I(VGinA) }
RXqg_inA xqg_inA 0 0.01
CXqg_pinA xqg_pinA 0 1
BXqg_pinA 0 xqg_pinA I={ I(VGPinA) }
RXqg_pinA xqg_pinA 0 0.01
CXqg_outA xqg_outA 0 1
BXqg_outA 0 xqg_outA I={ I(VGoutA) }
RXqg_outA xqg_outA 0 0.01
CXqg_poutA xqg_poutA 0 1
BXqg_poutA 0 xqg_poutA I={ I(VGPoutA) }
RXqg_poutA xqg_poutA 0 0.01
CXqg_holdA xqg_holdA 0 1
BXqg_holdA 0 xqg_holdA I={ I(VGholdA) }
RXqg_holdA xqg_holdA 0 0.01
CXqg_zeroA xqg_zeroA 0 1
BXqg_zeroA 0 xqg_zeroA I={ I(VGzeroA) }
RXqg_zeroA xqg_zeroA 0 0.01
CXqg_indd xqg_indd 0 1
BXqg_indd 0 xqg_indd I={ I(VGindd) }
RXqg_indd xqg_indd 0 0.01
CXqg_pindd xqg_pindd 0 1
BXqg_pindd 0 xqg_pindd I={ I(VGPindd) }
RXqg_pindd xqg_pindd 0 0.01
CXqg_inB xqg_inB 0 1
BXqg_inB 0 xqg_inB I={ I(VGinB) }
RXqg_inB xqg_inB 0 0.01
CXqg_pinB xqg_pinB 0 1
BXqg_pinB 0 xqg_pinB I={ I(VGPinB) }
RXqg_pinB xqg_pinB 0 0.01
CXqg_outB xqg_outB 0 1
BXqg_outB 0 xqg_outB I={ I(VGoutB) }
RXqg_outB xqg_outB 0 0.01
CXqg_poutB xqg_poutB 0 1
BXqg_poutB 0 xqg_poutB I={ I(VGPoutB) }
RXqg_poutB xqg_poutB 0 0.01
CXqg_holdB xqg_holdB 0 1
BXqg_holdB 0 xqg_holdB I={ I(VGholdB) }
RXqg_holdB xqg_holdB 0 0.01
CXqg_zeroB xqg_zeroB 0 1
BXqg_zeroB 0 xqg_zeroB I={ I(VGzeroB) }
RXqg_zeroB xqg_zeroB 0 0.01
CXqg_inC xqg_inC 0 1
BXqg_inC 0 xqg_inC I={ I(VGinC) }
RXqg_inC xqg_inC 0 0.01
CXqg_pinC xqg_pinC 0 1
BXqg_pinC 0 xqg_pinC I={ I(VGPinC) }
RXqg_pinC xqg_pinC 0 0.01
CXqg_outC xqg_outC 0 1
BXqg_outC 0 xqg_outC I={ I(VGoutC) }
RXqg_outC xqg_outC 0 0.01
CXqg_poutC xqg_poutC 0 1
BXqg_poutC 0 xqg_poutC I={ I(VGPoutC) }
RXqg_poutC xqg_poutC 0 0.01
CXqg_holdC xqg_holdC 0 1
BXqg_holdC 0 xqg_holdC I={ I(VGholdC) }
RXqg_holdC xqg_holdC 0 0.01
CXqg_zeroC xqg_zeroC 0 1
BXqg_zeroC 0 xqg_zeroC I={ I(VGzeroC) }
RXqg_zeroC xqg_zeroC 0 0.01
CXegn xegn 0 1
BXegn 0 xegn I={ V(ginA_s)*I(VGinA)+V(gpinA_s)*I(VGPinA)+V(goutA_s)*I(VGoutA)+V(gpoutA_s)*I(VGPoutA)+V(gholdA_s)*I(VGholdA)+V(gzeroA_s)*I(VGzeroA)+V(gindd_s)*I(VGindd)+V(gpindd_s)*I(VGPindd)+V(ginB_s)*I(VGinB)+V(gpinB_s)*I(VGPinB)+V(goutB_s)*I(VGoutB)+V(gpoutB_s)*I(VGPoutB)+V(gholdB_s)*I(VGholdB)+V(gzeroB_s)*I(VGzeroB)+V(ginC_s)*I(VGinC)+V(gpinC_s)*I(VGPinC)+V(goutC_s)*I(VGoutC)+V(gpoutC_s)*I(VGPoutC)+V(gholdC_s)*I(VGholdC)+V(gzeroC_s)*I(VGzeroC) }
RXegn xegn 0 0.01
VI1_0 in1_0 0 PWL(0 1.65 275p 1.65 277p 0 551p 0 553p 1.65 827p 1.65 829p 0 1103p 0 1105p 1.65 1379p 1.65 1381p 0 1655p 0 1657p 1.65 1931p 1.65 1933p 0)
VI1_1 in1_1 0 PWL(0 1.65 275p 1.65 277p 0 551p 0 553p 1.65 827p 1.65 829p 0 1103p 0 1105p 1.65 1379p 1.65 1381p 0 1655p 0 1657p 1.65 1931p 1.65 1933p 0)
VI1_2 in1_2 0 PWL(0 1.65 275p 1.65 277p 0 551p 0 553p 1.65 827p 1.65 829p 0 1103p 0 1105p 1.65 1379p 1.65 1381p 0 1655p 0 1657p 1.65 1931p 1.65 1933p 0)
VI1_3 in1_3 0 PWL(0 0 275p 0 277p 1.65 551p 1.65 553p 0 827p 0 829p 1.65 1103p 1.65 1105p 0 1379p 0 1381p 1.65 1655p 1.65 1657p 0 1931p 0 1933p 1.65)
VI1_4 in1_4 0 PWL(0 1.65 275p 1.65 277p 0 551p 0 553p 1.65 827p 1.65 829p 0 1103p 0 1105p 1.65 1379p 1.65 1381p 0 1655p 0 1657p 1.65 1931p 1.65 1933p 0)
VI1_5 in1_5 0 PWL(0 0 275p 0 277p 1.65 551p 1.65 553p 0 827p 0 829p 1.65 1103p 1.65 1105p 0 1379p 0 1381p 1.65 1655p 1.65 1657p 0 1931p 0 1933p 1.65)
VI1_6 in1_6 0 PWL(0 0 275p 0 277p 1.65 551p 1.65 553p 0 827p 0 829p 1.65 1103p 1.65 1105p 0 1379p 0 1381p 1.65 1655p 1.65 1657p 0 1931p 0 1933p 1.65)
VI1_7 in1_7 0 PWL(0 1.65 275p 1.65 277p 0 551p 0 553p 1.65 827p 1.65 829p 0 1103p 0 1105p 1.65 1379p 1.65 1381p 0 1655p 0 1657p 1.65 1931p 1.65 1933p 0)
VMG1 gn1 0 0
XP1_1_0 o1_1_0 in1_0 ph1 ph1 sg13_lv_pmos w=1.12u l=0.13u
XN1_1_0 o1_1_0 in1_0 gn1 gn1 sg13_lv_nmos w=0.74u l=0.13u
CL1_1_0 o1_1_0 gn1 2f
XP1_1_1 o1_1_1 in1_1 ph1 ph1 sg13_lv_pmos w=1.12u l=0.13u
XN1_1_1 o1_1_1 in1_1 gn1 gn1 sg13_lv_nmos w=0.74u l=0.13u
CL1_1_1 o1_1_1 gn1 2f
XP1_1_2 o1_1_2 in1_2 ph1 ph1 sg13_lv_pmos w=1.12u l=0.13u
XN1_1_2 o1_1_2 in1_2 gn1 gn1 sg13_lv_nmos w=0.74u l=0.13u
CL1_1_2 o1_1_2 gn1 2f
XP1_1_3 o1_1_3 in1_3 ph1 ph1 sg13_lv_pmos w=1.12u l=0.13u
XN1_1_3 o1_1_3 in1_3 gn1 gn1 sg13_lv_nmos w=0.74u l=0.13u
CL1_1_3 o1_1_3 gn1 2f
XP1_1_4 o1_1_4 in1_4 ph1 ph1 sg13_lv_pmos w=1.12u l=0.13u
XN1_1_4 o1_1_4 in1_4 gn1 gn1 sg13_lv_nmos w=0.74u l=0.13u
CL1_1_4 o1_1_4 gn1 2f
XP1_1_5 o1_1_5 in1_5 ph1 ph1 sg13_lv_pmos w=1.12u l=0.13u
XN1_1_5 o1_1_5 in1_5 gn1 gn1 sg13_lv_nmos w=0.74u l=0.13u
CL1_1_5 o1_1_5 gn1 2f
XP1_1_6 o1_1_6 in1_6 ph1 ph1 sg13_lv_pmos w=1.12u l=0.13u
XN1_1_6 o1_1_6 in1_6 gn1 gn1 sg13_lv_nmos w=0.74u l=0.13u
CL1_1_6 o1_1_6 gn1 2f
XP1_1_7 o1_1_7 in1_7 ph1 ph1 sg13_lv_pmos w=1.12u l=0.13u
XN1_1_7 o1_1_7 in1_7 gn1 gn1 sg13_lv_nmos w=0.74u l=0.13u
CL1_1_7 o1_1_7 gn1 2f
XP1_2_0 o1_2_0 o1_1_0 ph1 ph1 sg13_lv_pmos w=1.12u l=0.13u
XN1_2_0 o1_2_0 o1_1_0 gn1 gn1 sg13_lv_nmos w=0.74u l=0.13u
CL1_2_0 o1_2_0 gn1 2f
XP1_2_1 o1_2_1 o1_1_1 ph1 ph1 sg13_lv_pmos w=1.12u l=0.13u
XN1_2_1 o1_2_1 o1_1_1 gn1 gn1 sg13_lv_nmos w=0.74u l=0.13u
CL1_2_1 o1_2_1 gn1 2f
XP1_2_2 o1_2_2 o1_1_2 ph1 ph1 sg13_lv_pmos w=1.12u l=0.13u
XN1_2_2 o1_2_2 o1_1_2 gn1 gn1 sg13_lv_nmos w=0.74u l=0.13u
CL1_2_2 o1_2_2 gn1 2f
XP1_2_3 o1_2_3 o1_1_3 ph1 ph1 sg13_lv_pmos w=1.12u l=0.13u
XN1_2_3 o1_2_3 o1_1_3 gn1 gn1 sg13_lv_nmos w=0.74u l=0.13u
CL1_2_3 o1_2_3 gn1 2f
XP1_2_4 o1_2_4 o1_1_4 ph1 ph1 sg13_lv_pmos w=1.12u l=0.13u
XN1_2_4 o1_2_4 o1_1_4 gn1 gn1 sg13_lv_nmos w=0.74u l=0.13u
CL1_2_4 o1_2_4 gn1 2f
XP1_2_5 o1_2_5 o1_1_5 ph1 ph1 sg13_lv_pmos w=1.12u l=0.13u
XN1_2_5 o1_2_5 o1_1_5 gn1 gn1 sg13_lv_nmos w=0.74u l=0.13u
CL1_2_5 o1_2_5 gn1 2f
XP1_2_6 o1_2_6 o1_1_6 ph1 ph1 sg13_lv_pmos w=1.12u l=0.13u
XN1_2_6 o1_2_6 o1_1_6 gn1 gn1 sg13_lv_nmos w=0.74u l=0.13u
CL1_2_6 o1_2_6 gn1 2f
XP1_2_7 o1_2_7 o1_1_7 ph1 ph1 sg13_lv_pmos w=1.12u l=0.13u
XN1_2_7 o1_2_7 o1_1_7 gn1 gn1 sg13_lv_nmos w=0.74u l=0.13u
CL1_2_7 o1_2_7 gn1 2f
XP1_3_0 o1_3_0 o1_2_0 ph1 ph1 sg13_lv_pmos w=1.12u l=0.13u
XN1_3_0 o1_3_0 o1_2_0 gn1 gn1 sg13_lv_nmos w=0.74u l=0.13u
CL1_3_0 o1_3_0 gn1 2f
XP1_3_1 o1_3_1 o1_2_1 ph1 ph1 sg13_lv_pmos w=1.12u l=0.13u
XN1_3_1 o1_3_1 o1_2_1 gn1 gn1 sg13_lv_nmos w=0.74u l=0.13u
CL1_3_1 o1_3_1 gn1 2f
XP1_3_2 o1_3_2 o1_2_2 ph1 ph1 sg13_lv_pmos w=1.12u l=0.13u
XN1_3_2 o1_3_2 o1_2_2 gn1 gn1 sg13_lv_nmos w=0.74u l=0.13u
CL1_3_2 o1_3_2 gn1 2f
XP1_3_3 o1_3_3 o1_2_3 ph1 ph1 sg13_lv_pmos w=1.12u l=0.13u
XN1_3_3 o1_3_3 o1_2_3 gn1 gn1 sg13_lv_nmos w=0.74u l=0.13u
CL1_3_3 o1_3_3 gn1 2f
XP1_3_4 o1_3_4 o1_2_4 ph1 ph1 sg13_lv_pmos w=1.12u l=0.13u
XN1_3_4 o1_3_4 o1_2_4 gn1 gn1 sg13_lv_nmos w=0.74u l=0.13u
CL1_3_4 o1_3_4 gn1 2f
XP1_3_5 o1_3_5 o1_2_5 ph1 ph1 sg13_lv_pmos w=1.12u l=0.13u
XN1_3_5 o1_3_5 o1_2_5 gn1 gn1 sg13_lv_nmos w=0.74u l=0.13u
CL1_3_5 o1_3_5 gn1 2f
XP1_3_6 o1_3_6 o1_2_6 ph1 ph1 sg13_lv_pmos w=1.12u l=0.13u
XN1_3_6 o1_3_6 o1_2_6 gn1 gn1 sg13_lv_nmos w=0.74u l=0.13u
CL1_3_6 o1_3_6 gn1 2f
XP1_3_7 o1_3_7 o1_2_7 ph1 ph1 sg13_lv_pmos w=1.12u l=0.13u
XN1_3_7 o1_3_7 o1_2_7 gn1 gn1 sg13_lv_nmos w=0.74u l=0.13u
CL1_3_7 o1_3_7 gn1 2f
VMG2 gn2 0 0
XP2_1_0 o2_1_0 o1_3_0 ph2 ph2 sg13_lv_pmos w=1.12u l=0.13u
XN2_1_0 o2_1_0 o1_3_0 gn2 gn2 sg13_lv_nmos w=0.74u l=0.13u
CL2_1_0 o2_1_0 gn2 2f
XP2_1_1 o2_1_1 o1_3_1 ph2 ph2 sg13_lv_pmos w=1.12u l=0.13u
XN2_1_1 o2_1_1 o1_3_1 gn2 gn2 sg13_lv_nmos w=0.74u l=0.13u
CL2_1_1 o2_1_1 gn2 2f
XP2_1_2 o2_1_2 o1_3_2 ph2 ph2 sg13_lv_pmos w=1.12u l=0.13u
XN2_1_2 o2_1_2 o1_3_2 gn2 gn2 sg13_lv_nmos w=0.74u l=0.13u
CL2_1_2 o2_1_2 gn2 2f
XP2_1_3 o2_1_3 o1_3_3 ph2 ph2 sg13_lv_pmos w=1.12u l=0.13u
XN2_1_3 o2_1_3 o1_3_3 gn2 gn2 sg13_lv_nmos w=0.74u l=0.13u
CL2_1_3 o2_1_3 gn2 2f
XP2_1_4 o2_1_4 o1_3_4 ph2 ph2 sg13_lv_pmos w=1.12u l=0.13u
XN2_1_4 o2_1_4 o1_3_4 gn2 gn2 sg13_lv_nmos w=0.74u l=0.13u
CL2_1_4 o2_1_4 gn2 2f
XP2_1_5 o2_1_5 o1_3_5 ph2 ph2 sg13_lv_pmos w=1.12u l=0.13u
XN2_1_5 o2_1_5 o1_3_5 gn2 gn2 sg13_lv_nmos w=0.74u l=0.13u
CL2_1_5 o2_1_5 gn2 2f
XP2_1_6 o2_1_6 o1_3_6 ph2 ph2 sg13_lv_pmos w=1.12u l=0.13u
XN2_1_6 o2_1_6 o1_3_6 gn2 gn2 sg13_lv_nmos w=0.74u l=0.13u
CL2_1_6 o2_1_6 gn2 2f
XP2_1_7 o2_1_7 o1_3_7 ph2 ph2 sg13_lv_pmos w=1.12u l=0.13u
XN2_1_7 o2_1_7 o1_3_7 gn2 gn2 sg13_lv_nmos w=0.74u l=0.13u
CL2_1_7 o2_1_7 gn2 2f
XP2_2_0 o2_2_0 o2_1_0 ph2 ph2 sg13_lv_pmos w=1.12u l=0.13u
XN2_2_0 o2_2_0 o2_1_0 gn2 gn2 sg13_lv_nmos w=0.74u l=0.13u
CL2_2_0 o2_2_0 gn2 2f
XP2_2_1 o2_2_1 o2_1_1 ph2 ph2 sg13_lv_pmos w=1.12u l=0.13u
XN2_2_1 o2_2_1 o2_1_1 gn2 gn2 sg13_lv_nmos w=0.74u l=0.13u
CL2_2_1 o2_2_1 gn2 2f
XP2_2_2 o2_2_2 o2_1_2 ph2 ph2 sg13_lv_pmos w=1.12u l=0.13u
XN2_2_2 o2_2_2 o2_1_2 gn2 gn2 sg13_lv_nmos w=0.74u l=0.13u
CL2_2_2 o2_2_2 gn2 2f
XP2_2_3 o2_2_3 o2_1_3 ph2 ph2 sg13_lv_pmos w=1.12u l=0.13u
XN2_2_3 o2_2_3 o2_1_3 gn2 gn2 sg13_lv_nmos w=0.74u l=0.13u
CL2_2_3 o2_2_3 gn2 2f
XP2_2_4 o2_2_4 o2_1_4 ph2 ph2 sg13_lv_pmos w=1.12u l=0.13u
XN2_2_4 o2_2_4 o2_1_4 gn2 gn2 sg13_lv_nmos w=0.74u l=0.13u
CL2_2_4 o2_2_4 gn2 2f
XP2_2_5 o2_2_5 o2_1_5 ph2 ph2 sg13_lv_pmos w=1.12u l=0.13u
XN2_2_5 o2_2_5 o2_1_5 gn2 gn2 sg13_lv_nmos w=0.74u l=0.13u
CL2_2_5 o2_2_5 gn2 2f
XP2_2_6 o2_2_6 o2_1_6 ph2 ph2 sg13_lv_pmos w=1.12u l=0.13u
XN2_2_6 o2_2_6 o2_1_6 gn2 gn2 sg13_lv_nmos w=0.74u l=0.13u
CL2_2_6 o2_2_6 gn2 2f
XP2_2_7 o2_2_7 o2_1_7 ph2 ph2 sg13_lv_pmos w=1.12u l=0.13u
XN2_2_7 o2_2_7 o2_1_7 gn2 gn2 sg13_lv_nmos w=0.74u l=0.13u
CL2_2_7 o2_2_7 gn2 2f
XP2_3_0 o2_3_0 o2_2_0 ph2 ph2 sg13_lv_pmos w=1.12u l=0.13u
XN2_3_0 o2_3_0 o2_2_0 gn2 gn2 sg13_lv_nmos w=0.74u l=0.13u
CL2_3_0 o2_3_0 gn2 2f
XP2_3_1 o2_3_1 o2_2_1 ph2 ph2 sg13_lv_pmos w=1.12u l=0.13u
XN2_3_1 o2_3_1 o2_2_1 gn2 gn2 sg13_lv_nmos w=0.74u l=0.13u
CL2_3_1 o2_3_1 gn2 2f
XP2_3_2 o2_3_2 o2_2_2 ph2 ph2 sg13_lv_pmos w=1.12u l=0.13u
XN2_3_2 o2_3_2 o2_2_2 gn2 gn2 sg13_lv_nmos w=0.74u l=0.13u
CL2_3_2 o2_3_2 gn2 2f
XP2_3_3 o2_3_3 o2_2_3 ph2 ph2 sg13_lv_pmos w=1.12u l=0.13u
XN2_3_3 o2_3_3 o2_2_3 gn2 gn2 sg13_lv_nmos w=0.74u l=0.13u
CL2_3_3 o2_3_3 gn2 2f
XP2_3_4 o2_3_4 o2_2_4 ph2 ph2 sg13_lv_pmos w=1.12u l=0.13u
XN2_3_4 o2_3_4 o2_2_4 gn2 gn2 sg13_lv_nmos w=0.74u l=0.13u
CL2_3_4 o2_3_4 gn2 2f
XP2_3_5 o2_3_5 o2_2_5 ph2 ph2 sg13_lv_pmos w=1.12u l=0.13u
XN2_3_5 o2_3_5 o2_2_5 gn2 gn2 sg13_lv_nmos w=0.74u l=0.13u
CL2_3_5 o2_3_5 gn2 2f
XP2_3_6 o2_3_6 o2_2_6 ph2 ph2 sg13_lv_pmos w=1.12u l=0.13u
XN2_3_6 o2_3_6 o2_2_6 gn2 gn2 sg13_lv_nmos w=0.74u l=0.13u
CL2_3_6 o2_3_6 gn2 2f
XP2_3_7 o2_3_7 o2_2_7 ph2 ph2 sg13_lv_pmos w=1.12u l=0.13u
XN2_3_7 o2_3_7 o2_2_7 gn2 gn2 sg13_lv_nmos w=0.74u l=0.13u
CL2_3_7 o2_3_7 gn2 2f
VMG3 gn3 0 0
XP3_1_0 o3_1_0 o2_3_0 ph3 ph3 sg13_lv_pmos w=1.12u l=0.13u
XN3_1_0 o3_1_0 o2_3_0 gn3 gn3 sg13_lv_nmos w=0.74u l=0.13u
CL3_1_0 o3_1_0 gn3 2f
XP3_1_1 o3_1_1 o2_3_1 ph3 ph3 sg13_lv_pmos w=1.12u l=0.13u
XN3_1_1 o3_1_1 o2_3_1 gn3 gn3 sg13_lv_nmos w=0.74u l=0.13u
CL3_1_1 o3_1_1 gn3 2f
XP3_1_2 o3_1_2 o2_3_2 ph3 ph3 sg13_lv_pmos w=1.12u l=0.13u
XN3_1_2 o3_1_2 o2_3_2 gn3 gn3 sg13_lv_nmos w=0.74u l=0.13u
CL3_1_2 o3_1_2 gn3 2f
XP3_1_3 o3_1_3 o2_3_3 ph3 ph3 sg13_lv_pmos w=1.12u l=0.13u
XN3_1_3 o3_1_3 o2_3_3 gn3 gn3 sg13_lv_nmos w=0.74u l=0.13u
CL3_1_3 o3_1_3 gn3 2f
XP3_1_4 o3_1_4 o2_3_4 ph3 ph3 sg13_lv_pmos w=1.12u l=0.13u
XN3_1_4 o3_1_4 o2_3_4 gn3 gn3 sg13_lv_nmos w=0.74u l=0.13u
CL3_1_4 o3_1_4 gn3 2f
XP3_1_5 o3_1_5 o2_3_5 ph3 ph3 sg13_lv_pmos w=1.12u l=0.13u
XN3_1_5 o3_1_5 o2_3_5 gn3 gn3 sg13_lv_nmos w=0.74u l=0.13u
CL3_1_5 o3_1_5 gn3 2f
XP3_1_6 o3_1_6 o2_3_6 ph3 ph3 sg13_lv_pmos w=1.12u l=0.13u
XN3_1_6 o3_1_6 o2_3_6 gn3 gn3 sg13_lv_nmos w=0.74u l=0.13u
CL3_1_6 o3_1_6 gn3 2f
XP3_1_7 o3_1_7 o2_3_7 ph3 ph3 sg13_lv_pmos w=1.12u l=0.13u
XN3_1_7 o3_1_7 o2_3_7 gn3 gn3 sg13_lv_nmos w=0.74u l=0.13u
CL3_1_7 o3_1_7 gn3 2f
XP3_2_0 o3_2_0 o3_1_0 ph3 ph3 sg13_lv_pmos w=1.12u l=0.13u
XN3_2_0 o3_2_0 o3_1_0 gn3 gn3 sg13_lv_nmos w=0.74u l=0.13u
CL3_2_0 o3_2_0 gn3 2f
XP3_2_1 o3_2_1 o3_1_1 ph3 ph3 sg13_lv_pmos w=1.12u l=0.13u
XN3_2_1 o3_2_1 o3_1_1 gn3 gn3 sg13_lv_nmos w=0.74u l=0.13u
CL3_2_1 o3_2_1 gn3 2f
XP3_2_2 o3_2_2 o3_1_2 ph3 ph3 sg13_lv_pmos w=1.12u l=0.13u
XN3_2_2 o3_2_2 o3_1_2 gn3 gn3 sg13_lv_nmos w=0.74u l=0.13u
CL3_2_2 o3_2_2 gn3 2f
XP3_2_3 o3_2_3 o3_1_3 ph3 ph3 sg13_lv_pmos w=1.12u l=0.13u
XN3_2_3 o3_2_3 o3_1_3 gn3 gn3 sg13_lv_nmos w=0.74u l=0.13u
CL3_2_3 o3_2_3 gn3 2f
XP3_2_4 o3_2_4 o3_1_4 ph3 ph3 sg13_lv_pmos w=1.12u l=0.13u
XN3_2_4 o3_2_4 o3_1_4 gn3 gn3 sg13_lv_nmos w=0.74u l=0.13u
CL3_2_4 o3_2_4 gn3 2f
XP3_2_5 o3_2_5 o3_1_5 ph3 ph3 sg13_lv_pmos w=1.12u l=0.13u
XN3_2_5 o3_2_5 o3_1_5 gn3 gn3 sg13_lv_nmos w=0.74u l=0.13u
CL3_2_5 o3_2_5 gn3 2f
XP3_2_6 o3_2_6 o3_1_6 ph3 ph3 sg13_lv_pmos w=1.12u l=0.13u
XN3_2_6 o3_2_6 o3_1_6 gn3 gn3 sg13_lv_nmos w=0.74u l=0.13u
CL3_2_6 o3_2_6 gn3 2f
XP3_2_7 o3_2_7 o3_1_7 ph3 ph3 sg13_lv_pmos w=1.12u l=0.13u
XN3_2_7 o3_2_7 o3_1_7 gn3 gn3 sg13_lv_nmos w=0.74u l=0.13u
CL3_2_7 o3_2_7 gn3 2f
XP3_3_0 o3_3_0 o3_2_0 ph3 ph3 sg13_lv_pmos w=1.12u l=0.13u
XN3_3_0 o3_3_0 o3_2_0 gn3 gn3 sg13_lv_nmos w=0.74u l=0.13u
CL3_3_0 o3_3_0 gn3 2f
XP3_3_1 o3_3_1 o3_2_1 ph3 ph3 sg13_lv_pmos w=1.12u l=0.13u
XN3_3_1 o3_3_1 o3_2_1 gn3 gn3 sg13_lv_nmos w=0.74u l=0.13u
CL3_3_1 o3_3_1 gn3 2f
XP3_3_2 o3_3_2 o3_2_2 ph3 ph3 sg13_lv_pmos w=1.12u l=0.13u
XN3_3_2 o3_3_2 o3_2_2 gn3 gn3 sg13_lv_nmos w=0.74u l=0.13u
CL3_3_2 o3_3_2 gn3 2f
XP3_3_3 o3_3_3 o3_2_3 ph3 ph3 sg13_lv_pmos w=1.12u l=0.13u
XN3_3_3 o3_3_3 o3_2_3 gn3 gn3 sg13_lv_nmos w=0.74u l=0.13u
CL3_3_3 o3_3_3 gn3 2f
XP3_3_4 o3_3_4 o3_2_4 ph3 ph3 sg13_lv_pmos w=1.12u l=0.13u
XN3_3_4 o3_3_4 o3_2_4 gn3 gn3 sg13_lv_nmos w=0.74u l=0.13u
CL3_3_4 o3_3_4 gn3 2f
XP3_3_5 o3_3_5 o3_2_5 ph3 ph3 sg13_lv_pmos w=1.12u l=0.13u
XN3_3_5 o3_3_5 o3_2_5 gn3 gn3 sg13_lv_nmos w=0.74u l=0.13u
CL3_3_5 o3_3_5 gn3 2f
XP3_3_6 o3_3_6 o3_2_6 ph3 ph3 sg13_lv_pmos w=1.12u l=0.13u
XN3_3_6 o3_3_6 o3_2_6 gn3 gn3 sg13_lv_nmos w=0.74u l=0.13u
CL3_3_6 o3_3_6 gn3 2f
XP3_3_7 o3_3_7 o3_2_7 ph3 ph3 sg13_lv_pmos w=1.12u l=0.13u
XN3_3_7 o3_3_7 o3_2_7 gn3 gn3 sg13_lv_nmos w=0.74u l=0.13u
CL3_3_7 o3_3_7 gn3 2f
VMG4 gn4 0 0
XP4_1_0 o4_1_0 o3_3_0 ph4 ph4 sg13_lv_pmos w=1.12u l=0.13u
XN4_1_0 o4_1_0 o3_3_0 gn4 gn4 sg13_lv_nmos w=0.74u l=0.13u
CL4_1_0 o4_1_0 gn4 2f
XP4_1_1 o4_1_1 o3_3_1 ph4 ph4 sg13_lv_pmos w=1.12u l=0.13u
XN4_1_1 o4_1_1 o3_3_1 gn4 gn4 sg13_lv_nmos w=0.74u l=0.13u
CL4_1_1 o4_1_1 gn4 2f
XP4_1_2 o4_1_2 o3_3_2 ph4 ph4 sg13_lv_pmos w=1.12u l=0.13u
XN4_1_2 o4_1_2 o3_3_2 gn4 gn4 sg13_lv_nmos w=0.74u l=0.13u
CL4_1_2 o4_1_2 gn4 2f
XP4_1_3 o4_1_3 o3_3_3 ph4 ph4 sg13_lv_pmos w=1.12u l=0.13u
XN4_1_3 o4_1_3 o3_3_3 gn4 gn4 sg13_lv_nmos w=0.74u l=0.13u
CL4_1_3 o4_1_3 gn4 2f
XP4_1_4 o4_1_4 o3_3_4 ph4 ph4 sg13_lv_pmos w=1.12u l=0.13u
XN4_1_4 o4_1_4 o3_3_4 gn4 gn4 sg13_lv_nmos w=0.74u l=0.13u
CL4_1_4 o4_1_4 gn4 2f
XP4_1_5 o4_1_5 o3_3_5 ph4 ph4 sg13_lv_pmos w=1.12u l=0.13u
XN4_1_5 o4_1_5 o3_3_5 gn4 gn4 sg13_lv_nmos w=0.74u l=0.13u
CL4_1_5 o4_1_5 gn4 2f
XP4_1_6 o4_1_6 o3_3_6 ph4 ph4 sg13_lv_pmos w=1.12u l=0.13u
XN4_1_6 o4_1_6 o3_3_6 gn4 gn4 sg13_lv_nmos w=0.74u l=0.13u
CL4_1_6 o4_1_6 gn4 2f
XP4_1_7 o4_1_7 o3_3_7 ph4 ph4 sg13_lv_pmos w=1.12u l=0.13u
XN4_1_7 o4_1_7 o3_3_7 gn4 gn4 sg13_lv_nmos w=0.74u l=0.13u
CL4_1_7 o4_1_7 gn4 2f
XP4_2_0 o4_2_0 o4_1_0 ph4 ph4 sg13_lv_pmos w=1.12u l=0.13u
XN4_2_0 o4_2_0 o4_1_0 gn4 gn4 sg13_lv_nmos w=0.74u l=0.13u
CL4_2_0 o4_2_0 gn4 2f
XP4_2_1 o4_2_1 o4_1_1 ph4 ph4 sg13_lv_pmos w=1.12u l=0.13u
XN4_2_1 o4_2_1 o4_1_1 gn4 gn4 sg13_lv_nmos w=0.74u l=0.13u
CL4_2_1 o4_2_1 gn4 2f
XP4_2_2 o4_2_2 o4_1_2 ph4 ph4 sg13_lv_pmos w=1.12u l=0.13u
XN4_2_2 o4_2_2 o4_1_2 gn4 gn4 sg13_lv_nmos w=0.74u l=0.13u
CL4_2_2 o4_2_2 gn4 2f
XP4_2_3 o4_2_3 o4_1_3 ph4 ph4 sg13_lv_pmos w=1.12u l=0.13u
XN4_2_3 o4_2_3 o4_1_3 gn4 gn4 sg13_lv_nmos w=0.74u l=0.13u
CL4_2_3 o4_2_3 gn4 2f
XP4_2_4 o4_2_4 o4_1_4 ph4 ph4 sg13_lv_pmos w=1.12u l=0.13u
XN4_2_4 o4_2_4 o4_1_4 gn4 gn4 sg13_lv_nmos w=0.74u l=0.13u
CL4_2_4 o4_2_4 gn4 2f
XP4_2_5 o4_2_5 o4_1_5 ph4 ph4 sg13_lv_pmos w=1.12u l=0.13u
XN4_2_5 o4_2_5 o4_1_5 gn4 gn4 sg13_lv_nmos w=0.74u l=0.13u
CL4_2_5 o4_2_5 gn4 2f
XP4_2_6 o4_2_6 o4_1_6 ph4 ph4 sg13_lv_pmos w=1.12u l=0.13u
XN4_2_6 o4_2_6 o4_1_6 gn4 gn4 sg13_lv_nmos w=0.74u l=0.13u
CL4_2_6 o4_2_6 gn4 2f
XP4_2_7 o4_2_7 o4_1_7 ph4 ph4 sg13_lv_pmos w=1.12u l=0.13u
XN4_2_7 o4_2_7 o4_1_7 gn4 gn4 sg13_lv_nmos w=0.74u l=0.13u
CL4_2_7 o4_2_7 gn4 2f
XP4_3_0 o4_3_0 o4_2_0 ph4 ph4 sg13_lv_pmos w=1.12u l=0.13u
XN4_3_0 o4_3_0 o4_2_0 gn4 gn4 sg13_lv_nmos w=0.74u l=0.13u
CL4_3_0 o4_3_0 gn4 2f
XP4_3_1 o4_3_1 o4_2_1 ph4 ph4 sg13_lv_pmos w=1.12u l=0.13u
XN4_3_1 o4_3_1 o4_2_1 gn4 gn4 sg13_lv_nmos w=0.74u l=0.13u
CL4_3_1 o4_3_1 gn4 2f
XP4_3_2 o4_3_2 o4_2_2 ph4 ph4 sg13_lv_pmos w=1.12u l=0.13u
XN4_3_2 o4_3_2 o4_2_2 gn4 gn4 sg13_lv_nmos w=0.74u l=0.13u
CL4_3_2 o4_3_2 gn4 2f
XP4_3_3 o4_3_3 o4_2_3 ph4 ph4 sg13_lv_pmos w=1.12u l=0.13u
XN4_3_3 o4_3_3 o4_2_3 gn4 gn4 sg13_lv_nmos w=0.74u l=0.13u
CL4_3_3 o4_3_3 gn4 2f
XP4_3_4 o4_3_4 o4_2_4 ph4 ph4 sg13_lv_pmos w=1.12u l=0.13u
XN4_3_4 o4_3_4 o4_2_4 gn4 gn4 sg13_lv_nmos w=0.74u l=0.13u
CL4_3_4 o4_3_4 gn4 2f
XP4_3_5 o4_3_5 o4_2_5 ph4 ph4 sg13_lv_pmos w=1.12u l=0.13u
XN4_3_5 o4_3_5 o4_2_5 gn4 gn4 sg13_lv_nmos w=0.74u l=0.13u
CL4_3_5 o4_3_5 gn4 2f
XP4_3_6 o4_3_6 o4_2_6 ph4 ph4 sg13_lv_pmos w=1.12u l=0.13u
XN4_3_6 o4_3_6 o4_2_6 gn4 gn4 sg13_lv_nmos w=0.74u l=0.13u
CL4_3_6 o4_3_6 gn4 2f
XP4_3_7 o4_3_7 o4_2_7 ph4 ph4 sg13_lv_pmos w=1.12u l=0.13u
XN4_3_7 o4_3_7 o4_2_7 gn4 gn4 sg13_lv_nmos w=0.74u l=0.13u
CL4_3_7 o4_3_7 gn4 2f
VMG5 gn5 0 0
XP5_1_0 o5_1_0 o4_3_0 ph5 ph5 sg13_lv_pmos w=1.12u l=0.13u
XN5_1_0 o5_1_0 o4_3_0 gn5 gn5 sg13_lv_nmos w=0.74u l=0.13u
CL5_1_0 o5_1_0 gn5 2f
XP5_1_1 o5_1_1 o4_3_1 ph5 ph5 sg13_lv_pmos w=1.12u l=0.13u
XN5_1_1 o5_1_1 o4_3_1 gn5 gn5 sg13_lv_nmos w=0.74u l=0.13u
CL5_1_1 o5_1_1 gn5 2f
XP5_1_2 o5_1_2 o4_3_2 ph5 ph5 sg13_lv_pmos w=1.12u l=0.13u
XN5_1_2 o5_1_2 o4_3_2 gn5 gn5 sg13_lv_nmos w=0.74u l=0.13u
CL5_1_2 o5_1_2 gn5 2f
XP5_1_3 o5_1_3 o4_3_3 ph5 ph5 sg13_lv_pmos w=1.12u l=0.13u
XN5_1_3 o5_1_3 o4_3_3 gn5 gn5 sg13_lv_nmos w=0.74u l=0.13u
CL5_1_3 o5_1_3 gn5 2f
XP5_1_4 o5_1_4 o4_3_4 ph5 ph5 sg13_lv_pmos w=1.12u l=0.13u
XN5_1_4 o5_1_4 o4_3_4 gn5 gn5 sg13_lv_nmos w=0.74u l=0.13u
CL5_1_4 o5_1_4 gn5 2f
XP5_1_5 o5_1_5 o4_3_5 ph5 ph5 sg13_lv_pmos w=1.12u l=0.13u
XN5_1_5 o5_1_5 o4_3_5 gn5 gn5 sg13_lv_nmos w=0.74u l=0.13u
CL5_1_5 o5_1_5 gn5 2f
XP5_1_6 o5_1_6 o4_3_6 ph5 ph5 sg13_lv_pmos w=1.12u l=0.13u
XN5_1_6 o5_1_6 o4_3_6 gn5 gn5 sg13_lv_nmos w=0.74u l=0.13u
CL5_1_6 o5_1_6 gn5 2f
XP5_1_7 o5_1_7 o4_3_7 ph5 ph5 sg13_lv_pmos w=1.12u l=0.13u
XN5_1_7 o5_1_7 o4_3_7 gn5 gn5 sg13_lv_nmos w=0.74u l=0.13u
CL5_1_7 o5_1_7 gn5 2f
XP5_2_0 o5_2_0 o5_1_0 ph5 ph5 sg13_lv_pmos w=1.12u l=0.13u
XN5_2_0 o5_2_0 o5_1_0 gn5 gn5 sg13_lv_nmos w=0.74u l=0.13u
CL5_2_0 o5_2_0 gn5 2f
XP5_2_1 o5_2_1 o5_1_1 ph5 ph5 sg13_lv_pmos w=1.12u l=0.13u
XN5_2_1 o5_2_1 o5_1_1 gn5 gn5 sg13_lv_nmos w=0.74u l=0.13u
CL5_2_1 o5_2_1 gn5 2f
XP5_2_2 o5_2_2 o5_1_2 ph5 ph5 sg13_lv_pmos w=1.12u l=0.13u
XN5_2_2 o5_2_2 o5_1_2 gn5 gn5 sg13_lv_nmos w=0.74u l=0.13u
CL5_2_2 o5_2_2 gn5 2f
XP5_2_3 o5_2_3 o5_1_3 ph5 ph5 sg13_lv_pmos w=1.12u l=0.13u
XN5_2_3 o5_2_3 o5_1_3 gn5 gn5 sg13_lv_nmos w=0.74u l=0.13u
CL5_2_3 o5_2_3 gn5 2f
XP5_2_4 o5_2_4 o5_1_4 ph5 ph5 sg13_lv_pmos w=1.12u l=0.13u
XN5_2_4 o5_2_4 o5_1_4 gn5 gn5 sg13_lv_nmos w=0.74u l=0.13u
CL5_2_4 o5_2_4 gn5 2f
XP5_2_5 o5_2_5 o5_1_5 ph5 ph5 sg13_lv_pmos w=1.12u l=0.13u
XN5_2_5 o5_2_5 o5_1_5 gn5 gn5 sg13_lv_nmos w=0.74u l=0.13u
CL5_2_5 o5_2_5 gn5 2f
XP5_2_6 o5_2_6 o5_1_6 ph5 ph5 sg13_lv_pmos w=1.12u l=0.13u
XN5_2_6 o5_2_6 o5_1_6 gn5 gn5 sg13_lv_nmos w=0.74u l=0.13u
CL5_2_6 o5_2_6 gn5 2f
XP5_2_7 o5_2_7 o5_1_7 ph5 ph5 sg13_lv_pmos w=1.12u l=0.13u
XN5_2_7 o5_2_7 o5_1_7 gn5 gn5 sg13_lv_nmos w=0.74u l=0.13u
CL5_2_7 o5_2_7 gn5 2f
XP5_3_0 o5_3_0 o5_2_0 ph5 ph5 sg13_lv_pmos w=1.12u l=0.13u
XN5_3_0 o5_3_0 o5_2_0 gn5 gn5 sg13_lv_nmos w=0.74u l=0.13u
CL5_3_0 o5_3_0 gn5 2f
XP5_3_1 o5_3_1 o5_2_1 ph5 ph5 sg13_lv_pmos w=1.12u l=0.13u
XN5_3_1 o5_3_1 o5_2_1 gn5 gn5 sg13_lv_nmos w=0.74u l=0.13u
CL5_3_1 o5_3_1 gn5 2f
XP5_3_2 o5_3_2 o5_2_2 ph5 ph5 sg13_lv_pmos w=1.12u l=0.13u
XN5_3_2 o5_3_2 o5_2_2 gn5 gn5 sg13_lv_nmos w=0.74u l=0.13u
CL5_3_2 o5_3_2 gn5 2f
XP5_3_3 o5_3_3 o5_2_3 ph5 ph5 sg13_lv_pmos w=1.12u l=0.13u
XN5_3_3 o5_3_3 o5_2_3 gn5 gn5 sg13_lv_nmos w=0.74u l=0.13u
CL5_3_3 o5_3_3 gn5 2f
XP5_3_4 o5_3_4 o5_2_4 ph5 ph5 sg13_lv_pmos w=1.12u l=0.13u
XN5_3_4 o5_3_4 o5_2_4 gn5 gn5 sg13_lv_nmos w=0.74u l=0.13u
CL5_3_4 o5_3_4 gn5 2f
XP5_3_5 o5_3_5 o5_2_5 ph5 ph5 sg13_lv_pmos w=1.12u l=0.13u
XN5_3_5 o5_3_5 o5_2_5 gn5 gn5 sg13_lv_nmos w=0.74u l=0.13u
CL5_3_5 o5_3_5 gn5 2f
XP5_3_6 o5_3_6 o5_2_6 ph5 ph5 sg13_lv_pmos w=1.12u l=0.13u
XN5_3_6 o5_3_6 o5_2_6 gn5 gn5 sg13_lv_nmos w=0.74u l=0.13u
CL5_3_6 o5_3_6 gn5 2f
XP5_3_7 o5_3_7 o5_2_7 ph5 ph5 sg13_lv_pmos w=1.12u l=0.13u
XN5_3_7 o5_3_7 o5_2_7 gn5 gn5 sg13_lv_nmos w=0.74u l=0.13u
CL5_3_7 o5_3_7 gn5 2f
VMG6 gn6 0 0
XP6_1_0 o6_1_0 o5_3_0 ph6 ph6 sg13_lv_pmos w=1.12u l=0.13u
XN6_1_0 o6_1_0 o5_3_0 gn6 gn6 sg13_lv_nmos w=0.74u l=0.13u
CL6_1_0 o6_1_0 gn6 2f
XP6_1_1 o6_1_1 o5_3_1 ph6 ph6 sg13_lv_pmos w=1.12u l=0.13u
XN6_1_1 o6_1_1 o5_3_1 gn6 gn6 sg13_lv_nmos w=0.74u l=0.13u
CL6_1_1 o6_1_1 gn6 2f
XP6_1_2 o6_1_2 o5_3_2 ph6 ph6 sg13_lv_pmos w=1.12u l=0.13u
XN6_1_2 o6_1_2 o5_3_2 gn6 gn6 sg13_lv_nmos w=0.74u l=0.13u
CL6_1_2 o6_1_2 gn6 2f
XP6_1_3 o6_1_3 o5_3_3 ph6 ph6 sg13_lv_pmos w=1.12u l=0.13u
XN6_1_3 o6_1_3 o5_3_3 gn6 gn6 sg13_lv_nmos w=0.74u l=0.13u
CL6_1_3 o6_1_3 gn6 2f
XP6_1_4 o6_1_4 o5_3_4 ph6 ph6 sg13_lv_pmos w=1.12u l=0.13u
XN6_1_4 o6_1_4 o5_3_4 gn6 gn6 sg13_lv_nmos w=0.74u l=0.13u
CL6_1_4 o6_1_4 gn6 2f
XP6_1_5 o6_1_5 o5_3_5 ph6 ph6 sg13_lv_pmos w=1.12u l=0.13u
XN6_1_5 o6_1_5 o5_3_5 gn6 gn6 sg13_lv_nmos w=0.74u l=0.13u
CL6_1_5 o6_1_5 gn6 2f
XP6_1_6 o6_1_6 o5_3_6 ph6 ph6 sg13_lv_pmos w=1.12u l=0.13u
XN6_1_6 o6_1_6 o5_3_6 gn6 gn6 sg13_lv_nmos w=0.74u l=0.13u
CL6_1_6 o6_1_6 gn6 2f
XP6_1_7 o6_1_7 o5_3_7 ph6 ph6 sg13_lv_pmos w=1.12u l=0.13u
XN6_1_7 o6_1_7 o5_3_7 gn6 gn6 sg13_lv_nmos w=0.74u l=0.13u
CL6_1_7 o6_1_7 gn6 2f
XP6_2_0 o6_2_0 o6_1_0 ph6 ph6 sg13_lv_pmos w=1.12u l=0.13u
XN6_2_0 o6_2_0 o6_1_0 gn6 gn6 sg13_lv_nmos w=0.74u l=0.13u
CL6_2_0 o6_2_0 gn6 2f
XP6_2_1 o6_2_1 o6_1_1 ph6 ph6 sg13_lv_pmos w=1.12u l=0.13u
XN6_2_1 o6_2_1 o6_1_1 gn6 gn6 sg13_lv_nmos w=0.74u l=0.13u
CL6_2_1 o6_2_1 gn6 2f
XP6_2_2 o6_2_2 o6_1_2 ph6 ph6 sg13_lv_pmos w=1.12u l=0.13u
XN6_2_2 o6_2_2 o6_1_2 gn6 gn6 sg13_lv_nmos w=0.74u l=0.13u
CL6_2_2 o6_2_2 gn6 2f
XP6_2_3 o6_2_3 o6_1_3 ph6 ph6 sg13_lv_pmos w=1.12u l=0.13u
XN6_2_3 o6_2_3 o6_1_3 gn6 gn6 sg13_lv_nmos w=0.74u l=0.13u
CL6_2_3 o6_2_3 gn6 2f
XP6_2_4 o6_2_4 o6_1_4 ph6 ph6 sg13_lv_pmos w=1.12u l=0.13u
XN6_2_4 o6_2_4 o6_1_4 gn6 gn6 sg13_lv_nmos w=0.74u l=0.13u
CL6_2_4 o6_2_4 gn6 2f
XP6_2_5 o6_2_5 o6_1_5 ph6 ph6 sg13_lv_pmos w=1.12u l=0.13u
XN6_2_5 o6_2_5 o6_1_5 gn6 gn6 sg13_lv_nmos w=0.74u l=0.13u
CL6_2_5 o6_2_5 gn6 2f
XP6_2_6 o6_2_6 o6_1_6 ph6 ph6 sg13_lv_pmos w=1.12u l=0.13u
XN6_2_6 o6_2_6 o6_1_6 gn6 gn6 sg13_lv_nmos w=0.74u l=0.13u
CL6_2_6 o6_2_6 gn6 2f
XP6_2_7 o6_2_7 o6_1_7 ph6 ph6 sg13_lv_pmos w=1.12u l=0.13u
XN6_2_7 o6_2_7 o6_1_7 gn6 gn6 sg13_lv_nmos w=0.74u l=0.13u
CL6_2_7 o6_2_7 gn6 2f
XP6_3_0 o6_3_0 o6_2_0 ph6 ph6 sg13_lv_pmos w=1.12u l=0.13u
XN6_3_0 o6_3_0 o6_2_0 gn6 gn6 sg13_lv_nmos w=0.74u l=0.13u
CL6_3_0 o6_3_0 gn6 2f
XP6_3_1 o6_3_1 o6_2_1 ph6 ph6 sg13_lv_pmos w=1.12u l=0.13u
XN6_3_1 o6_3_1 o6_2_1 gn6 gn6 sg13_lv_nmos w=0.74u l=0.13u
CL6_3_1 o6_3_1 gn6 2f
XP6_3_2 o6_3_2 o6_2_2 ph6 ph6 sg13_lv_pmos w=1.12u l=0.13u
XN6_3_2 o6_3_2 o6_2_2 gn6 gn6 sg13_lv_nmos w=0.74u l=0.13u
CL6_3_2 o6_3_2 gn6 2f
XP6_3_3 o6_3_3 o6_2_3 ph6 ph6 sg13_lv_pmos w=1.12u l=0.13u
XN6_3_3 o6_3_3 o6_2_3 gn6 gn6 sg13_lv_nmos w=0.74u l=0.13u
CL6_3_3 o6_3_3 gn6 2f
XP6_3_4 o6_3_4 o6_2_4 ph6 ph6 sg13_lv_pmos w=1.12u l=0.13u
XN6_3_4 o6_3_4 o6_2_4 gn6 gn6 sg13_lv_nmos w=0.74u l=0.13u
CL6_3_4 o6_3_4 gn6 2f
XP6_3_5 o6_3_5 o6_2_5 ph6 ph6 sg13_lv_pmos w=1.12u l=0.13u
XN6_3_5 o6_3_5 o6_2_5 gn6 gn6 sg13_lv_nmos w=0.74u l=0.13u
CL6_3_5 o6_3_5 gn6 2f
XP6_3_6 o6_3_6 o6_2_6 ph6 ph6 sg13_lv_pmos w=1.12u l=0.13u
XN6_3_6 o6_3_6 o6_2_6 gn6 gn6 sg13_lv_nmos w=0.74u l=0.13u
CL6_3_6 o6_3_6 gn6 2f
XP6_3_7 o6_3_7 o6_2_7 ph6 ph6 sg13_lv_pmos w=1.12u l=0.13u
XN6_3_7 o6_3_7 o6_2_7 gn6 gn6 sg13_lv_nmos w=0.74u l=0.13u
CL6_3_7 o6_3_7 gn6 2f
CXqph1 xqph1 0 1
BXqph1 0 xqph1 I={ -I(VPH1) }
RXqph1 xqph1 0 0.01
CXeph1 xeph1 0 1
BXeph1 0 xeph1 I={ -V(ph1)*I(VPH1) }
RXeph1 xeph1 0 0.01
CXqg1 xqg1 0 1
BXqg1 0 xqg1 I={ I(VMG1) }
RXqg1 xqg1 0 0.01
CXqph2 xqph2 0 1
BXqph2 0 xqph2 I={ -I(VPH2) }
RXqph2 xqph2 0 0.01
CXeph2 xeph2 0 1
BXeph2 0 xeph2 I={ -V(ph2)*I(VPH2) }
RXeph2 xeph2 0 0.01
CXqg2 xqg2 0 1
BXqg2 0 xqg2 I={ I(VMG2) }
RXqg2 xqg2 0 0.01
CXqph3 xqph3 0 1
BXqph3 0 xqph3 I={ -I(VPH3) }
RXqph3 xqph3 0 0.01
CXeph3 xeph3 0 1
BXeph3 0 xeph3 I={ -V(ph3)*I(VPH3) }
RXeph3 xeph3 0 0.01
CXqg3 xqg3 0 1
BXqg3 0 xqg3 I={ I(VMG3) }
RXqg3 xqg3 0 0.01
CXqph4 xqph4 0 1
BXqph4 0 xqph4 I={ -I(VPH4) }
RXqph4 xqph4 0 0.01
CXeph4 xeph4 0 1
BXeph4 0 xeph4 I={ -V(ph4)*I(VPH4) }
RXeph4 xeph4 0 0.01
CXqg4 xqg4 0 1
BXqg4 0 xqg4 I={ I(VMG4) }
RXqg4 xqg4 0 0.01
CXqph5 xqph5 0 1
BXqph5 0 xqph5 I={ -I(VPH5) }
RXqph5 xqph5 0 0.01
CXeph5 xeph5 0 1
BXeph5 0 xeph5 I={ -V(ph5)*I(VPH5) }
RXeph5 xeph5 0 0.01
CXqg5 xqg5 0 1
BXqg5 0 xqg5 I={ I(VMG5) }
RXqg5 xqg5 0 0.01
CXqph6 xqph6 0 1
BXqph6 0 xqph6 I={ -I(VPH6) }
RXqph6 xqph6 0 0.01
CXeph6 xeph6 0 1
BXeph6 0 xeph6 I={ -V(ph6)*I(VPH6) }
RXeph6 xeph6 0 0.01
CXqg6 xqg6 0 1
BXqg6 0 xqg6 I={ I(VMG6) }
RXqg6 xqg6 0 0.01
.ic V(pA)=0 V(pB)=1.65 V(pC)=1.65 V(vddh)=1.65 V(lin)=0.8 V(lmid)=0.8 V(lx)=0.8 V(lout)=0.8 V(ph1)=0 V(ph2)=1.65 V(ph3)=1.65 V(ph4)=0 V(ph5)=1.65 V(ph6)=1.65
.tran 0.1p 1932p 0 0.25p UIC
.measure tran VRK1W2 FIND V(ph1) AT=691.000000p
.measure tran VK1_1_0W2 FIND V(o1_1_0) AT=691.000000p
.measure tran VK1_1_1W2 FIND V(o1_1_1) AT=691.000000p
.measure tran VK1_1_2W2 FIND V(o1_1_2) AT=691.000000p
.measure tran VK1_1_3W2 FIND V(o1_1_3) AT=691.000000p
.measure tran VK1_1_4W2 FIND V(o1_1_4) AT=691.000000p
.measure tran VK1_1_5W2 FIND V(o1_1_5) AT=691.000000p
.measure tran VK1_1_6W2 FIND V(o1_1_6) AT=691.000000p
.measure tran VK1_1_7W2 FIND V(o1_1_7) AT=691.000000p
.measure tran VK1_2_0W2 FIND V(o1_2_0) AT=691.000000p
.measure tran VK1_2_1W2 FIND V(o1_2_1) AT=691.000000p
.measure tran VK1_2_2W2 FIND V(o1_2_2) AT=691.000000p
.measure tran VK1_2_3W2 FIND V(o1_2_3) AT=691.000000p
.measure tran VK1_2_4W2 FIND V(o1_2_4) AT=691.000000p
.measure tran VK1_2_5W2 FIND V(o1_2_5) AT=691.000000p
.measure tran VK1_2_6W2 FIND V(o1_2_6) AT=691.000000p
.measure tran VK1_2_7W2 FIND V(o1_2_7) AT=691.000000p
.measure tran VK1_3_0W2 FIND V(o1_3_0) AT=691.000000p
.measure tran VK1_3_1W2 FIND V(o1_3_1) AT=691.000000p
.measure tran VK1_3_2W2 FIND V(o1_3_2) AT=691.000000p
.measure tran VK1_3_3W2 FIND V(o1_3_3) AT=691.000000p
.measure tran VK1_3_4W2 FIND V(o1_3_4) AT=691.000000p
.measure tran VK1_3_5W2 FIND V(o1_3_5) AT=691.000000p
.measure tran VK1_3_6W2 FIND V(o1_3_6) AT=691.000000p
.measure tran VK1_3_7W2 FIND V(o1_3_7) AT=691.000000p
.measure tran VRK2W2 FIND V(ph2) AT=783.000000p
.measure tran VK2_1_0W2 FIND V(o2_1_0) AT=783.000000p
.measure tran VK2_1_1W2 FIND V(o2_1_1) AT=783.000000p
.measure tran VK2_1_2W2 FIND V(o2_1_2) AT=783.000000p
.measure tran VK2_1_3W2 FIND V(o2_1_3) AT=783.000000p
.measure tran VK2_1_4W2 FIND V(o2_1_4) AT=783.000000p
.measure tran VK2_1_5W2 FIND V(o2_1_5) AT=783.000000p
.measure tran VK2_1_6W2 FIND V(o2_1_6) AT=783.000000p
.measure tran VK2_1_7W2 FIND V(o2_1_7) AT=783.000000p
.measure tran VK2_2_0W2 FIND V(o2_2_0) AT=783.000000p
.measure tran VK2_2_1W2 FIND V(o2_2_1) AT=783.000000p
.measure tran VK2_2_2W2 FIND V(o2_2_2) AT=783.000000p
.measure tran VK2_2_3W2 FIND V(o2_2_3) AT=783.000000p
.measure tran VK2_2_4W2 FIND V(o2_2_4) AT=783.000000p
.measure tran VK2_2_5W2 FIND V(o2_2_5) AT=783.000000p
.measure tran VK2_2_6W2 FIND V(o2_2_6) AT=783.000000p
.measure tran VK2_2_7W2 FIND V(o2_2_7) AT=783.000000p
.measure tran VK2_3_0W2 FIND V(o2_3_0) AT=783.000000p
.measure tran VK2_3_1W2 FIND V(o2_3_1) AT=783.000000p
.measure tran VK2_3_2W2 FIND V(o2_3_2) AT=783.000000p
.measure tran VK2_3_3W2 FIND V(o2_3_3) AT=783.000000p
.measure tran VK2_3_4W2 FIND V(o2_3_4) AT=783.000000p
.measure tran VK2_3_5W2 FIND V(o2_3_5) AT=783.000000p
.measure tran VK2_3_6W2 FIND V(o2_3_6) AT=783.000000p
.measure tran VK2_3_7W2 FIND V(o2_3_7) AT=783.000000p
.measure tran VRK3W2 FIND V(ph3) AT=875.000000p
.measure tran VK3_1_0W2 FIND V(o3_1_0) AT=875.000000p
.measure tran VK3_1_1W2 FIND V(o3_1_1) AT=875.000000p
.measure tran VK3_1_2W2 FIND V(o3_1_2) AT=875.000000p
.measure tran VK3_1_3W2 FIND V(o3_1_3) AT=875.000000p
.measure tran VK3_1_4W2 FIND V(o3_1_4) AT=875.000000p
.measure tran VK3_1_5W2 FIND V(o3_1_5) AT=875.000000p
.measure tran VK3_1_6W2 FIND V(o3_1_6) AT=875.000000p
.measure tran VK3_1_7W2 FIND V(o3_1_7) AT=875.000000p
.measure tran VK3_2_0W2 FIND V(o3_2_0) AT=875.000000p
.measure tran VK3_2_1W2 FIND V(o3_2_1) AT=875.000000p
.measure tran VK3_2_2W2 FIND V(o3_2_2) AT=875.000000p
.measure tran VK3_2_3W2 FIND V(o3_2_3) AT=875.000000p
.measure tran VK3_2_4W2 FIND V(o3_2_4) AT=875.000000p
.measure tran VK3_2_5W2 FIND V(o3_2_5) AT=875.000000p
.measure tran VK3_2_6W2 FIND V(o3_2_6) AT=875.000000p
.measure tran VK3_2_7W2 FIND V(o3_2_7) AT=875.000000p
.measure tran VK3_3_0W2 FIND V(o3_3_0) AT=875.000000p
.measure tran VK3_3_1W2 FIND V(o3_3_1) AT=875.000000p
.measure tran VK3_3_2W2 FIND V(o3_3_2) AT=875.000000p
.measure tran VK3_3_3W2 FIND V(o3_3_3) AT=875.000000p
.measure tran VK3_3_4W2 FIND V(o3_3_4) AT=875.000000p
.measure tran VK3_3_5W2 FIND V(o3_3_5) AT=875.000000p
.measure tran VK3_3_6W2 FIND V(o3_3_6) AT=875.000000p
.measure tran VK3_3_7W2 FIND V(o3_3_7) AT=875.000000p
.measure tran VRK4W2 FIND V(ph4) AT=967.000000p
.measure tran VK4_1_0W2 FIND V(o4_1_0) AT=967.000000p
.measure tran VK4_1_1W2 FIND V(o4_1_1) AT=967.000000p
.measure tran VK4_1_2W2 FIND V(o4_1_2) AT=967.000000p
.measure tran VK4_1_3W2 FIND V(o4_1_3) AT=967.000000p
.measure tran VK4_1_4W2 FIND V(o4_1_4) AT=967.000000p
.measure tran VK4_1_5W2 FIND V(o4_1_5) AT=967.000000p
.measure tran VK4_1_6W2 FIND V(o4_1_6) AT=967.000000p
.measure tran VK4_1_7W2 FIND V(o4_1_7) AT=967.000000p
.measure tran VK4_2_0W2 FIND V(o4_2_0) AT=967.000000p
.measure tran VK4_2_1W2 FIND V(o4_2_1) AT=967.000000p
.measure tran VK4_2_2W2 FIND V(o4_2_2) AT=967.000000p
.measure tran VK4_2_3W2 FIND V(o4_2_3) AT=967.000000p
.measure tran VK4_2_4W2 FIND V(o4_2_4) AT=967.000000p
.measure tran VK4_2_5W2 FIND V(o4_2_5) AT=967.000000p
.measure tran VK4_2_6W2 FIND V(o4_2_6) AT=967.000000p
.measure tran VK4_2_7W2 FIND V(o4_2_7) AT=967.000000p
.measure tran VK4_3_0W2 FIND V(o4_3_0) AT=967.000000p
.measure tran VK4_3_1W2 FIND V(o4_3_1) AT=967.000000p
.measure tran VK4_3_2W2 FIND V(o4_3_2) AT=967.000000p
.measure tran VK4_3_3W2 FIND V(o4_3_3) AT=967.000000p
.measure tran VK4_3_4W2 FIND V(o4_3_4) AT=967.000000p
.measure tran VK4_3_5W2 FIND V(o4_3_5) AT=967.000000p
.measure tran VK4_3_6W2 FIND V(o4_3_6) AT=967.000000p
.measure tran VK4_3_7W2 FIND V(o4_3_7) AT=967.000000p
.measure tran VRK5W2 FIND V(ph5) AT=1059.000000p
.measure tran VK5_1_0W2 FIND V(o5_1_0) AT=1059.000000p
.measure tran VK5_1_1W2 FIND V(o5_1_1) AT=1059.000000p
.measure tran VK5_1_2W2 FIND V(o5_1_2) AT=1059.000000p
.measure tran VK5_1_3W2 FIND V(o5_1_3) AT=1059.000000p
.measure tran VK5_1_4W2 FIND V(o5_1_4) AT=1059.000000p
.measure tran VK5_1_5W2 FIND V(o5_1_5) AT=1059.000000p
.measure tran VK5_1_6W2 FIND V(o5_1_6) AT=1059.000000p
.measure tran VK5_1_7W2 FIND V(o5_1_7) AT=1059.000000p
.measure tran VK5_2_0W2 FIND V(o5_2_0) AT=1059.000000p
.measure tran VK5_2_1W2 FIND V(o5_2_1) AT=1059.000000p
.measure tran VK5_2_2W2 FIND V(o5_2_2) AT=1059.000000p
.measure tran VK5_2_3W2 FIND V(o5_2_3) AT=1059.000000p
.measure tran VK5_2_4W2 FIND V(o5_2_4) AT=1059.000000p
.measure tran VK5_2_5W2 FIND V(o5_2_5) AT=1059.000000p
.measure tran VK5_2_6W2 FIND V(o5_2_6) AT=1059.000000p
.measure tran VK5_2_7W2 FIND V(o5_2_7) AT=1059.000000p
.measure tran VK5_3_0W2 FIND V(o5_3_0) AT=1059.000000p
.measure tran VK5_3_1W2 FIND V(o5_3_1) AT=1059.000000p
.measure tran VK5_3_2W2 FIND V(o5_3_2) AT=1059.000000p
.measure tran VK5_3_3W2 FIND V(o5_3_3) AT=1059.000000p
.measure tran VK5_3_4W2 FIND V(o5_3_4) AT=1059.000000p
.measure tran VK5_3_5W2 FIND V(o5_3_5) AT=1059.000000p
.measure tran VK5_3_6W2 FIND V(o5_3_6) AT=1059.000000p
.measure tran VK5_3_7W2 FIND V(o5_3_7) AT=1059.000000p
.measure tran VRK6W2 FIND V(ph6) AT=1151.000000p
.measure tran VK6_1_0W2 FIND V(o6_1_0) AT=1151.000000p
.measure tran VK6_1_1W2 FIND V(o6_1_1) AT=1151.000000p
.measure tran VK6_1_2W2 FIND V(o6_1_2) AT=1151.000000p
.measure tran VK6_1_3W2 FIND V(o6_1_3) AT=1151.000000p
.measure tran VK6_1_4W2 FIND V(o6_1_4) AT=1151.000000p
.measure tran VK6_1_5W2 FIND V(o6_1_5) AT=1151.000000p
.measure tran VK6_1_6W2 FIND V(o6_1_6) AT=1151.000000p
.measure tran VK6_1_7W2 FIND V(o6_1_7) AT=1151.000000p
.measure tran VK6_2_0W2 FIND V(o6_2_0) AT=1151.000000p
.measure tran VK6_2_1W2 FIND V(o6_2_1) AT=1151.000000p
.measure tran VK6_2_2W2 FIND V(o6_2_2) AT=1151.000000p
.measure tran VK6_2_3W2 FIND V(o6_2_3) AT=1151.000000p
.measure tran VK6_2_4W2 FIND V(o6_2_4) AT=1151.000000p
.measure tran VK6_2_5W2 FIND V(o6_2_5) AT=1151.000000p
.measure tran VK6_2_6W2 FIND V(o6_2_6) AT=1151.000000p
.measure tran VK6_2_7W2 FIND V(o6_2_7) AT=1151.000000p
.measure tran VK6_3_0W2 FIND V(o6_3_0) AT=1151.000000p
.measure tran VK6_3_1W2 FIND V(o6_3_1) AT=1151.000000p
.measure tran VK6_3_2W2 FIND V(o6_3_2) AT=1151.000000p
.measure tran VK6_3_3W2 FIND V(o6_3_3) AT=1151.000000p
.measure tran VK6_3_4W2 FIND V(o6_3_4) AT=1151.000000p
.measure tran VK6_3_5W2 FIND V(o6_3_5) AT=1151.000000p
.measure tran VK6_3_6W2 FIND V(o6_3_6) AT=1151.000000p
.measure tran VK6_3_7W2 FIND V(o6_3_7) AT=1151.000000p
.measure tran VRK1W3 FIND V(ph1) AT=967.000000p
.measure tran VK1_1_0W3 FIND V(o1_1_0) AT=967.000000p
.measure tran VK1_1_1W3 FIND V(o1_1_1) AT=967.000000p
.measure tran VK1_1_2W3 FIND V(o1_1_2) AT=967.000000p
.measure tran VK1_1_3W3 FIND V(o1_1_3) AT=967.000000p
.measure tran VK1_1_4W3 FIND V(o1_1_4) AT=967.000000p
.measure tran VK1_1_5W3 FIND V(o1_1_5) AT=967.000000p
.measure tran VK1_1_6W3 FIND V(o1_1_6) AT=967.000000p
.measure tran VK1_1_7W3 FIND V(o1_1_7) AT=967.000000p
.measure tran VK1_2_0W3 FIND V(o1_2_0) AT=967.000000p
.measure tran VK1_2_1W3 FIND V(o1_2_1) AT=967.000000p
.measure tran VK1_2_2W3 FIND V(o1_2_2) AT=967.000000p
.measure tran VK1_2_3W3 FIND V(o1_2_3) AT=967.000000p
.measure tran VK1_2_4W3 FIND V(o1_2_4) AT=967.000000p
.measure tran VK1_2_5W3 FIND V(o1_2_5) AT=967.000000p
.measure tran VK1_2_6W3 FIND V(o1_2_6) AT=967.000000p
.measure tran VK1_2_7W3 FIND V(o1_2_7) AT=967.000000p
.measure tran VK1_3_0W3 FIND V(o1_3_0) AT=967.000000p
.measure tran VK1_3_1W3 FIND V(o1_3_1) AT=967.000000p
.measure tran VK1_3_2W3 FIND V(o1_3_2) AT=967.000000p
.measure tran VK1_3_3W3 FIND V(o1_3_3) AT=967.000000p
.measure tran VK1_3_4W3 FIND V(o1_3_4) AT=967.000000p
.measure tran VK1_3_5W3 FIND V(o1_3_5) AT=967.000000p
.measure tran VK1_3_6W3 FIND V(o1_3_6) AT=967.000000p
.measure tran VK1_3_7W3 FIND V(o1_3_7) AT=967.000000p
.measure tran VRK2W3 FIND V(ph2) AT=1059.000000p
.measure tran VK2_1_0W3 FIND V(o2_1_0) AT=1059.000000p
.measure tran VK2_1_1W3 FIND V(o2_1_1) AT=1059.000000p
.measure tran VK2_1_2W3 FIND V(o2_1_2) AT=1059.000000p
.measure tran VK2_1_3W3 FIND V(o2_1_3) AT=1059.000000p
.measure tran VK2_1_4W3 FIND V(o2_1_4) AT=1059.000000p
.measure tran VK2_1_5W3 FIND V(o2_1_5) AT=1059.000000p
.measure tran VK2_1_6W3 FIND V(o2_1_6) AT=1059.000000p
.measure tran VK2_1_7W3 FIND V(o2_1_7) AT=1059.000000p
.measure tran VK2_2_0W3 FIND V(o2_2_0) AT=1059.000000p
.measure tran VK2_2_1W3 FIND V(o2_2_1) AT=1059.000000p
.measure tran VK2_2_2W3 FIND V(o2_2_2) AT=1059.000000p
.measure tran VK2_2_3W3 FIND V(o2_2_3) AT=1059.000000p
.measure tran VK2_2_4W3 FIND V(o2_2_4) AT=1059.000000p
.measure tran VK2_2_5W3 FIND V(o2_2_5) AT=1059.000000p
.measure tran VK2_2_6W3 FIND V(o2_2_6) AT=1059.000000p
.measure tran VK2_2_7W3 FIND V(o2_2_7) AT=1059.000000p
.measure tran VK2_3_0W3 FIND V(o2_3_0) AT=1059.000000p
.measure tran VK2_3_1W3 FIND V(o2_3_1) AT=1059.000000p
.measure tran VK2_3_2W3 FIND V(o2_3_2) AT=1059.000000p
.measure tran VK2_3_3W3 FIND V(o2_3_3) AT=1059.000000p
.measure tran VK2_3_4W3 FIND V(o2_3_4) AT=1059.000000p
.measure tran VK2_3_5W3 FIND V(o2_3_5) AT=1059.000000p
.measure tran VK2_3_6W3 FIND V(o2_3_6) AT=1059.000000p
.measure tran VK2_3_7W3 FIND V(o2_3_7) AT=1059.000000p
.measure tran VRK3W3 FIND V(ph3) AT=1151.000000p
.measure tran VK3_1_0W3 FIND V(o3_1_0) AT=1151.000000p
.measure tran VK3_1_1W3 FIND V(o3_1_1) AT=1151.000000p
.measure tran VK3_1_2W3 FIND V(o3_1_2) AT=1151.000000p
.measure tran VK3_1_3W3 FIND V(o3_1_3) AT=1151.000000p
.measure tran VK3_1_4W3 FIND V(o3_1_4) AT=1151.000000p
.measure tran VK3_1_5W3 FIND V(o3_1_5) AT=1151.000000p
.measure tran VK3_1_6W3 FIND V(o3_1_6) AT=1151.000000p
.measure tran VK3_1_7W3 FIND V(o3_1_7) AT=1151.000000p
.measure tran VK3_2_0W3 FIND V(o3_2_0) AT=1151.000000p
.measure tran VK3_2_1W3 FIND V(o3_2_1) AT=1151.000000p
.measure tran VK3_2_2W3 FIND V(o3_2_2) AT=1151.000000p
.measure tran VK3_2_3W3 FIND V(o3_2_3) AT=1151.000000p
.measure tran VK3_2_4W3 FIND V(o3_2_4) AT=1151.000000p
.measure tran VK3_2_5W3 FIND V(o3_2_5) AT=1151.000000p
.measure tran VK3_2_6W3 FIND V(o3_2_6) AT=1151.000000p
.measure tran VK3_2_7W3 FIND V(o3_2_7) AT=1151.000000p
.measure tran VK3_3_0W3 FIND V(o3_3_0) AT=1151.000000p
.measure tran VK3_3_1W3 FIND V(o3_3_1) AT=1151.000000p
.measure tran VK3_3_2W3 FIND V(o3_3_2) AT=1151.000000p
.measure tran VK3_3_3W3 FIND V(o3_3_3) AT=1151.000000p
.measure tran VK3_3_4W3 FIND V(o3_3_4) AT=1151.000000p
.measure tran VK3_3_5W3 FIND V(o3_3_5) AT=1151.000000p
.measure tran VK3_3_6W3 FIND V(o3_3_6) AT=1151.000000p
.measure tran VK3_3_7W3 FIND V(o3_3_7) AT=1151.000000p
.measure tran VRK4W3 FIND V(ph4) AT=1243.000000p
.measure tran VK4_1_0W3 FIND V(o4_1_0) AT=1243.000000p
.measure tran VK4_1_1W3 FIND V(o4_1_1) AT=1243.000000p
.measure tran VK4_1_2W3 FIND V(o4_1_2) AT=1243.000000p
.measure tran VK4_1_3W3 FIND V(o4_1_3) AT=1243.000000p
.measure tran VK4_1_4W3 FIND V(o4_1_4) AT=1243.000000p
.measure tran VK4_1_5W3 FIND V(o4_1_5) AT=1243.000000p
.measure tran VK4_1_6W3 FIND V(o4_1_6) AT=1243.000000p
.measure tran VK4_1_7W3 FIND V(o4_1_7) AT=1243.000000p
.measure tran VK4_2_0W3 FIND V(o4_2_0) AT=1243.000000p
.measure tran VK4_2_1W3 FIND V(o4_2_1) AT=1243.000000p
.measure tran VK4_2_2W3 FIND V(o4_2_2) AT=1243.000000p
.measure tran VK4_2_3W3 FIND V(o4_2_3) AT=1243.000000p
.measure tran VK4_2_4W3 FIND V(o4_2_4) AT=1243.000000p
.measure tran VK4_2_5W3 FIND V(o4_2_5) AT=1243.000000p
.measure tran VK4_2_6W3 FIND V(o4_2_6) AT=1243.000000p
.measure tran VK4_2_7W3 FIND V(o4_2_7) AT=1243.000000p
.measure tran VK4_3_0W3 FIND V(o4_3_0) AT=1243.000000p
.measure tran VK4_3_1W3 FIND V(o4_3_1) AT=1243.000000p
.measure tran VK4_3_2W3 FIND V(o4_3_2) AT=1243.000000p
.measure tran VK4_3_3W3 FIND V(o4_3_3) AT=1243.000000p
.measure tran VK4_3_4W3 FIND V(o4_3_4) AT=1243.000000p
.measure tran VK4_3_5W3 FIND V(o4_3_5) AT=1243.000000p
.measure tran VK4_3_6W3 FIND V(o4_3_6) AT=1243.000000p
.measure tran VK4_3_7W3 FIND V(o4_3_7) AT=1243.000000p
.measure tran VRK5W3 FIND V(ph5) AT=1335.000000p
.measure tran VK5_1_0W3 FIND V(o5_1_0) AT=1335.000000p
.measure tran VK5_1_1W3 FIND V(o5_1_1) AT=1335.000000p
.measure tran VK5_1_2W3 FIND V(o5_1_2) AT=1335.000000p
.measure tran VK5_1_3W3 FIND V(o5_1_3) AT=1335.000000p
.measure tran VK5_1_4W3 FIND V(o5_1_4) AT=1335.000000p
.measure tran VK5_1_5W3 FIND V(o5_1_5) AT=1335.000000p
.measure tran VK5_1_6W3 FIND V(o5_1_6) AT=1335.000000p
.measure tran VK5_1_7W3 FIND V(o5_1_7) AT=1335.000000p
.measure tran VK5_2_0W3 FIND V(o5_2_0) AT=1335.000000p
.measure tran VK5_2_1W3 FIND V(o5_2_1) AT=1335.000000p
.measure tran VK5_2_2W3 FIND V(o5_2_2) AT=1335.000000p
.measure tran VK5_2_3W3 FIND V(o5_2_3) AT=1335.000000p
.measure tran VK5_2_4W3 FIND V(o5_2_4) AT=1335.000000p
.measure tran VK5_2_5W3 FIND V(o5_2_5) AT=1335.000000p
.measure tran VK5_2_6W3 FIND V(o5_2_6) AT=1335.000000p
.measure tran VK5_2_7W3 FIND V(o5_2_7) AT=1335.000000p
.measure tran VK5_3_0W3 FIND V(o5_3_0) AT=1335.000000p
.measure tran VK5_3_1W3 FIND V(o5_3_1) AT=1335.000000p
.measure tran VK5_3_2W3 FIND V(o5_3_2) AT=1335.000000p
.measure tran VK5_3_3W3 FIND V(o5_3_3) AT=1335.000000p
.measure tran VK5_3_4W3 FIND V(o5_3_4) AT=1335.000000p
.measure tran VK5_3_5W3 FIND V(o5_3_5) AT=1335.000000p
.measure tran VK5_3_6W3 FIND V(o5_3_6) AT=1335.000000p
.measure tran VK5_3_7W3 FIND V(o5_3_7) AT=1335.000000p
.measure tran VRK6W3 FIND V(ph6) AT=1427.000000p
.measure tran VK6_1_0W3 FIND V(o6_1_0) AT=1427.000000p
.measure tran VK6_1_1W3 FIND V(o6_1_1) AT=1427.000000p
.measure tran VK6_1_2W3 FIND V(o6_1_2) AT=1427.000000p
.measure tran VK6_1_3W3 FIND V(o6_1_3) AT=1427.000000p
.measure tran VK6_1_4W3 FIND V(o6_1_4) AT=1427.000000p
.measure tran VK6_1_5W3 FIND V(o6_1_5) AT=1427.000000p
.measure tran VK6_1_6W3 FIND V(o6_1_6) AT=1427.000000p
.measure tran VK6_1_7W3 FIND V(o6_1_7) AT=1427.000000p
.measure tran VK6_2_0W3 FIND V(o6_2_0) AT=1427.000000p
.measure tran VK6_2_1W3 FIND V(o6_2_1) AT=1427.000000p
.measure tran VK6_2_2W3 FIND V(o6_2_2) AT=1427.000000p
.measure tran VK6_2_3W3 FIND V(o6_2_3) AT=1427.000000p
.measure tran VK6_2_4W3 FIND V(o6_2_4) AT=1427.000000p
.measure tran VK6_2_5W3 FIND V(o6_2_5) AT=1427.000000p
.measure tran VK6_2_6W3 FIND V(o6_2_6) AT=1427.000000p
.measure tran VK6_2_7W3 FIND V(o6_2_7) AT=1427.000000p
.measure tran VK6_3_0W3 FIND V(o6_3_0) AT=1427.000000p
.measure tran VK6_3_1W3 FIND V(o6_3_1) AT=1427.000000p
.measure tran VK6_3_2W3 FIND V(o6_3_2) AT=1427.000000p
.measure tran VK6_3_3W3 FIND V(o6_3_3) AT=1427.000000p
.measure tran VK6_3_4W3 FIND V(o6_3_4) AT=1427.000000p
.measure tran VK6_3_5W3 FIND V(o6_3_5) AT=1427.000000p
.measure tran VK6_3_6W3 FIND V(o6_3_6) AT=1427.000000p
.measure tran VK6_3_7W3 FIND V(o6_3_7) AT=1427.000000p
.measure tran VRK1W4 FIND V(ph1) AT=1243.000000p
.measure tran VK1_1_0W4 FIND V(o1_1_0) AT=1243.000000p
.measure tran VK1_1_1W4 FIND V(o1_1_1) AT=1243.000000p
.measure tran VK1_1_2W4 FIND V(o1_1_2) AT=1243.000000p
.measure tran VK1_1_3W4 FIND V(o1_1_3) AT=1243.000000p
.measure tran VK1_1_4W4 FIND V(o1_1_4) AT=1243.000000p
.measure tran VK1_1_5W4 FIND V(o1_1_5) AT=1243.000000p
.measure tran VK1_1_6W4 FIND V(o1_1_6) AT=1243.000000p
.measure tran VK1_1_7W4 FIND V(o1_1_7) AT=1243.000000p
.measure tran VK1_2_0W4 FIND V(o1_2_0) AT=1243.000000p
.measure tran VK1_2_1W4 FIND V(o1_2_1) AT=1243.000000p
.measure tran VK1_2_2W4 FIND V(o1_2_2) AT=1243.000000p
.measure tran VK1_2_3W4 FIND V(o1_2_3) AT=1243.000000p
.measure tran VK1_2_4W4 FIND V(o1_2_4) AT=1243.000000p
.measure tran VK1_2_5W4 FIND V(o1_2_5) AT=1243.000000p
.measure tran VK1_2_6W4 FIND V(o1_2_6) AT=1243.000000p
.measure tran VK1_2_7W4 FIND V(o1_2_7) AT=1243.000000p
.measure tran VK1_3_0W4 FIND V(o1_3_0) AT=1243.000000p
.measure tran VK1_3_1W4 FIND V(o1_3_1) AT=1243.000000p
.measure tran VK1_3_2W4 FIND V(o1_3_2) AT=1243.000000p
.measure tran VK1_3_3W4 FIND V(o1_3_3) AT=1243.000000p
.measure tran VK1_3_4W4 FIND V(o1_3_4) AT=1243.000000p
.measure tran VK1_3_5W4 FIND V(o1_3_5) AT=1243.000000p
.measure tran VK1_3_6W4 FIND V(o1_3_6) AT=1243.000000p
.measure tran VK1_3_7W4 FIND V(o1_3_7) AT=1243.000000p
.measure tran VRK2W4 FIND V(ph2) AT=1335.000000p
.measure tran VK2_1_0W4 FIND V(o2_1_0) AT=1335.000000p
.measure tran VK2_1_1W4 FIND V(o2_1_1) AT=1335.000000p
.measure tran VK2_1_2W4 FIND V(o2_1_2) AT=1335.000000p
.measure tran VK2_1_3W4 FIND V(o2_1_3) AT=1335.000000p
.measure tran VK2_1_4W4 FIND V(o2_1_4) AT=1335.000000p
.measure tran VK2_1_5W4 FIND V(o2_1_5) AT=1335.000000p
.measure tran VK2_1_6W4 FIND V(o2_1_6) AT=1335.000000p
.measure tran VK2_1_7W4 FIND V(o2_1_7) AT=1335.000000p
.measure tran VK2_2_0W4 FIND V(o2_2_0) AT=1335.000000p
.measure tran VK2_2_1W4 FIND V(o2_2_1) AT=1335.000000p
.measure tran VK2_2_2W4 FIND V(o2_2_2) AT=1335.000000p
.measure tran VK2_2_3W4 FIND V(o2_2_3) AT=1335.000000p
.measure tran VK2_2_4W4 FIND V(o2_2_4) AT=1335.000000p
.measure tran VK2_2_5W4 FIND V(o2_2_5) AT=1335.000000p
.measure tran VK2_2_6W4 FIND V(o2_2_6) AT=1335.000000p
.measure tran VK2_2_7W4 FIND V(o2_2_7) AT=1335.000000p
.measure tran VK2_3_0W4 FIND V(o2_3_0) AT=1335.000000p
.measure tran VK2_3_1W4 FIND V(o2_3_1) AT=1335.000000p
.measure tran VK2_3_2W4 FIND V(o2_3_2) AT=1335.000000p
.measure tran VK2_3_3W4 FIND V(o2_3_3) AT=1335.000000p
.measure tran VK2_3_4W4 FIND V(o2_3_4) AT=1335.000000p
.measure tran VK2_3_5W4 FIND V(o2_3_5) AT=1335.000000p
.measure tran VK2_3_6W4 FIND V(o2_3_6) AT=1335.000000p
.measure tran VK2_3_7W4 FIND V(o2_3_7) AT=1335.000000p
.measure tran VRK3W4 FIND V(ph3) AT=1427.000000p
.measure tran VK3_1_0W4 FIND V(o3_1_0) AT=1427.000000p
.measure tran VK3_1_1W4 FIND V(o3_1_1) AT=1427.000000p
.measure tran VK3_1_2W4 FIND V(o3_1_2) AT=1427.000000p
.measure tran VK3_1_3W4 FIND V(o3_1_3) AT=1427.000000p
.measure tran VK3_1_4W4 FIND V(o3_1_4) AT=1427.000000p
.measure tran VK3_1_5W4 FIND V(o3_1_5) AT=1427.000000p
.measure tran VK3_1_6W4 FIND V(o3_1_6) AT=1427.000000p
.measure tran VK3_1_7W4 FIND V(o3_1_7) AT=1427.000000p
.measure tran VK3_2_0W4 FIND V(o3_2_0) AT=1427.000000p
.measure tran VK3_2_1W4 FIND V(o3_2_1) AT=1427.000000p
.measure tran VK3_2_2W4 FIND V(o3_2_2) AT=1427.000000p
.measure tran VK3_2_3W4 FIND V(o3_2_3) AT=1427.000000p
.measure tran VK3_2_4W4 FIND V(o3_2_4) AT=1427.000000p
.measure tran VK3_2_5W4 FIND V(o3_2_5) AT=1427.000000p
.measure tran VK3_2_6W4 FIND V(o3_2_6) AT=1427.000000p
.measure tran VK3_2_7W4 FIND V(o3_2_7) AT=1427.000000p
.measure tran VK3_3_0W4 FIND V(o3_3_0) AT=1427.000000p
.measure tran VK3_3_1W4 FIND V(o3_3_1) AT=1427.000000p
.measure tran VK3_3_2W4 FIND V(o3_3_2) AT=1427.000000p
.measure tran VK3_3_3W4 FIND V(o3_3_3) AT=1427.000000p
.measure tran VK3_3_4W4 FIND V(o3_3_4) AT=1427.000000p
.measure tran VK3_3_5W4 FIND V(o3_3_5) AT=1427.000000p
.measure tran VK3_3_6W4 FIND V(o3_3_6) AT=1427.000000p
.measure tran VK3_3_7W4 FIND V(o3_3_7) AT=1427.000000p
.measure tran VRK4W4 FIND V(ph4) AT=1519.000000p
.measure tran VK4_1_0W4 FIND V(o4_1_0) AT=1519.000000p
.measure tran VK4_1_1W4 FIND V(o4_1_1) AT=1519.000000p
.measure tran VK4_1_2W4 FIND V(o4_1_2) AT=1519.000000p
.measure tran VK4_1_3W4 FIND V(o4_1_3) AT=1519.000000p
.measure tran VK4_1_4W4 FIND V(o4_1_4) AT=1519.000000p
.measure tran VK4_1_5W4 FIND V(o4_1_5) AT=1519.000000p
.measure tran VK4_1_6W4 FIND V(o4_1_6) AT=1519.000000p
.measure tran VK4_1_7W4 FIND V(o4_1_7) AT=1519.000000p
.measure tran VK4_2_0W4 FIND V(o4_2_0) AT=1519.000000p
.measure tran VK4_2_1W4 FIND V(o4_2_1) AT=1519.000000p
.measure tran VK4_2_2W4 FIND V(o4_2_2) AT=1519.000000p
.measure tran VK4_2_3W4 FIND V(o4_2_3) AT=1519.000000p
.measure tran VK4_2_4W4 FIND V(o4_2_4) AT=1519.000000p
.measure tran VK4_2_5W4 FIND V(o4_2_5) AT=1519.000000p
.measure tran VK4_2_6W4 FIND V(o4_2_6) AT=1519.000000p
.measure tran VK4_2_7W4 FIND V(o4_2_7) AT=1519.000000p
.measure tran VK4_3_0W4 FIND V(o4_3_0) AT=1519.000000p
.measure tran VK4_3_1W4 FIND V(o4_3_1) AT=1519.000000p
.measure tran VK4_3_2W4 FIND V(o4_3_2) AT=1519.000000p
.measure tran VK4_3_3W4 FIND V(o4_3_3) AT=1519.000000p
.measure tran VK4_3_4W4 FIND V(o4_3_4) AT=1519.000000p
.measure tran VK4_3_5W4 FIND V(o4_3_5) AT=1519.000000p
.measure tran VK4_3_6W4 FIND V(o4_3_6) AT=1519.000000p
.measure tran VK4_3_7W4 FIND V(o4_3_7) AT=1519.000000p
.measure tran VRK5W4 FIND V(ph5) AT=1611.000000p
.measure tran VK5_1_0W4 FIND V(o5_1_0) AT=1611.000000p
.measure tran VK5_1_1W4 FIND V(o5_1_1) AT=1611.000000p
.measure tran VK5_1_2W4 FIND V(o5_1_2) AT=1611.000000p
.measure tran VK5_1_3W4 FIND V(o5_1_3) AT=1611.000000p
.measure tran VK5_1_4W4 FIND V(o5_1_4) AT=1611.000000p
.measure tran VK5_1_5W4 FIND V(o5_1_5) AT=1611.000000p
.measure tran VK5_1_6W4 FIND V(o5_1_6) AT=1611.000000p
.measure tran VK5_1_7W4 FIND V(o5_1_7) AT=1611.000000p
.measure tran VK5_2_0W4 FIND V(o5_2_0) AT=1611.000000p
.measure tran VK5_2_1W4 FIND V(o5_2_1) AT=1611.000000p
.measure tran VK5_2_2W4 FIND V(o5_2_2) AT=1611.000000p
.measure tran VK5_2_3W4 FIND V(o5_2_3) AT=1611.000000p
.measure tran VK5_2_4W4 FIND V(o5_2_4) AT=1611.000000p
.measure tran VK5_2_5W4 FIND V(o5_2_5) AT=1611.000000p
.measure tran VK5_2_6W4 FIND V(o5_2_6) AT=1611.000000p
.measure tran VK5_2_7W4 FIND V(o5_2_7) AT=1611.000000p
.measure tran VK5_3_0W4 FIND V(o5_3_0) AT=1611.000000p
.measure tran VK5_3_1W4 FIND V(o5_3_1) AT=1611.000000p
.measure tran VK5_3_2W4 FIND V(o5_3_2) AT=1611.000000p
.measure tran VK5_3_3W4 FIND V(o5_3_3) AT=1611.000000p
.measure tran VK5_3_4W4 FIND V(o5_3_4) AT=1611.000000p
.measure tran VK5_3_5W4 FIND V(o5_3_5) AT=1611.000000p
.measure tran VK5_3_6W4 FIND V(o5_3_6) AT=1611.000000p
.measure tran VK5_3_7W4 FIND V(o5_3_7) AT=1611.000000p
.measure tran VRK6W4 FIND V(ph6) AT=1703.000000p
.measure tran VK6_1_0W4 FIND V(o6_1_0) AT=1703.000000p
.measure tran VK6_1_1W4 FIND V(o6_1_1) AT=1703.000000p
.measure tran VK6_1_2W4 FIND V(o6_1_2) AT=1703.000000p
.measure tran VK6_1_3W4 FIND V(o6_1_3) AT=1703.000000p
.measure tran VK6_1_4W4 FIND V(o6_1_4) AT=1703.000000p
.measure tran VK6_1_5W4 FIND V(o6_1_5) AT=1703.000000p
.measure tran VK6_1_6W4 FIND V(o6_1_6) AT=1703.000000p
.measure tran VK6_1_7W4 FIND V(o6_1_7) AT=1703.000000p
.measure tran VK6_2_0W4 FIND V(o6_2_0) AT=1703.000000p
.measure tran VK6_2_1W4 FIND V(o6_2_1) AT=1703.000000p
.measure tran VK6_2_2W4 FIND V(o6_2_2) AT=1703.000000p
.measure tran VK6_2_3W4 FIND V(o6_2_3) AT=1703.000000p
.measure tran VK6_2_4W4 FIND V(o6_2_4) AT=1703.000000p
.measure tran VK6_2_5W4 FIND V(o6_2_5) AT=1703.000000p
.measure tran VK6_2_6W4 FIND V(o6_2_6) AT=1703.000000p
.measure tran VK6_2_7W4 FIND V(o6_2_7) AT=1703.000000p
.measure tran VK6_3_0W4 FIND V(o6_3_0) AT=1703.000000p
.measure tran VK6_3_1W4 FIND V(o6_3_1) AT=1703.000000p
.measure tran VK6_3_2W4 FIND V(o6_3_2) AT=1703.000000p
.measure tran VK6_3_3W4 FIND V(o6_3_3) AT=1703.000000p
.measure tran VK6_3_4W4 FIND V(o6_3_4) AT=1703.000000p
.measure tran VK6_3_5W4 FIND V(o6_3_5) AT=1703.000000p
.measure tran VK6_3_6W4 FIND V(o6_3_6) AT=1703.000000p
.measure tran VK6_3_7W4 FIND V(o6_3_7) AT=1703.000000p
.measure tran QPH1T2 FIND V(xqph1) AT=553.000000p
.measure tran EPH1T2 FIND V(xeph1) AT=553.000000p
.measure tran QPH1R2 FIND V(xqph1) AT=645.000000p
.measure tran EPH1R2 FIND V(xeph1) AT=645.000000p
.measure tran QPH1H2 FIND V(xqph1) AT=737.000000p
.measure tran EPH1H2 FIND V(xeph1) AT=737.000000p
.measure tran QPH1T3 FIND V(xqph1) AT=829.000000p
.measure tran EPH1T3 FIND V(xeph1) AT=829.000000p
.measure tran QPH1R3 FIND V(xqph1) AT=921.000000p
.measure tran EPH1R3 FIND V(xeph1) AT=921.000000p
.measure tran QPH1H3 FIND V(xqph1) AT=1013.000000p
.measure tran EPH1H3 FIND V(xeph1) AT=1013.000000p
.measure tran QPH1T4 FIND V(xqph1) AT=1105.000000p
.measure tran EPH1T4 FIND V(xeph1) AT=1105.000000p
.measure tran QPH1R4 FIND V(xqph1) AT=1197.000000p
.measure tran EPH1R4 FIND V(xeph1) AT=1197.000000p
.measure tran QPH1H4 FIND V(xqph1) AT=1289.000000p
.measure tran EPH1H4 FIND V(xeph1) AT=1289.000000p
.measure tran QPH1T5 FIND V(xqph1) AT=1381.000000p
.measure tran EPH1T5 FIND V(xeph1) AT=1381.000000p
.measure tran QPH2T2 FIND V(xqph2) AT=645.000000p
.measure tran EPH2T2 FIND V(xeph2) AT=645.000000p
.measure tran QPH2R2 FIND V(xqph2) AT=737.000000p
.measure tran EPH2R2 FIND V(xeph2) AT=737.000000p
.measure tran QPH2H2 FIND V(xqph2) AT=829.000000p
.measure tran EPH2H2 FIND V(xeph2) AT=829.000000p
.measure tran QPH2T3 FIND V(xqph2) AT=921.000000p
.measure tran EPH2T3 FIND V(xeph2) AT=921.000000p
.measure tran QPH2R3 FIND V(xqph2) AT=1013.000000p
.measure tran EPH2R3 FIND V(xeph2) AT=1013.000000p
.measure tran QPH2H3 FIND V(xqph2) AT=1105.000000p
.measure tran EPH2H3 FIND V(xeph2) AT=1105.000000p
.measure tran QPH2T4 FIND V(xqph2) AT=1197.000000p
.measure tran EPH2T4 FIND V(xeph2) AT=1197.000000p
.measure tran QPH2R4 FIND V(xqph2) AT=1289.000000p
.measure tran EPH2R4 FIND V(xeph2) AT=1289.000000p
.measure tran QPH2H4 FIND V(xqph2) AT=1381.000000p
.measure tran EPH2H4 FIND V(xeph2) AT=1381.000000p
.measure tran QPH2T5 FIND V(xqph2) AT=1473.000000p
.measure tran EPH2T5 FIND V(xeph2) AT=1473.000000p
.measure tran QPH3T2 FIND V(xqph3) AT=737.000000p
.measure tran EPH3T2 FIND V(xeph3) AT=737.000000p
.measure tran QPH3R2 FIND V(xqph3) AT=829.000000p
.measure tran EPH3R2 FIND V(xeph3) AT=829.000000p
.measure tran QPH3H2 FIND V(xqph3) AT=921.000000p
.measure tran EPH3H2 FIND V(xeph3) AT=921.000000p
.measure tran QPH3T3 FIND V(xqph3) AT=1013.000000p
.measure tran EPH3T3 FIND V(xeph3) AT=1013.000000p
.measure tran QPH3R3 FIND V(xqph3) AT=1105.000000p
.measure tran EPH3R3 FIND V(xeph3) AT=1105.000000p
.measure tran QPH3H3 FIND V(xqph3) AT=1197.000000p
.measure tran EPH3H3 FIND V(xeph3) AT=1197.000000p
.measure tran QPH3T4 FIND V(xqph3) AT=1289.000000p
.measure tran EPH3T4 FIND V(xeph3) AT=1289.000000p
.measure tran QPH3R4 FIND V(xqph3) AT=1381.000000p
.measure tran EPH3R4 FIND V(xeph3) AT=1381.000000p
.measure tran QPH3H4 FIND V(xqph3) AT=1473.000000p
.measure tran EPH3H4 FIND V(xeph3) AT=1473.000000p
.measure tran QPH3T5 FIND V(xqph3) AT=1565.000000p
.measure tran EPH3T5 FIND V(xeph3) AT=1565.000000p
.measure tran QPH4T2 FIND V(xqph4) AT=829.000000p
.measure tran EPH4T2 FIND V(xeph4) AT=829.000000p
.measure tran QPH4R2 FIND V(xqph4) AT=921.000000p
.measure tran EPH4R2 FIND V(xeph4) AT=921.000000p
.measure tran QPH4H2 FIND V(xqph4) AT=1013.000000p
.measure tran EPH4H2 FIND V(xeph4) AT=1013.000000p
.measure tran QPH4T3 FIND V(xqph4) AT=1105.000000p
.measure tran EPH4T3 FIND V(xeph4) AT=1105.000000p
.measure tran QPH4R3 FIND V(xqph4) AT=1197.000000p
.measure tran EPH4R3 FIND V(xeph4) AT=1197.000000p
.measure tran QPH4H3 FIND V(xqph4) AT=1289.000000p
.measure tran EPH4H3 FIND V(xeph4) AT=1289.000000p
.measure tran QPH4T4 FIND V(xqph4) AT=1381.000000p
.measure tran EPH4T4 FIND V(xeph4) AT=1381.000000p
.measure tran QPH4R4 FIND V(xqph4) AT=1473.000000p
.measure tran EPH4R4 FIND V(xeph4) AT=1473.000000p
.measure tran QPH4H4 FIND V(xqph4) AT=1565.000000p
.measure tran EPH4H4 FIND V(xeph4) AT=1565.000000p
.measure tran QPH4T5 FIND V(xqph4) AT=1657.000000p
.measure tran EPH4T5 FIND V(xeph4) AT=1657.000000p
.measure tran QPH5T2 FIND V(xqph5) AT=921.000000p
.measure tran EPH5T2 FIND V(xeph5) AT=921.000000p
.measure tran QPH5R2 FIND V(xqph5) AT=1013.000000p
.measure tran EPH5R2 FIND V(xeph5) AT=1013.000000p
.measure tran QPH5H2 FIND V(xqph5) AT=1105.000000p
.measure tran EPH5H2 FIND V(xeph5) AT=1105.000000p
.measure tran QPH5T3 FIND V(xqph5) AT=1197.000000p
.measure tran EPH5T3 FIND V(xeph5) AT=1197.000000p
.measure tran QPH5R3 FIND V(xqph5) AT=1289.000000p
.measure tran EPH5R3 FIND V(xeph5) AT=1289.000000p
.measure tran QPH5H3 FIND V(xqph5) AT=1381.000000p
.measure tran EPH5H3 FIND V(xeph5) AT=1381.000000p
.measure tran QPH5T4 FIND V(xqph5) AT=1473.000000p
.measure tran EPH5T4 FIND V(xeph5) AT=1473.000000p
.measure tran QPH5R4 FIND V(xqph5) AT=1565.000000p
.measure tran EPH5R4 FIND V(xeph5) AT=1565.000000p
.measure tran QPH5H4 FIND V(xqph5) AT=1657.000000p
.measure tran EPH5H4 FIND V(xeph5) AT=1657.000000p
.measure tran QPH5T5 FIND V(xqph5) AT=1749.000000p
.measure tran EPH5T5 FIND V(xeph5) AT=1749.000000p
.measure tran QPH6T2 FIND V(xqph6) AT=1013.000000p
.measure tran EPH6T2 FIND V(xeph6) AT=1013.000000p
.measure tran QPH6R2 FIND V(xqph6) AT=1105.000000p
.measure tran EPH6R2 FIND V(xeph6) AT=1105.000000p
.measure tran QPH6H2 FIND V(xqph6) AT=1197.000000p
.measure tran EPH6H2 FIND V(xeph6) AT=1197.000000p
.measure tran QPH6T3 FIND V(xqph6) AT=1289.000000p
.measure tran EPH6T3 FIND V(xeph6) AT=1289.000000p
.measure tran QPH6R3 FIND V(xqph6) AT=1381.000000p
.measure tran EPH6R3 FIND V(xeph6) AT=1381.000000p
.measure tran QPH6H3 FIND V(xqph6) AT=1473.000000p
.measure tran EPH6H3 FIND V(xeph6) AT=1473.000000p
.measure tran QPH6T4 FIND V(xqph6) AT=1565.000000p
.measure tran EPH6T4 FIND V(xeph6) AT=1565.000000p
.measure tran QPH6R4 FIND V(xqph6) AT=1657.000000p
.measure tran EPH6R4 FIND V(xeph6) AT=1657.000000p
.measure tran QPH6H4 FIND V(xqph6) AT=1749.000000p
.measure tran EPH6H4 FIND V(xeph6) AT=1749.000000p
.measure tran QPH6T5 FIND V(xqph6) AT=1841.000000p
.measure tran EPH6T5 FIND V(xeph6) AT=1841.000000p
.measure tran IL_T2 FIND I(L1) AT=553.000000p
.measure tran QDD_T2 FIND V(xqdd) AT=553.000000p
.measure tran QZR_T2 FIND V(xqzr) AT=553.000000p
.measure tran ERL_T2 FIND V(xerl) AT=553.000000p
.measure tran ESW_T2 FIND V(xesw) AT=553.000000p
.measure tran EGN_T2 FIND V(xegn) AT=553.000000p
.measure tran IL_T3 FIND I(L1) AT=829.000000p
.measure tran QDD_T3 FIND V(xqdd) AT=829.000000p
.measure tran QZR_T3 FIND V(xqzr) AT=829.000000p
.measure tran ERL_T3 FIND V(xerl) AT=829.000000p
.measure tran ESW_T3 FIND V(xesw) AT=829.000000p
.measure tran EGN_T3 FIND V(xegn) AT=829.000000p
.measure tran IL_T4 FIND I(L1) AT=1105.000000p
.measure tran QDD_T4 FIND V(xqdd) AT=1105.000000p
.measure tran QZR_T4 FIND V(xqzr) AT=1105.000000p
.measure tran ERL_T4 FIND V(xerl) AT=1105.000000p
.measure tran ESW_T4 FIND V(xesw) AT=1105.000000p
.measure tran EGN_T4 FIND V(xegn) AT=1105.000000p
.measure tran IL_T5 FIND I(L1) AT=1381.000000p
.measure tran QDD_T5 FIND V(xqdd) AT=1381.000000p
.measure tran QZR_T5 FIND V(xqzr) AT=1381.000000p
.measure tran ERL_T5 FIND V(xerl) AT=1381.000000p
.measure tran ESW_T5 FIND V(xesw) AT=1381.000000p
.measure tran EGN_T5 FIND V(xegn) AT=1381.000000p
.measure tran QGA_inA FIND V(xqg_inA) AT=1012.500000p
.measure tran QGB_inA FIND V(xqg_inA) AT=1018.500000p
.measure tran QGA_pinA FIND V(xqg_pinA) AT=1012.500000p
.measure tran QGB_pinA FIND V(xqg_pinA) AT=1018.500000p
.measure tran QGA_outA FIND V(xqg_outA) AT=828.500000p
.measure tran QGB_outA FIND V(xqg_outA) AT=834.500000p
.measure tran QGA_poutA FIND V(xqg_poutA) AT=828.500000p
.measure tran QGB_poutA FIND V(xqg_poutA) AT=834.500000p
.measure tran QGA_holdA FIND V(xqg_holdA) AT=920.500000p
.measure tran QGB_holdA FIND V(xqg_holdA) AT=926.500000p
.measure tran QGA_zeroA FIND V(xqg_zeroA) AT=1086.100000p
.measure tran QGB_zeroA FIND V(xqg_zeroA) AT=1092.100000p
.measure tran QGA_indd FIND V(xqg_indd) AT=1086.100000p
.measure tran QGB_indd FIND V(xqg_indd) AT=1092.100000p
.measure tran QGA_pindd FIND V(xqg_pindd) AT=1086.100000p
.measure tran QGB_pindd FIND V(xqg_pindd) AT=1092.100000p
.measure tran QGA_inB FIND V(xqg_inB) AT=828.500000p
.measure tran QGB_inB FIND V(xqg_inB) AT=834.500000p
.measure tran QGA_pinB FIND V(xqg_pinB) AT=828.500000p
.measure tran QGB_pinB FIND V(xqg_pinB) AT=834.500000p
.measure tran QGA_outB FIND V(xqg_outB) AT=920.500000p
.measure tran QGB_outB FIND V(xqg_outB) AT=926.500000p
.measure tran QGA_poutB FIND V(xqg_poutB) AT=920.500000p
.measure tran QGB_poutB FIND V(xqg_poutB) AT=926.500000p
.measure tran QGA_holdB FIND V(xqg_holdB) AT=1012.500000p
.measure tran QGB_holdB FIND V(xqg_holdB) AT=1018.500000p
.measure tran QGA_zeroB FIND V(xqg_zeroB) AT=902.100000p
.measure tran QGB_zeroB FIND V(xqg_zeroB) AT=908.100000p
.measure tran QGA_inC FIND V(xqg_inC) AT=920.500000p
.measure tran QGB_inC FIND V(xqg_inC) AT=926.500000p
.measure tran QGA_pinC FIND V(xqg_pinC) AT=920.500000p
.measure tran QGB_pinC FIND V(xqg_pinC) AT=926.500000p
.measure tran QGA_outC FIND V(xqg_outC) AT=1012.500000p
.measure tran QGB_outC FIND V(xqg_outC) AT=1018.500000p
.measure tran QGA_poutC FIND V(xqg_poutC) AT=1012.500000p
.measure tran QGB_poutC FIND V(xqg_poutC) AT=1018.500000p
.measure tran QGA_holdC FIND V(xqg_holdC) AT=828.500000p
.measure tran QGB_holdC FIND V(xqg_holdC) AT=834.500000p
.measure tran QGA_zeroC FIND V(xqg_zeroC) AT=994.100000p
.measure tran QGB_zeroC FIND V(xqg_zeroC) AT=1000.100000p
.print tran V(ph1) V(ph2) V(ph3) V(ph4) V(ph5) V(ph6) V(o1_1_0) V(o1_1_1) V(o1_1_2) V(o1_1_3) V(o1_1_4) V(o1_1_5) V(o1_1_6) V(o1_1_7) V(o1_2_0) V(o1_2_1) V(o1_2_2) V(o1_2_3) V(o1_2_4) V(o1_2_5) V(o1_2_6) V(o1_2_7) V(o1_3_0) V(o1_3_1) V(o1_3_2) V(o1_3_3) V(o1_3_4) V(o1_3_5) V(o1_3_6) V(o1_3_7) V(o2_1_0) V(o2_1_1) V(o2_1_2) V(o2_1_3) V(o2_1_4) V(o2_1_5) V(o2_1_6) V(o2_1_7) V(o2_2_0) V(o2_2_1) V(o2_2_2) V(o2_2_3) V(o2_2_4) V(o2_2_5) V(o2_2_6) V(o2_2_7) V(o2_3_0) V(o2_3_1) V(o2_3_2) V(o2_3_3) V(o2_3_4) V(o2_3_5) V(o2_3_6) V(o2_3_7) V(o3_1_0) V(o3_1_1) V(o3_1_2) V(o3_1_3) V(o3_1_4) V(o3_1_5) V(o3_1_6) V(o3_1_7) V(o3_2_0) V(o3_2_1) V(o3_2_2) V(o3_2_3) V(o3_2_4) V(o3_2_5) V(o3_2_6) V(o3_2_7) V(o3_3_0) V(o3_3_1) V(o3_3_2) V(o3_3_3) V(o3_3_4) V(o3_3_5) V(o3_3_6) V(o3_3_7) V(o4_1_0) V(o4_1_1) V(o4_1_2) V(o4_1_3) V(o4_1_4) V(o4_1_5) V(o4_1_6) V(o4_1_7) V(o4_2_0) V(o4_2_1) V(o4_2_2) V(o4_2_3) V(o4_2_4) V(o4_2_5) V(o4_2_6) V(o4_2_7) V(o4_3_0) V(o4_3_1) V(o4_3_2) V(o4_3_3) V(o4_3_4) V(o4_3_5) V(o4_3_6) V(o4_3_7) V(o5_1_0) V(o5_1_1) V(o5_1_2) V(o5_1_3) V(o5_1_4) V(o5_1_5) V(o5_1_6) V(o5_1_7) V(o5_2_0) V(o5_2_1) V(o5_2_2) V(o5_2_3) V(o5_2_4) V(o5_2_5) V(o5_2_6) V(o5_2_7) V(o5_3_0) V(o5_3_1) V(o5_3_2) V(o5_3_3) V(o5_3_4) V(o5_3_5) V(o5_3_6) V(o5_3_7) V(o6_1_0) V(o6_1_1) V(o6_1_2) V(o6_1_3) V(o6_1_4) V(o6_1_5) V(o6_1_6) V(o6_1_7) V(o6_2_0) V(o6_2_1) V(o6_2_2) V(o6_2_3) V(o6_2_4) V(o6_2_5) V(o6_2_6) V(o6_2_7) V(o6_3_0) V(o6_3_1) V(o6_3_2) V(o6_3_3) V(o6_3_4) V(o6_3_5) V(o6_3_6) V(o6_3_7) I(VPH1) I(VPH2) I(VPH3) I(VPH4) I(VPH5) I(VPH6) I(VMG1) I(VMG2) I(VMG3) I(VMG4) I(VMG5) I(VMG6) I(L1) V(lin) V(lout) I(VDDH) I(VZR) I(VML) V(pA) V(pB) V(pC)
.end
