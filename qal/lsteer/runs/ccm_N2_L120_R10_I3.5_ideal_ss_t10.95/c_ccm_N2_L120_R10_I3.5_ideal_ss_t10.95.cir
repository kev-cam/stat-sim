.hdl "/usr/local/share/xyce/verilog-a/psp103/psp103.va"
.include "/usr/local/src/kestrel/sim/models/sg13g2_psp103_tt.lib"
.include "/usr/local/src/stat-sim/qal/sg13lv_compat.sp"
.OPTIONS TIMEINT METHOD=GEAR RELTOL=1e-6 ABSTOL=1e-15 CHGTOL=1e-17
* ---- qal/lsteer steered-inductor network (replaces VPHk/RSk) ----
VDDH vddh 0 1.65
VZR vzr 0 0
VPH1 ph1 pA 0
VPH2 ph2 pB 0
VPH3 ph3 pC 0
VPH4 ph4 pA 0
VPH5 ph5 pB 0
VPH6 ph6 pC 0
Ctin lin 0 20f
Ctout lout 0 20f
VML lin lmid 0
RL1 lmid lx 10
L1 lx lout 120n IC=3.58143m
.model SWI VSWITCH RON=0.05 ROFF=1e8 VON=0.7 VOFF=0.3
Vcss css 0 PWL(0 1 275.5p 1 275.8p 0)
Sfw lin lout css 0 SWI
VTRA trA 0 PWL(0 0 92p 1.65 184p 1.65 276p 0 368p 1.65 460p 1.65 552p 0 644p 1.65 736p 1.65)
StrA trA pA css 0 SWI
VTRB trB 0 PWL(0 1.65 92p 0 184p 1.65 276p 1.65 368p 0 460p 1.65 552p 1.65)
StrB trB pB css 0 SWI
VTRC trC 0 PWL(0 1.65 92p 1.65 184p 0 276p 1.65 368p 1.65 460p 0 552p 1.65 644p 1.65)
StrC trC pC css 0 SWI
VcinA cinA 0 PWL(0 0 460.2p 0 460.5p 1 546.9p 1 547.2p 0 736.2p 0 736.5p 1 822.9p 1 823.2p 0 1012.2p 0 1012.5p 1 1098.9p 1 1099.2p 0 1288.2p 0 1288.5p 1 1374.9p 1 1375.2p 0 1564.2p 0 1564.5p 1 1650.9p 1 1651.2p 0 1840.2p 0 1840.5p 1 1926.9p 1 1927.2p 0 2116.2p 0 2116.5p 1 2202.9p 1 2203.2p 0)
VSinA pA sinA 0
SinA sinA lin cinA 0 SWI
VcoutA coutA 0 PWL(0 0 276.2p 0 276.5p 1 367.5p 1 367.8p 0 552.2p 0 552.5p 1 643.5p 1 643.8p 0 828.2p 0 828.5p 1 919.5p 1 919.8p 0 1104.2p 0 1104.5p 1 1195.5p 1 1195.8p 0 1380.2p 0 1380.5p 1 1471.5p 1 1471.8p 0 1656.2p 0 1656.5p 1 1747.5p 1 1747.8p 0 1932.2p 0 1932.5p 1 2023.5p 1 2023.8p 0)
VSoutA pA soutA 0
SoutA soutA lout coutA 0 SWI
VcholdA choldA 0 PWL(0 0 368.2p 0 368.5p 1 459.5p 1 459.8p 0 644.2p 0 644.5p 1 735.5p 1 735.8p 0 920.2p 0 920.5p 1 1011.5p 1 1011.8p 0 1196.2p 0 1196.5p 1 1287.5p 1 1287.8p 0 1472.2p 0 1472.5p 1 1563.5p 1 1563.8p 0 1748.2p 0 1748.5p 1 1839.5p 1 1839.8p 0 2024.2p 0 2024.5p 1 2115.5p 1 2115.8p 0)
VSholdA pA sholdA 0
SholdA sholdA vddh choldA 0 SWI
VczeroA czeroA 0 PWL(0 0 547.6p 0 547.9p 1 551.5p 1 551.8p 0 823.6p 0 823.9p 1 827.5p 1 827.8p 0 1099.6p 0 1099.9p 1 1103.5p 1 1103.8p 0 1375.6p 0 1375.9p 1 1379.5p 1 1379.8p 0 1651.6p 0 1651.9p 1 1655.5p 1 1655.8p 0 1927.6p 0 1927.9p 1 1931.5p 1 1931.8p 0 2203.6p 0 2203.9p 1 2207.5p 1 2207.8p 0)
VSzeroA pA szeroA 0
SzeroA szeroA vzr czeroA 0 SWI
Vcindd cindd 0 PWL(0 0 363.6p 0 363.9p 1 367.5p 1 367.8p 0 455.6p 0 455.9p 1 459.5p 1 459.8p 0 547.6p 0 547.9p 1 551.5p 1 551.8p 0 639.6p 0 639.9p 1 643.5p 1 643.8p 0 731.6p 0 731.9p 1 735.5p 1 735.8p 0 823.6p 0 823.9p 1 827.5p 1 827.8p 0 915.6p 0 915.9p 1 919.5p 1 919.8p 0 1007.6p 0 1007.9p 1 1011.5p 1 1011.8p 0 1099.6p 0 1099.9p 1 1103.5p 1 1103.8p 0 1191.6p 0 1191.9p 1 1195.5p 1 1195.8p 0 1283.6p 0 1283.9p 1 1287.5p 1 1287.8p 0 1375.6p 0 1375.9p 1 1379.5p 1 1379.8p 0 1467.6p 0 1467.9p 1 1471.5p 1 1471.8p 0 1559.6p 0 1559.9p 1 1563.5p 1 1563.8p 0 1651.6p 0 1651.9p 1 1655.5p 1 1655.8p 0 1743.6p 0 1743.9p 1 1747.5p 1 1747.8p 0 1835.6p 0 1835.9p 1 1839.5p 1 1839.8p 0 1927.6p 0 1927.9p 1 1931.5p 1 1931.8p 0 2019.6p 0 2019.9p 1 2023.5p 1 2023.8p 0 2111.6p 0 2111.9p 1 2115.5p 1 2115.8p 0 2203.6p 0 2203.9p 1 2207.5p 1 2207.8p 0)
VSindd vddh sindd 0
Sindd sindd lin cindd 0 SWI
VcinB cinB 0 PWL(0 0 276.2p 0 276.5p 1 362.9p 1 363.2p 0 552.2p 0 552.5p 1 638.9p 1 639.2p 0 828.2p 0 828.5p 1 914.9p 1 915.2p 0 1104.2p 0 1104.5p 1 1190.9p 1 1191.2p 0 1380.2p 0 1380.5p 1 1466.9p 1 1467.2p 0 1656.2p 0 1656.5p 1 1742.9p 1 1743.2p 0 1932.2p 0 1932.5p 1 2018.9p 1 2019.2p 0)
VSinB pB sinB 0
SinB sinB lin cinB 0 SWI
VcoutB coutB 0 PWL(0 0 368.2p 0 368.5p 1 459.5p 1 459.8p 0 644.2p 0 644.5p 1 735.5p 1 735.8p 0 920.2p 0 920.5p 1 1011.5p 1 1011.8p 0 1196.2p 0 1196.5p 1 1287.5p 1 1287.8p 0 1472.2p 0 1472.5p 1 1563.5p 1 1563.8p 0 1748.2p 0 1748.5p 1 1839.5p 1 1839.8p 0 2024.2p 0 2024.5p 1 2115.5p 1 2115.8p 0)
VSoutB pB soutB 0
SoutB soutB lout coutB 0 SWI
VcholdB choldB 0 PWL(0 0 460.2p 0 460.5p 1 551.5p 1 551.8p 0 736.2p 0 736.5p 1 827.5p 1 827.8p 0 1012.2p 0 1012.5p 1 1103.5p 1 1103.8p 0 1288.2p 0 1288.5p 1 1379.5p 1 1379.8p 0 1564.2p 0 1564.5p 1 1655.5p 1 1655.8p 0 1840.2p 0 1840.5p 1 1931.5p 1 1931.8p 0 2116.2p 0 2116.5p 1 2207.5p 1 2207.8p 0)
VSholdB pB sholdB 0
SholdB sholdB vddh choldB 0 SWI
VczeroB czeroB 0 PWL(0 0 363.6p 0 363.9p 1 367.5p 1 367.8p 0 639.6p 0 639.9p 1 643.5p 1 643.8p 0 915.6p 0 915.9p 1 919.5p 1 919.8p 0 1191.6p 0 1191.9p 1 1195.5p 1 1195.8p 0 1467.6p 0 1467.9p 1 1471.5p 1 1471.8p 0 1743.6p 0 1743.9p 1 1747.5p 1 1747.8p 0 2019.6p 0 2019.9p 1 2023.5p 1 2023.8p 0)
VSzeroB pB szeroB 0
SzeroB szeroB vzr czeroB 0 SWI
VcinC cinC 0 PWL(0 0 368.2p 0 368.5p 1 454.9p 1 455.2p 0 644.2p 0 644.5p 1 730.9p 1 731.2p 0 920.2p 0 920.5p 1 1006.9p 1 1007.2p 0 1196.2p 0 1196.5p 1 1282.9p 1 1283.2p 0 1472.2p 0 1472.5p 1 1558.9p 1 1559.2p 0 1748.2p 0 1748.5p 1 1834.9p 1 1835.2p 0 2024.2p 0 2024.5p 1 2110.9p 1 2111.2p 0)
VSinC pC sinC 0
SinC sinC lin cinC 0 SWI
VcoutC coutC 0 PWL(0 0 460.2p 0 460.5p 1 551.5p 1 551.8p 0 736.2p 0 736.5p 1 827.5p 1 827.8p 0 1012.2p 0 1012.5p 1 1103.5p 1 1103.8p 0 1288.2p 0 1288.5p 1 1379.5p 1 1379.8p 0 1564.2p 0 1564.5p 1 1655.5p 1 1655.8p 0 1840.2p 0 1840.5p 1 1931.5p 1 1931.8p 0 2116.2p 0 2116.5p 1 2207.5p 1 2207.8p 0)
VSoutC pC soutC 0
SoutC soutC lout coutC 0 SWI
VcholdC choldC 0 PWL(0 0 276.2p 0 276.5p 1 367.5p 1 367.8p 0 552.2p 0 552.5p 1 643.5p 1 643.8p 0 828.2p 0 828.5p 1 919.5p 1 919.8p 0 1104.2p 0 1104.5p 1 1195.5p 1 1195.8p 0 1380.2p 0 1380.5p 1 1471.5p 1 1471.8p 0 1656.2p 0 1656.5p 1 1747.5p 1 1747.8p 0 1932.2p 0 1932.5p 1 2023.5p 1 2023.8p 0)
VSholdC pC sholdC 0
SholdC sholdC vddh choldC 0 SWI
VczeroC czeroC 0 PWL(0 0 455.6p 0 455.9p 1 459.5p 1 459.8p 0 731.6p 0 731.9p 1 735.5p 1 735.8p 0 1007.6p 0 1007.9p 1 1011.5p 1 1011.8p 0 1283.6p 0 1283.9p 1 1287.5p 1 1287.8p 0 1559.6p 0 1559.9p 1 1563.5p 1 1563.8p 0 1835.6p 0 1835.9p 1 1839.5p 1 1839.8p 0 2111.6p 0 2111.9p 1 2115.5p 1 2115.8p 0)
VSzeroC pC szeroC 0
SzeroC szeroC vzr czeroC 0 SWI
CXqdd xqdd 0 1
BXqdd 0 xqdd I={ -I(VDDH) }
RXqdd xqdd 0 0.01
CXqzr xqzr 0 1
BXqzr 0 xqzr I={ -I(VZR) }
RXqzr xqzr 0 0.01
CXerl xerl 0 1
BXerl 0 xerl I={ I(VML)*I(VML)*10 }
RXerl xerl 0 0.01
CXesw xesw 0 1
BXesw 0 xesw I={ (V(pA)-V(lin))*I(VSinA)+(V(pA)-V(lout))*I(VSoutA)+(V(pA)-V(vddh))*I(VSholdA)+(V(pA)-V(vzr))*I(VSzeroA)+(V(vddh)-V(lin))*I(VSindd)+(V(pB)-V(lin))*I(VSinB)+(V(pB)-V(lout))*I(VSoutB)+(V(pB)-V(vddh))*I(VSholdB)+(V(pB)-V(vzr))*I(VSzeroB)+(V(pC)-V(lin))*I(VSinC)+(V(pC)-V(lout))*I(VSoutC)+(V(pC)-V(vddh))*I(VSholdC)+(V(pC)-V(vzr))*I(VSzeroC) }
RXesw xesw 0 0.01
VI1_0 in1_0 0 PWL(0 1.65 275p 1.65 277p 0 551p 0 553p 1.65 827p 1.65 829p 0 1103p 0 1105p 1.65 1379p 1.65 1381p 0 1655p 0 1657p 1.65 1931p 1.65 1933p 0)
VI1_1 in1_1 0 PWL(0 1.65 275p 1.65 277p 0 551p 0 553p 1.65 827p 1.65 829p 0 1103p 0 1105p 1.65 1379p 1.65 1381p 0 1655p 0 1657p 1.65 1931p 1.65 1933p 0)
VI1_2 in1_2 0 PWL(0 1.65 275p 1.65 277p 0 551p 0 553p 1.65 827p 1.65 829p 0 1103p 0 1105p 1.65 1379p 1.65 1381p 0 1655p 0 1657p 1.65 1931p 1.65 1933p 0)
VI1_3 in1_3 0 PWL(0 0 275p 0 277p 1.65 551p 1.65 553p 0 827p 0 829p 1.65 1103p 1.65 1105p 0 1379p 0 1381p 1.65 1655p 1.65 1657p 0 1931p 0 1933p 1.65)
VI1_4 in1_4 0 PWL(0 1.65 275p 1.65 277p 0 551p 0 553p 1.65 827p 1.65 829p 0 1103p 0 1105p 1.65 1379p 1.65 1381p 0 1655p 0 1657p 1.65 1931p 1.65 1933p 0)
VI1_5 in1_5 0 PWL(0 0 275p 0 277p 1.65 551p 1.65 553p 0 827p 0 829p 1.65 1103p 1.65 1105p 0 1379p 0 1381p 1.65 1655p 1.65 1657p 0 1931p 0 1933p 1.65)
VI1_6 in1_6 0 PWL(0 0 275p 0 277p 1.65 551p 1.65 553p 0 827p 0 829p 1.65 1103p 1.65 1105p 0 1379p 0 1381p 1.65 1655p 1.65 1657p 0 1931p 0 1933p 1.65)
VI1_7 in1_7 0 PWL(0 1.65 275p 1.65 277p 0 551p 0 553p 1.65 827p 1.65 829p 0 1103p 0 1105p 1.65 1379p 1.65 1381p 0 1655p 0 1657p 1.65 1931p 1.65 1933p 0)
VMG1 gn1 0 0
XP1_1_0 o1_1_0 in1_0 ph1 ph1 sg13_lv_pmos w=1.12u l=0.13u
XN1_1_0 o1_1_0 in1_0 gn1 gn1 sg13_lv_nmos w=0.74u l=0.13u
CL1_1_0 o1_1_0 gn1 2f
XP1_1_1 o1_1_1 in1_1 ph1 ph1 sg13_lv_pmos w=1.12u l=0.13u
XN1_1_1 o1_1_1 in1_1 gn1 gn1 sg13_lv_nmos w=0.74u l=0.13u
CL1_1_1 o1_1_1 gn1 2f
XP1_1_2 o1_1_2 in1_2 ph1 ph1 sg13_lv_pmos w=1.12u l=0.13u
XN1_1_2 o1_1_2 in1_2 gn1 gn1 sg13_lv_nmos w=0.74u l=0.13u
CL1_1_2 o1_1_2 gn1 2f
XP1_1_3 o1_1_3 in1_3 ph1 ph1 sg13_lv_pmos w=1.12u l=0.13u
XN1_1_3 o1_1_3 in1_3 gn1 gn1 sg13_lv_nmos w=0.74u l=0.13u
CL1_1_3 o1_1_3 gn1 2f
XP1_1_4 o1_1_4 in1_4 ph1 ph1 sg13_lv_pmos w=1.12u l=0.13u
XN1_1_4 o1_1_4 in1_4 gn1 gn1 sg13_lv_nmos w=0.74u l=0.13u
CL1_1_4 o1_1_4 gn1 2f
XP1_1_5 o1_1_5 in1_5 ph1 ph1 sg13_lv_pmos w=1.12u l=0.13u
XN1_1_5 o1_1_5 in1_5 gn1 gn1 sg13_lv_nmos w=0.74u l=0.13u
CL1_1_5 o1_1_5 gn1 2f
XP1_1_6 o1_1_6 in1_6 ph1 ph1 sg13_lv_pmos w=1.12u l=0.13u
XN1_1_6 o1_1_6 in1_6 gn1 gn1 sg13_lv_nmos w=0.74u l=0.13u
CL1_1_6 o1_1_6 gn1 2f
XP1_1_7 o1_1_7 in1_7 ph1 ph1 sg13_lv_pmos w=1.12u l=0.13u
XN1_1_7 o1_1_7 in1_7 gn1 gn1 sg13_lv_nmos w=0.74u l=0.13u
CL1_1_7 o1_1_7 gn1 2f
XP1_2_0 o1_2_0 o1_1_0 ph1 ph1 sg13_lv_pmos w=1.12u l=0.13u
XN1_2_0 o1_2_0 o1_1_0 gn1 gn1 sg13_lv_nmos w=0.74u l=0.13u
CL1_2_0 o1_2_0 gn1 2f
XP1_2_1 o1_2_1 o1_1_1 ph1 ph1 sg13_lv_pmos w=1.12u l=0.13u
XN1_2_1 o1_2_1 o1_1_1 gn1 gn1 sg13_lv_nmos w=0.74u l=0.13u
CL1_2_1 o1_2_1 gn1 2f
XP1_2_2 o1_2_2 o1_1_2 ph1 ph1 sg13_lv_pmos w=1.12u l=0.13u
XN1_2_2 o1_2_2 o1_1_2 gn1 gn1 sg13_lv_nmos w=0.74u l=0.13u
CL1_2_2 o1_2_2 gn1 2f
XP1_2_3 o1_2_3 o1_1_3 ph1 ph1 sg13_lv_pmos w=1.12u l=0.13u
XN1_2_3 o1_2_3 o1_1_3 gn1 gn1 sg13_lv_nmos w=0.74u l=0.13u
CL1_2_3 o1_2_3 gn1 2f
XP1_2_4 o1_2_4 o1_1_4 ph1 ph1 sg13_lv_pmos w=1.12u l=0.13u
XN1_2_4 o1_2_4 o1_1_4 gn1 gn1 sg13_lv_nmos w=0.74u l=0.13u
CL1_2_4 o1_2_4 gn1 2f
XP1_2_5 o1_2_5 o1_1_5 ph1 ph1 sg13_lv_pmos w=1.12u l=0.13u
XN1_2_5 o1_2_5 o1_1_5 gn1 gn1 sg13_lv_nmos w=0.74u l=0.13u
CL1_2_5 o1_2_5 gn1 2f
XP1_2_6 o1_2_6 o1_1_6 ph1 ph1 sg13_lv_pmos w=1.12u l=0.13u
XN1_2_6 o1_2_6 o1_1_6 gn1 gn1 sg13_lv_nmos w=0.74u l=0.13u
CL1_2_6 o1_2_6 gn1 2f
XP1_2_7 o1_2_7 o1_1_7 ph1 ph1 sg13_lv_pmos w=1.12u l=0.13u
XN1_2_7 o1_2_7 o1_1_7 gn1 gn1 sg13_lv_nmos w=0.74u l=0.13u
CL1_2_7 o1_2_7 gn1 2f
XP1_3_0 o1_3_0 o1_2_0 ph1 ph1 sg13_lv_pmos w=1.12u l=0.13u
XN1_3_0 o1_3_0 o1_2_0 gn1 gn1 sg13_lv_nmos w=0.74u l=0.13u
CL1_3_0 o1_3_0 gn1 2f
XP1_3_1 o1_3_1 o1_2_1 ph1 ph1 sg13_lv_pmos w=1.12u l=0.13u
XN1_3_1 o1_3_1 o1_2_1 gn1 gn1 sg13_lv_nmos w=0.74u l=0.13u
CL1_3_1 o1_3_1 gn1 2f
XP1_3_2 o1_3_2 o1_2_2 ph1 ph1 sg13_lv_pmos w=1.12u l=0.13u
XN1_3_2 o1_3_2 o1_2_2 gn1 gn1 sg13_lv_nmos w=0.74u l=0.13u
CL1_3_2 o1_3_2 gn1 2f
XP1_3_3 o1_3_3 o1_2_3 ph1 ph1 sg13_lv_pmos w=1.12u l=0.13u
XN1_3_3 o1_3_3 o1_2_3 gn1 gn1 sg13_lv_nmos w=0.74u l=0.13u
CL1_3_3 o1_3_3 gn1 2f
XP1_3_4 o1_3_4 o1_2_4 ph1 ph1 sg13_lv_pmos w=1.12u l=0.13u
XN1_3_4 o1_3_4 o1_2_4 gn1 gn1 sg13_lv_nmos w=0.74u l=0.13u
CL1_3_4 o1_3_4 gn1 2f
XP1_3_5 o1_3_5 o1_2_5 ph1 ph1 sg13_lv_pmos w=1.12u l=0.13u
XN1_3_5 o1_3_5 o1_2_5 gn1 gn1 sg13_lv_nmos w=0.74u l=0.13u
CL1_3_5 o1_3_5 gn1 2f
XP1_3_6 o1_3_6 o1_2_6 ph1 ph1 sg13_lv_pmos w=1.12u l=0.13u
XN1_3_6 o1_3_6 o1_2_6 gn1 gn1 sg13_lv_nmos w=0.74u l=0.13u
CL1_3_6 o1_3_6 gn1 2f
XP1_3_7 o1_3_7 o1_2_7 ph1 ph1 sg13_lv_pmos w=1.12u l=0.13u
XN1_3_7 o1_3_7 o1_2_7 gn1 gn1 sg13_lv_nmos w=0.74u l=0.13u
CL1_3_7 o1_3_7 gn1 2f
VMG2 gn2 0 0
XP2_1_0 o2_1_0 o1_3_0 ph2 ph2 sg13_lv_pmos w=1.12u l=0.13u
XN2_1_0 o2_1_0 o1_3_0 gn2 gn2 sg13_lv_nmos w=0.74u l=0.13u
CL2_1_0 o2_1_0 gn2 2f
XP2_1_1 o2_1_1 o1_3_1 ph2 ph2 sg13_lv_pmos w=1.12u l=0.13u
XN2_1_1 o2_1_1 o1_3_1 gn2 gn2 sg13_lv_nmos w=0.74u l=0.13u
CL2_1_1 o2_1_1 gn2 2f
XP2_1_2 o2_1_2 o1_3_2 ph2 ph2 sg13_lv_pmos w=1.12u l=0.13u
XN2_1_2 o2_1_2 o1_3_2 gn2 gn2 sg13_lv_nmos w=0.74u l=0.13u
CL2_1_2 o2_1_2 gn2 2f
XP2_1_3 o2_1_3 o1_3_3 ph2 ph2 sg13_lv_pmos w=1.12u l=0.13u
XN2_1_3 o2_1_3 o1_3_3 gn2 gn2 sg13_lv_nmos w=0.74u l=0.13u
CL2_1_3 o2_1_3 gn2 2f
XP2_1_4 o2_1_4 o1_3_4 ph2 ph2 sg13_lv_pmos w=1.12u l=0.13u
XN2_1_4 o2_1_4 o1_3_4 gn2 gn2 sg13_lv_nmos w=0.74u l=0.13u
CL2_1_4 o2_1_4 gn2 2f
XP2_1_5 o2_1_5 o1_3_5 ph2 ph2 sg13_lv_pmos w=1.12u l=0.13u
XN2_1_5 o2_1_5 o1_3_5 gn2 gn2 sg13_lv_nmos w=0.74u l=0.13u
CL2_1_5 o2_1_5 gn2 2f
XP2_1_6 o2_1_6 o1_3_6 ph2 ph2 sg13_lv_pmos w=1.12u l=0.13u
XN2_1_6 o2_1_6 o1_3_6 gn2 gn2 sg13_lv_nmos w=0.74u l=0.13u
CL2_1_6 o2_1_6 gn2 2f
XP2_1_7 o2_1_7 o1_3_7 ph2 ph2 sg13_lv_pmos w=1.12u l=0.13u
XN2_1_7 o2_1_7 o1_3_7 gn2 gn2 sg13_lv_nmos w=0.74u l=0.13u
CL2_1_7 o2_1_7 gn2 2f
XP2_2_0 o2_2_0 o2_1_0 ph2 ph2 sg13_lv_pmos w=1.12u l=0.13u
XN2_2_0 o2_2_0 o2_1_0 gn2 gn2 sg13_lv_nmos w=0.74u l=0.13u
CL2_2_0 o2_2_0 gn2 2f
XP2_2_1 o2_2_1 o2_1_1 ph2 ph2 sg13_lv_pmos w=1.12u l=0.13u
XN2_2_1 o2_2_1 o2_1_1 gn2 gn2 sg13_lv_nmos w=0.74u l=0.13u
CL2_2_1 o2_2_1 gn2 2f
XP2_2_2 o2_2_2 o2_1_2 ph2 ph2 sg13_lv_pmos w=1.12u l=0.13u
XN2_2_2 o2_2_2 o2_1_2 gn2 gn2 sg13_lv_nmos w=0.74u l=0.13u
CL2_2_2 o2_2_2 gn2 2f
XP2_2_3 o2_2_3 o2_1_3 ph2 ph2 sg13_lv_pmos w=1.12u l=0.13u
XN2_2_3 o2_2_3 o2_1_3 gn2 gn2 sg13_lv_nmos w=0.74u l=0.13u
CL2_2_3 o2_2_3 gn2 2f
XP2_2_4 o2_2_4 o2_1_4 ph2 ph2 sg13_lv_pmos w=1.12u l=0.13u
XN2_2_4 o2_2_4 o2_1_4 gn2 gn2 sg13_lv_nmos w=0.74u l=0.13u
CL2_2_4 o2_2_4 gn2 2f
XP2_2_5 o2_2_5 o2_1_5 ph2 ph2 sg13_lv_pmos w=1.12u l=0.13u
XN2_2_5 o2_2_5 o2_1_5 gn2 gn2 sg13_lv_nmos w=0.74u l=0.13u
CL2_2_5 o2_2_5 gn2 2f
XP2_2_6 o2_2_6 o2_1_6 ph2 ph2 sg13_lv_pmos w=1.12u l=0.13u
XN2_2_6 o2_2_6 o2_1_6 gn2 gn2 sg13_lv_nmos w=0.74u l=0.13u
CL2_2_6 o2_2_6 gn2 2f
XP2_2_7 o2_2_7 o2_1_7 ph2 ph2 sg13_lv_pmos w=1.12u l=0.13u
XN2_2_7 o2_2_7 o2_1_7 gn2 gn2 sg13_lv_nmos w=0.74u l=0.13u
CL2_2_7 o2_2_7 gn2 2f
XP2_3_0 o2_3_0 o2_2_0 ph2 ph2 sg13_lv_pmos w=1.12u l=0.13u
XN2_3_0 o2_3_0 o2_2_0 gn2 gn2 sg13_lv_nmos w=0.74u l=0.13u
CL2_3_0 o2_3_0 gn2 2f
XP2_3_1 o2_3_1 o2_2_1 ph2 ph2 sg13_lv_pmos w=1.12u l=0.13u
XN2_3_1 o2_3_1 o2_2_1 gn2 gn2 sg13_lv_nmos w=0.74u l=0.13u
CL2_3_1 o2_3_1 gn2 2f
XP2_3_2 o2_3_2 o2_2_2 ph2 ph2 sg13_lv_pmos w=1.12u l=0.13u
XN2_3_2 o2_3_2 o2_2_2 gn2 gn2 sg13_lv_nmos w=0.74u l=0.13u
CL2_3_2 o2_3_2 gn2 2f
XP2_3_3 o2_3_3 o2_2_3 ph2 ph2 sg13_lv_pmos w=1.12u l=0.13u
XN2_3_3 o2_3_3 o2_2_3 gn2 gn2 sg13_lv_nmos w=0.74u l=0.13u
CL2_3_3 o2_3_3 gn2 2f
XP2_3_4 o2_3_4 o2_2_4 ph2 ph2 sg13_lv_pmos w=1.12u l=0.13u
XN2_3_4 o2_3_4 o2_2_4 gn2 gn2 sg13_lv_nmos w=0.74u l=0.13u
CL2_3_4 o2_3_4 gn2 2f
XP2_3_5 o2_3_5 o2_2_5 ph2 ph2 sg13_lv_pmos w=1.12u l=0.13u
XN2_3_5 o2_3_5 o2_2_5 gn2 gn2 sg13_lv_nmos w=0.74u l=0.13u
CL2_3_5 o2_3_5 gn2 2f
XP2_3_6 o2_3_6 o2_2_6 ph2 ph2 sg13_lv_pmos w=1.12u l=0.13u
XN2_3_6 o2_3_6 o2_2_6 gn2 gn2 sg13_lv_nmos w=0.74u l=0.13u
CL2_3_6 o2_3_6 gn2 2f
XP2_3_7 o2_3_7 o2_2_7 ph2 ph2 sg13_lv_pmos w=1.12u l=0.13u
XN2_3_7 o2_3_7 o2_2_7 gn2 gn2 sg13_lv_nmos w=0.74u l=0.13u
CL2_3_7 o2_3_7 gn2 2f
VMG3 gn3 0 0
XP3_1_0 o3_1_0 o2_3_0 ph3 ph3 sg13_lv_pmos w=1.12u l=0.13u
XN3_1_0 o3_1_0 o2_3_0 gn3 gn3 sg13_lv_nmos w=0.74u l=0.13u
CL3_1_0 o3_1_0 gn3 2f
XP3_1_1 o3_1_1 o2_3_1 ph3 ph3 sg13_lv_pmos w=1.12u l=0.13u
XN3_1_1 o3_1_1 o2_3_1 gn3 gn3 sg13_lv_nmos w=0.74u l=0.13u
CL3_1_1 o3_1_1 gn3 2f
XP3_1_2 o3_1_2 o2_3_2 ph3 ph3 sg13_lv_pmos w=1.12u l=0.13u
XN3_1_2 o3_1_2 o2_3_2 gn3 gn3 sg13_lv_nmos w=0.74u l=0.13u
CL3_1_2 o3_1_2 gn3 2f
XP3_1_3 o3_1_3 o2_3_3 ph3 ph3 sg13_lv_pmos w=1.12u l=0.13u
XN3_1_3 o3_1_3 o2_3_3 gn3 gn3 sg13_lv_nmos w=0.74u l=0.13u
CL3_1_3 o3_1_3 gn3 2f
XP3_1_4 o3_1_4 o2_3_4 ph3 ph3 sg13_lv_pmos w=1.12u l=0.13u
XN3_1_4 o3_1_4 o2_3_4 gn3 gn3 sg13_lv_nmos w=0.74u l=0.13u
CL3_1_4 o3_1_4 gn3 2f
XP3_1_5 o3_1_5 o2_3_5 ph3 ph3 sg13_lv_pmos w=1.12u l=0.13u
XN3_1_5 o3_1_5 o2_3_5 gn3 gn3 sg13_lv_nmos w=0.74u l=0.13u
CL3_1_5 o3_1_5 gn3 2f
XP3_1_6 o3_1_6 o2_3_6 ph3 ph3 sg13_lv_pmos w=1.12u l=0.13u
XN3_1_6 o3_1_6 o2_3_6 gn3 gn3 sg13_lv_nmos w=0.74u l=0.13u
CL3_1_6 o3_1_6 gn3 2f
XP3_1_7 o3_1_7 o2_3_7 ph3 ph3 sg13_lv_pmos w=1.12u l=0.13u
XN3_1_7 o3_1_7 o2_3_7 gn3 gn3 sg13_lv_nmos w=0.74u l=0.13u
CL3_1_7 o3_1_7 gn3 2f
XP3_2_0 o3_2_0 o3_1_0 ph3 ph3 sg13_lv_pmos w=1.12u l=0.13u
XN3_2_0 o3_2_0 o3_1_0 gn3 gn3 sg13_lv_nmos w=0.74u l=0.13u
CL3_2_0 o3_2_0 gn3 2f
XP3_2_1 o3_2_1 o3_1_1 ph3 ph3 sg13_lv_pmos w=1.12u l=0.13u
XN3_2_1 o3_2_1 o3_1_1 gn3 gn3 sg13_lv_nmos w=0.74u l=0.13u
CL3_2_1 o3_2_1 gn3 2f
XP3_2_2 o3_2_2 o3_1_2 ph3 ph3 sg13_lv_pmos w=1.12u l=0.13u
XN3_2_2 o3_2_2 o3_1_2 gn3 gn3 sg13_lv_nmos w=0.74u l=0.13u
CL3_2_2 o3_2_2 gn3 2f
XP3_2_3 o3_2_3 o3_1_3 ph3 ph3 sg13_lv_pmos w=1.12u l=0.13u
XN3_2_3 o3_2_3 o3_1_3 gn3 gn3 sg13_lv_nmos w=0.74u l=0.13u
CL3_2_3 o3_2_3 gn3 2f
XP3_2_4 o3_2_4 o3_1_4 ph3 ph3 sg13_lv_pmos w=1.12u l=0.13u
XN3_2_4 o3_2_4 o3_1_4 gn3 gn3 sg13_lv_nmos w=0.74u l=0.13u
CL3_2_4 o3_2_4 gn3 2f
XP3_2_5 o3_2_5 o3_1_5 ph3 ph3 sg13_lv_pmos w=1.12u l=0.13u
XN3_2_5 o3_2_5 o3_1_5 gn3 gn3 sg13_lv_nmos w=0.74u l=0.13u
CL3_2_5 o3_2_5 gn3 2f
XP3_2_6 o3_2_6 o3_1_6 ph3 ph3 sg13_lv_pmos w=1.12u l=0.13u
XN3_2_6 o3_2_6 o3_1_6 gn3 gn3 sg13_lv_nmos w=0.74u l=0.13u
CL3_2_6 o3_2_6 gn3 2f
XP3_2_7 o3_2_7 o3_1_7 ph3 ph3 sg13_lv_pmos w=1.12u l=0.13u
XN3_2_7 o3_2_7 o3_1_7 gn3 gn3 sg13_lv_nmos w=0.74u l=0.13u
CL3_2_7 o3_2_7 gn3 2f
XP3_3_0 o3_3_0 o3_2_0 ph3 ph3 sg13_lv_pmos w=1.12u l=0.13u
XN3_3_0 o3_3_0 o3_2_0 gn3 gn3 sg13_lv_nmos w=0.74u l=0.13u
CL3_3_0 o3_3_0 gn3 2f
XP3_3_1 o3_3_1 o3_2_1 ph3 ph3 sg13_lv_pmos w=1.12u l=0.13u
XN3_3_1 o3_3_1 o3_2_1 gn3 gn3 sg13_lv_nmos w=0.74u l=0.13u
CL3_3_1 o3_3_1 gn3 2f
XP3_3_2 o3_3_2 o3_2_2 ph3 ph3 sg13_lv_pmos w=1.12u l=0.13u
XN3_3_2 o3_3_2 o3_2_2 gn3 gn3 sg13_lv_nmos w=0.74u l=0.13u
CL3_3_2 o3_3_2 gn3 2f
XP3_3_3 o3_3_3 o3_2_3 ph3 ph3 sg13_lv_pmos w=1.12u l=0.13u
XN3_3_3 o3_3_3 o3_2_3 gn3 gn3 sg13_lv_nmos w=0.74u l=0.13u
CL3_3_3 o3_3_3 gn3 2f
XP3_3_4 o3_3_4 o3_2_4 ph3 ph3 sg13_lv_pmos w=1.12u l=0.13u
XN3_3_4 o3_3_4 o3_2_4 gn3 gn3 sg13_lv_nmos w=0.74u l=0.13u
CL3_3_4 o3_3_4 gn3 2f
XP3_3_5 o3_3_5 o3_2_5 ph3 ph3 sg13_lv_pmos w=1.12u l=0.13u
XN3_3_5 o3_3_5 o3_2_5 gn3 gn3 sg13_lv_nmos w=0.74u l=0.13u
CL3_3_5 o3_3_5 gn3 2f
XP3_3_6 o3_3_6 o3_2_6 ph3 ph3 sg13_lv_pmos w=1.12u l=0.13u
XN3_3_6 o3_3_6 o3_2_6 gn3 gn3 sg13_lv_nmos w=0.74u l=0.13u
CL3_3_6 o3_3_6 gn3 2f
XP3_3_7 o3_3_7 o3_2_7 ph3 ph3 sg13_lv_pmos w=1.12u l=0.13u
XN3_3_7 o3_3_7 o3_2_7 gn3 gn3 sg13_lv_nmos w=0.74u l=0.13u
CL3_3_7 o3_3_7 gn3 2f
VMG4 gn4 0 0
XP4_1_0 o4_1_0 o3_3_0 ph4 ph4 sg13_lv_pmos w=1.12u l=0.13u
XN4_1_0 o4_1_0 o3_3_0 gn4 gn4 sg13_lv_nmos w=0.74u l=0.13u
CL4_1_0 o4_1_0 gn4 2f
XP4_1_1 o4_1_1 o3_3_1 ph4 ph4 sg13_lv_pmos w=1.12u l=0.13u
XN4_1_1 o4_1_1 o3_3_1 gn4 gn4 sg13_lv_nmos w=0.74u l=0.13u
CL4_1_1 o4_1_1 gn4 2f
XP4_1_2 o4_1_2 o3_3_2 ph4 ph4 sg13_lv_pmos w=1.12u l=0.13u
XN4_1_2 o4_1_2 o3_3_2 gn4 gn4 sg13_lv_nmos w=0.74u l=0.13u
CL4_1_2 o4_1_2 gn4 2f
XP4_1_3 o4_1_3 o3_3_3 ph4 ph4 sg13_lv_pmos w=1.12u l=0.13u
XN4_1_3 o4_1_3 o3_3_3 gn4 gn4 sg13_lv_nmos w=0.74u l=0.13u
CL4_1_3 o4_1_3 gn4 2f
XP4_1_4 o4_1_4 o3_3_4 ph4 ph4 sg13_lv_pmos w=1.12u l=0.13u
XN4_1_4 o4_1_4 o3_3_4 gn4 gn4 sg13_lv_nmos w=0.74u l=0.13u
CL4_1_4 o4_1_4 gn4 2f
XP4_1_5 o4_1_5 o3_3_5 ph4 ph4 sg13_lv_pmos w=1.12u l=0.13u
XN4_1_5 o4_1_5 o3_3_5 gn4 gn4 sg13_lv_nmos w=0.74u l=0.13u
CL4_1_5 o4_1_5 gn4 2f
XP4_1_6 o4_1_6 o3_3_6 ph4 ph4 sg13_lv_pmos w=1.12u l=0.13u
XN4_1_6 o4_1_6 o3_3_6 gn4 gn4 sg13_lv_nmos w=0.74u l=0.13u
CL4_1_6 o4_1_6 gn4 2f
XP4_1_7 o4_1_7 o3_3_7 ph4 ph4 sg13_lv_pmos w=1.12u l=0.13u
XN4_1_7 o4_1_7 o3_3_7 gn4 gn4 sg13_lv_nmos w=0.74u l=0.13u
CL4_1_7 o4_1_7 gn4 2f
XP4_2_0 o4_2_0 o4_1_0 ph4 ph4 sg13_lv_pmos w=1.12u l=0.13u
XN4_2_0 o4_2_0 o4_1_0 gn4 gn4 sg13_lv_nmos w=0.74u l=0.13u
CL4_2_0 o4_2_0 gn4 2f
XP4_2_1 o4_2_1 o4_1_1 ph4 ph4 sg13_lv_pmos w=1.12u l=0.13u
XN4_2_1 o4_2_1 o4_1_1 gn4 gn4 sg13_lv_nmos w=0.74u l=0.13u
CL4_2_1 o4_2_1 gn4 2f
XP4_2_2 o4_2_2 o4_1_2 ph4 ph4 sg13_lv_pmos w=1.12u l=0.13u
XN4_2_2 o4_2_2 o4_1_2 gn4 gn4 sg13_lv_nmos w=0.74u l=0.13u
CL4_2_2 o4_2_2 gn4 2f
XP4_2_3 o4_2_3 o4_1_3 ph4 ph4 sg13_lv_pmos w=1.12u l=0.13u
XN4_2_3 o4_2_3 o4_1_3 gn4 gn4 sg13_lv_nmos w=0.74u l=0.13u
CL4_2_3 o4_2_3 gn4 2f
XP4_2_4 o4_2_4 o4_1_4 ph4 ph4 sg13_lv_pmos w=1.12u l=0.13u
XN4_2_4 o4_2_4 o4_1_4 gn4 gn4 sg13_lv_nmos w=0.74u l=0.13u
CL4_2_4 o4_2_4 gn4 2f
XP4_2_5 o4_2_5 o4_1_5 ph4 ph4 sg13_lv_pmos w=1.12u l=0.13u
XN4_2_5 o4_2_5 o4_1_5 gn4 gn4 sg13_lv_nmos w=0.74u l=0.13u
CL4_2_5 o4_2_5 gn4 2f
XP4_2_6 o4_2_6 o4_1_6 ph4 ph4 sg13_lv_pmos w=1.12u l=0.13u
XN4_2_6 o4_2_6 o4_1_6 gn4 gn4 sg13_lv_nmos w=0.74u l=0.13u
CL4_2_6 o4_2_6 gn4 2f
XP4_2_7 o4_2_7 o4_1_7 ph4 ph4 sg13_lv_pmos w=1.12u l=0.13u
XN4_2_7 o4_2_7 o4_1_7 gn4 gn4 sg13_lv_nmos w=0.74u l=0.13u
CL4_2_7 o4_2_7 gn4 2f
XP4_3_0 o4_3_0 o4_2_0 ph4 ph4 sg13_lv_pmos w=1.12u l=0.13u
XN4_3_0 o4_3_0 o4_2_0 gn4 gn4 sg13_lv_nmos w=0.74u l=0.13u
CL4_3_0 o4_3_0 gn4 2f
XP4_3_1 o4_3_1 o4_2_1 ph4 ph4 sg13_lv_pmos w=1.12u l=0.13u
XN4_3_1 o4_3_1 o4_2_1 gn4 gn4 sg13_lv_nmos w=0.74u l=0.13u
CL4_3_1 o4_3_1 gn4 2f
XP4_3_2 o4_3_2 o4_2_2 ph4 ph4 sg13_lv_pmos w=1.12u l=0.13u
XN4_3_2 o4_3_2 o4_2_2 gn4 gn4 sg13_lv_nmos w=0.74u l=0.13u
CL4_3_2 o4_3_2 gn4 2f
XP4_3_3 o4_3_3 o4_2_3 ph4 ph4 sg13_lv_pmos w=1.12u l=0.13u
XN4_3_3 o4_3_3 o4_2_3 gn4 gn4 sg13_lv_nmos w=0.74u l=0.13u
CL4_3_3 o4_3_3 gn4 2f
XP4_3_4 o4_3_4 o4_2_4 ph4 ph4 sg13_lv_pmos w=1.12u l=0.13u
XN4_3_4 o4_3_4 o4_2_4 gn4 gn4 sg13_lv_nmos w=0.74u l=0.13u
CL4_3_4 o4_3_4 gn4 2f
XP4_3_5 o4_3_5 o4_2_5 ph4 ph4 sg13_lv_pmos w=1.12u l=0.13u
XN4_3_5 o4_3_5 o4_2_5 gn4 gn4 sg13_lv_nmos w=0.74u l=0.13u
CL4_3_5 o4_3_5 gn4 2f
XP4_3_6 o4_3_6 o4_2_6 ph4 ph4 sg13_lv_pmos w=1.12u l=0.13u
XN4_3_6 o4_3_6 o4_2_6 gn4 gn4 sg13_lv_nmos w=0.74u l=0.13u
CL4_3_6 o4_3_6 gn4 2f
XP4_3_7 o4_3_7 o4_2_7 ph4 ph4 sg13_lv_pmos w=1.12u l=0.13u
XN4_3_7 o4_3_7 o4_2_7 gn4 gn4 sg13_lv_nmos w=0.74u l=0.13u
CL4_3_7 o4_3_7 gn4 2f
VMG5 gn5 0 0
XP5_1_0 o5_1_0 o4_3_0 ph5 ph5 sg13_lv_pmos w=1.12u l=0.13u
XN5_1_0 o5_1_0 o4_3_0 gn5 gn5 sg13_lv_nmos w=0.74u l=0.13u
CL5_1_0 o5_1_0 gn5 2f
XP5_1_1 o5_1_1 o4_3_1 ph5 ph5 sg13_lv_pmos w=1.12u l=0.13u
XN5_1_1 o5_1_1 o4_3_1 gn5 gn5 sg13_lv_nmos w=0.74u l=0.13u
CL5_1_1 o5_1_1 gn5 2f
XP5_1_2 o5_1_2 o4_3_2 ph5 ph5 sg13_lv_pmos w=1.12u l=0.13u
XN5_1_2 o5_1_2 o4_3_2 gn5 gn5 sg13_lv_nmos w=0.74u l=0.13u
CL5_1_2 o5_1_2 gn5 2f
XP5_1_3 o5_1_3 o4_3_3 ph5 ph5 sg13_lv_pmos w=1.12u l=0.13u
XN5_1_3 o5_1_3 o4_3_3 gn5 gn5 sg13_lv_nmos w=0.74u l=0.13u
CL5_1_3 o5_1_3 gn5 2f
XP5_1_4 o5_1_4 o4_3_4 ph5 ph5 sg13_lv_pmos w=1.12u l=0.13u
XN5_1_4 o5_1_4 o4_3_4 gn5 gn5 sg13_lv_nmos w=0.74u l=0.13u
CL5_1_4 o5_1_4 gn5 2f
XP5_1_5 o5_1_5 o4_3_5 ph5 ph5 sg13_lv_pmos w=1.12u l=0.13u
XN5_1_5 o5_1_5 o4_3_5 gn5 gn5 sg13_lv_nmos w=0.74u l=0.13u
CL5_1_5 o5_1_5 gn5 2f
XP5_1_6 o5_1_6 o4_3_6 ph5 ph5 sg13_lv_pmos w=1.12u l=0.13u
XN5_1_6 o5_1_6 o4_3_6 gn5 gn5 sg13_lv_nmos w=0.74u l=0.13u
CL5_1_6 o5_1_6 gn5 2f
XP5_1_7 o5_1_7 o4_3_7 ph5 ph5 sg13_lv_pmos w=1.12u l=0.13u
XN5_1_7 o5_1_7 o4_3_7 gn5 gn5 sg13_lv_nmos w=0.74u l=0.13u
CL5_1_7 o5_1_7 gn5 2f
XP5_2_0 o5_2_0 o5_1_0 ph5 ph5 sg13_lv_pmos w=1.12u l=0.13u
XN5_2_0 o5_2_0 o5_1_0 gn5 gn5 sg13_lv_nmos w=0.74u l=0.13u
CL5_2_0 o5_2_0 gn5 2f
XP5_2_1 o5_2_1 o5_1_1 ph5 ph5 sg13_lv_pmos w=1.12u l=0.13u
XN5_2_1 o5_2_1 o5_1_1 gn5 gn5 sg13_lv_nmos w=0.74u l=0.13u
CL5_2_1 o5_2_1 gn5 2f
XP5_2_2 o5_2_2 o5_1_2 ph5 ph5 sg13_lv_pmos w=1.12u l=0.13u
XN5_2_2 o5_2_2 o5_1_2 gn5 gn5 sg13_lv_nmos w=0.74u l=0.13u
CL5_2_2 o5_2_2 gn5 2f
XP5_2_3 o5_2_3 o5_1_3 ph5 ph5 sg13_lv_pmos w=1.12u l=0.13u
XN5_2_3 o5_2_3 o5_1_3 gn5 gn5 sg13_lv_nmos w=0.74u l=0.13u
CL5_2_3 o5_2_3 gn5 2f
XP5_2_4 o5_2_4 o5_1_4 ph5 ph5 sg13_lv_pmos w=1.12u l=0.13u
XN5_2_4 o5_2_4 o5_1_4 gn5 gn5 sg13_lv_nmos w=0.74u l=0.13u
CL5_2_4 o5_2_4 gn5 2f
XP5_2_5 o5_2_5 o5_1_5 ph5 ph5 sg13_lv_pmos w=1.12u l=0.13u
XN5_2_5 o5_2_5 o5_1_5 gn5 gn5 sg13_lv_nmos w=0.74u l=0.13u
CL5_2_5 o5_2_5 gn5 2f
XP5_2_6 o5_2_6 o5_1_6 ph5 ph5 sg13_lv_pmos w=1.12u l=0.13u
XN5_2_6 o5_2_6 o5_1_6 gn5 gn5 sg13_lv_nmos w=0.74u l=0.13u
CL5_2_6 o5_2_6 gn5 2f
XP5_2_7 o5_2_7 o5_1_7 ph5 ph5 sg13_lv_pmos w=1.12u l=0.13u
XN5_2_7 o5_2_7 o5_1_7 gn5 gn5 sg13_lv_nmos w=0.74u l=0.13u
CL5_2_7 o5_2_7 gn5 2f
XP5_3_0 o5_3_0 o5_2_0 ph5 ph5 sg13_lv_pmos w=1.12u l=0.13u
XN5_3_0 o5_3_0 o5_2_0 gn5 gn5 sg13_lv_nmos w=0.74u l=0.13u
CL5_3_0 o5_3_0 gn5 2f
XP5_3_1 o5_3_1 o5_2_1 ph5 ph5 sg13_lv_pmos w=1.12u l=0.13u
XN5_3_1 o5_3_1 o5_2_1 gn5 gn5 sg13_lv_nmos w=0.74u l=0.13u
CL5_3_1 o5_3_1 gn5 2f
XP5_3_2 o5_3_2 o5_2_2 ph5 ph5 sg13_lv_pmos w=1.12u l=0.13u
XN5_3_2 o5_3_2 o5_2_2 gn5 gn5 sg13_lv_nmos w=0.74u l=0.13u
CL5_3_2 o5_3_2 gn5 2f
XP5_3_3 o5_3_3 o5_2_3 ph5 ph5 sg13_lv_pmos w=1.12u l=0.13u
XN5_3_3 o5_3_3 o5_2_3 gn5 gn5 sg13_lv_nmos w=0.74u l=0.13u
CL5_3_3 o5_3_3 gn5 2f
XP5_3_4 o5_3_4 o5_2_4 ph5 ph5 sg13_lv_pmos w=1.12u l=0.13u
XN5_3_4 o5_3_4 o5_2_4 gn5 gn5 sg13_lv_nmos w=0.74u l=0.13u
CL5_3_4 o5_3_4 gn5 2f
XP5_3_5 o5_3_5 o5_2_5 ph5 ph5 sg13_lv_pmos w=1.12u l=0.13u
XN5_3_5 o5_3_5 o5_2_5 gn5 gn5 sg13_lv_nmos w=0.74u l=0.13u
CL5_3_5 o5_3_5 gn5 2f
XP5_3_6 o5_3_6 o5_2_6 ph5 ph5 sg13_lv_pmos w=1.12u l=0.13u
XN5_3_6 o5_3_6 o5_2_6 gn5 gn5 sg13_lv_nmos w=0.74u l=0.13u
CL5_3_6 o5_3_6 gn5 2f
XP5_3_7 o5_3_7 o5_2_7 ph5 ph5 sg13_lv_pmos w=1.12u l=0.13u
XN5_3_7 o5_3_7 o5_2_7 gn5 gn5 sg13_lv_nmos w=0.74u l=0.13u
CL5_3_7 o5_3_7 gn5 2f
VMG6 gn6 0 0
XP6_1_0 o6_1_0 o5_3_0 ph6 ph6 sg13_lv_pmos w=1.12u l=0.13u
XN6_1_0 o6_1_0 o5_3_0 gn6 gn6 sg13_lv_nmos w=0.74u l=0.13u
CL6_1_0 o6_1_0 gn6 2f
XP6_1_1 o6_1_1 o5_3_1 ph6 ph6 sg13_lv_pmos w=1.12u l=0.13u
XN6_1_1 o6_1_1 o5_3_1 gn6 gn6 sg13_lv_nmos w=0.74u l=0.13u
CL6_1_1 o6_1_1 gn6 2f
XP6_1_2 o6_1_2 o5_3_2 ph6 ph6 sg13_lv_pmos w=1.12u l=0.13u
XN6_1_2 o6_1_2 o5_3_2 gn6 gn6 sg13_lv_nmos w=0.74u l=0.13u
CL6_1_2 o6_1_2 gn6 2f
XP6_1_3 o6_1_3 o5_3_3 ph6 ph6 sg13_lv_pmos w=1.12u l=0.13u
XN6_1_3 o6_1_3 o5_3_3 gn6 gn6 sg13_lv_nmos w=0.74u l=0.13u
CL6_1_3 o6_1_3 gn6 2f
XP6_1_4 o6_1_4 o5_3_4 ph6 ph6 sg13_lv_pmos w=1.12u l=0.13u
XN6_1_4 o6_1_4 o5_3_4 gn6 gn6 sg13_lv_nmos w=0.74u l=0.13u
CL6_1_4 o6_1_4 gn6 2f
XP6_1_5 o6_1_5 o5_3_5 ph6 ph6 sg13_lv_pmos w=1.12u l=0.13u
XN6_1_5 o6_1_5 o5_3_5 gn6 gn6 sg13_lv_nmos w=0.74u l=0.13u
CL6_1_5 o6_1_5 gn6 2f
XP6_1_6 o6_1_6 o5_3_6 ph6 ph6 sg13_lv_pmos w=1.12u l=0.13u
XN6_1_6 o6_1_6 o5_3_6 gn6 gn6 sg13_lv_nmos w=0.74u l=0.13u
CL6_1_6 o6_1_6 gn6 2f
XP6_1_7 o6_1_7 o5_3_7 ph6 ph6 sg13_lv_pmos w=1.12u l=0.13u
XN6_1_7 o6_1_7 o5_3_7 gn6 gn6 sg13_lv_nmos w=0.74u l=0.13u
CL6_1_7 o6_1_7 gn6 2f
XP6_2_0 o6_2_0 o6_1_0 ph6 ph6 sg13_lv_pmos w=1.12u l=0.13u
XN6_2_0 o6_2_0 o6_1_0 gn6 gn6 sg13_lv_nmos w=0.74u l=0.13u
CL6_2_0 o6_2_0 gn6 2f
XP6_2_1 o6_2_1 o6_1_1 ph6 ph6 sg13_lv_pmos w=1.12u l=0.13u
XN6_2_1 o6_2_1 o6_1_1 gn6 gn6 sg13_lv_nmos w=0.74u l=0.13u
CL6_2_1 o6_2_1 gn6 2f
XP6_2_2 o6_2_2 o6_1_2 ph6 ph6 sg13_lv_pmos w=1.12u l=0.13u
XN6_2_2 o6_2_2 o6_1_2 gn6 gn6 sg13_lv_nmos w=0.74u l=0.13u
CL6_2_2 o6_2_2 gn6 2f
XP6_2_3 o6_2_3 o6_1_3 ph6 ph6 sg13_lv_pmos w=1.12u l=0.13u
XN6_2_3 o6_2_3 o6_1_3 gn6 gn6 sg13_lv_nmos w=0.74u l=0.13u
CL6_2_3 o6_2_3 gn6 2f
XP6_2_4 o6_2_4 o6_1_4 ph6 ph6 sg13_lv_pmos w=1.12u l=0.13u
XN6_2_4 o6_2_4 o6_1_4 gn6 gn6 sg13_lv_nmos w=0.74u l=0.13u
CL6_2_4 o6_2_4 gn6 2f
XP6_2_5 o6_2_5 o6_1_5 ph6 ph6 sg13_lv_pmos w=1.12u l=0.13u
XN6_2_5 o6_2_5 o6_1_5 gn6 gn6 sg13_lv_nmos w=0.74u l=0.13u
CL6_2_5 o6_2_5 gn6 2f
XP6_2_6 o6_2_6 o6_1_6 ph6 ph6 sg13_lv_pmos w=1.12u l=0.13u
XN6_2_6 o6_2_6 o6_1_6 gn6 gn6 sg13_lv_nmos w=0.74u l=0.13u
CL6_2_6 o6_2_6 gn6 2f
XP6_2_7 o6_2_7 o6_1_7 ph6 ph6 sg13_lv_pmos w=1.12u l=0.13u
XN6_2_7 o6_2_7 o6_1_7 gn6 gn6 sg13_lv_nmos w=0.74u l=0.13u
CL6_2_7 o6_2_7 gn6 2f
XP6_3_0 o6_3_0 o6_2_0 ph6 ph6 sg13_lv_pmos w=1.12u l=0.13u
XN6_3_0 o6_3_0 o6_2_0 gn6 gn6 sg13_lv_nmos w=0.74u l=0.13u
CL6_3_0 o6_3_0 gn6 2f
XP6_3_1 o6_3_1 o6_2_1 ph6 ph6 sg13_lv_pmos w=1.12u l=0.13u
XN6_3_1 o6_3_1 o6_2_1 gn6 gn6 sg13_lv_nmos w=0.74u l=0.13u
CL6_3_1 o6_3_1 gn6 2f
XP6_3_2 o6_3_2 o6_2_2 ph6 ph6 sg13_lv_pmos w=1.12u l=0.13u
XN6_3_2 o6_3_2 o6_2_2 gn6 gn6 sg13_lv_nmos w=0.74u l=0.13u
CL6_3_2 o6_3_2 gn6 2f
XP6_3_3 o6_3_3 o6_2_3 ph6 ph6 sg13_lv_pmos w=1.12u l=0.13u
XN6_3_3 o6_3_3 o6_2_3 gn6 gn6 sg13_lv_nmos w=0.74u l=0.13u
CL6_3_3 o6_3_3 gn6 2f
XP6_3_4 o6_3_4 o6_2_4 ph6 ph6 sg13_lv_pmos w=1.12u l=0.13u
XN6_3_4 o6_3_4 o6_2_4 gn6 gn6 sg13_lv_nmos w=0.74u l=0.13u
CL6_3_4 o6_3_4 gn6 2f
XP6_3_5 o6_3_5 o6_2_5 ph6 ph6 sg13_lv_pmos w=1.12u l=0.13u
XN6_3_5 o6_3_5 o6_2_5 gn6 gn6 sg13_lv_nmos w=0.74u l=0.13u
CL6_3_5 o6_3_5 gn6 2f
XP6_3_6 o6_3_6 o6_2_6 ph6 ph6 sg13_lv_pmos w=1.12u l=0.13u
XN6_3_6 o6_3_6 o6_2_6 gn6 gn6 sg13_lv_nmos w=0.74u l=0.13u
CL6_3_6 o6_3_6 gn6 2f
XP6_3_7 o6_3_7 o6_2_7 ph6 ph6 sg13_lv_pmos w=1.12u l=0.13u
XN6_3_7 o6_3_7 o6_2_7 gn6 gn6 sg13_lv_nmos w=0.74u l=0.13u
CL6_3_7 o6_3_7 gn6 2f
CXqph1 xqph1 0 1
BXqph1 0 xqph1 I={ -I(VPH1) }
RXqph1 xqph1 0 0.01
CXeph1 xeph1 0 1
BXeph1 0 xeph1 I={ -V(ph1)*I(VPH1) }
RXeph1 xeph1 0 0.01
CXqg1 xqg1 0 1
BXqg1 0 xqg1 I={ I(VMG1) }
RXqg1 xqg1 0 0.01
CXqph2 xqph2 0 1
BXqph2 0 xqph2 I={ -I(VPH2) }
RXqph2 xqph2 0 0.01
CXeph2 xeph2 0 1
BXeph2 0 xeph2 I={ -V(ph2)*I(VPH2) }
RXeph2 xeph2 0 0.01
CXqg2 xqg2 0 1
BXqg2 0 xqg2 I={ I(VMG2) }
RXqg2 xqg2 0 0.01
CXqph3 xqph3 0 1
BXqph3 0 xqph3 I={ -I(VPH3) }
RXqph3 xqph3 0 0.01
CXeph3 xeph3 0 1
BXeph3 0 xeph3 I={ -V(ph3)*I(VPH3) }
RXeph3 xeph3 0 0.01
CXqg3 xqg3 0 1
BXqg3 0 xqg3 I={ I(VMG3) }
RXqg3 xqg3 0 0.01
CXqph4 xqph4 0 1
BXqph4 0 xqph4 I={ -I(VPH4) }
RXqph4 xqph4 0 0.01
CXeph4 xeph4 0 1
BXeph4 0 xeph4 I={ -V(ph4)*I(VPH4) }
RXeph4 xeph4 0 0.01
CXqg4 xqg4 0 1
BXqg4 0 xqg4 I={ I(VMG4) }
RXqg4 xqg4 0 0.01
CXqph5 xqph5 0 1
BXqph5 0 xqph5 I={ -I(VPH5) }
RXqph5 xqph5 0 0.01
CXeph5 xeph5 0 1
BXeph5 0 xeph5 I={ -V(ph5)*I(VPH5) }
RXeph5 xeph5 0 0.01
CXqg5 xqg5 0 1
BXqg5 0 xqg5 I={ I(VMG5) }
RXqg5 xqg5 0 0.01
CXqph6 xqph6 0 1
BXqph6 0 xqph6 I={ -I(VPH6) }
RXqph6 xqph6 0 0.01
CXeph6 xeph6 0 1
BXeph6 0 xeph6 I={ -V(ph6)*I(VPH6) }
RXeph6 xeph6 0 0.01
CXqg6 xqg6 0 1
BXqg6 0 xqg6 I={ I(VMG6) }
RXqg6 xqg6 0 0.01
.ic V(pA)=0 V(pB)=1.65 V(pC)=1.65 V(vddh)=1.65 V(lin)=0.8 V(lmid)=0.8 V(lx)=0.8 V(lout)=0.8 V(ph1)=0 V(ph2)=1.65 V(ph3)=1.65 V(ph4)=0 V(ph5)=1.65 V(ph6)=1.65
.tran 0.1p 1932p 0 0.25p UIC
.measure tran VRK1W2 FIND V(ph1) AT=691.000000p
.measure tran VK1_1_0W2 FIND V(o1_1_0) AT=691.000000p
.measure tran VK1_1_1W2 FIND V(o1_1_1) AT=691.000000p
.measure tran VK1_1_2W2 FIND V(o1_1_2) AT=691.000000p
.measure tran VK1_1_3W2 FIND V(o1_1_3) AT=691.000000p
.measure tran VK1_1_4W2 FIND V(o1_1_4) AT=691.000000p
.measure tran VK1_1_5W2 FIND V(o1_1_5) AT=691.000000p
.measure tran VK1_1_6W2 FIND V(o1_1_6) AT=691.000000p
.measure tran VK1_1_7W2 FIND V(o1_1_7) AT=691.000000p
.measure tran VK1_2_0W2 FIND V(o1_2_0) AT=691.000000p
.measure tran VK1_2_1W2 FIND V(o1_2_1) AT=691.000000p
.measure tran VK1_2_2W2 FIND V(o1_2_2) AT=691.000000p
.measure tran VK1_2_3W2 FIND V(o1_2_3) AT=691.000000p
.measure tran VK1_2_4W2 FIND V(o1_2_4) AT=691.000000p
.measure tran VK1_2_5W2 FIND V(o1_2_5) AT=691.000000p
.measure tran VK1_2_6W2 FIND V(o1_2_6) AT=691.000000p
.measure tran VK1_2_7W2 FIND V(o1_2_7) AT=691.000000p
.measure tran VK1_3_0W2 FIND V(o1_3_0) AT=691.000000p
.measure tran VK1_3_1W2 FIND V(o1_3_1) AT=691.000000p
.measure tran VK1_3_2W2 FIND V(o1_3_2) AT=691.000000p
.measure tran VK1_3_3W2 FIND V(o1_3_3) AT=691.000000p
.measure tran VK1_3_4W2 FIND V(o1_3_4) AT=691.000000p
.measure tran VK1_3_5W2 FIND V(o1_3_5) AT=691.000000p
.measure tran VK1_3_6W2 FIND V(o1_3_6) AT=691.000000p
.measure tran VK1_3_7W2 FIND V(o1_3_7) AT=691.000000p
.measure tran VRK2W2 FIND V(ph2) AT=783.000000p
.measure tran VK2_1_0W2 FIND V(o2_1_0) AT=783.000000p
.measure tran VK2_1_1W2 FIND V(o2_1_1) AT=783.000000p
.measure tran VK2_1_2W2 FIND V(o2_1_2) AT=783.000000p
.measure tran VK2_1_3W2 FIND V(o2_1_3) AT=783.000000p
.measure tran VK2_1_4W2 FIND V(o2_1_4) AT=783.000000p
.measure tran VK2_1_5W2 FIND V(o2_1_5) AT=783.000000p
.measure tran VK2_1_6W2 FIND V(o2_1_6) AT=783.000000p
.measure tran VK2_1_7W2 FIND V(o2_1_7) AT=783.000000p
.measure tran VK2_2_0W2 FIND V(o2_2_0) AT=783.000000p
.measure tran VK2_2_1W2 FIND V(o2_2_1) AT=783.000000p
.measure tran VK2_2_2W2 FIND V(o2_2_2) AT=783.000000p
.measure tran VK2_2_3W2 FIND V(o2_2_3) AT=783.000000p
.measure tran VK2_2_4W2 FIND V(o2_2_4) AT=783.000000p
.measure tran VK2_2_5W2 FIND V(o2_2_5) AT=783.000000p
.measure tran VK2_2_6W2 FIND V(o2_2_6) AT=783.000000p
.measure tran VK2_2_7W2 FIND V(o2_2_7) AT=783.000000p
.measure tran VK2_3_0W2 FIND V(o2_3_0) AT=783.000000p
.measure tran VK2_3_1W2 FIND V(o2_3_1) AT=783.000000p
.measure tran VK2_3_2W2 FIND V(o2_3_2) AT=783.000000p
.measure tran VK2_3_3W2 FIND V(o2_3_3) AT=783.000000p
.measure tran VK2_3_4W2 FIND V(o2_3_4) AT=783.000000p
.measure tran VK2_3_5W2 FIND V(o2_3_5) AT=783.000000p
.measure tran VK2_3_6W2 FIND V(o2_3_6) AT=783.000000p
.measure tran VK2_3_7W2 FIND V(o2_3_7) AT=783.000000p
.measure tran VRK3W2 FIND V(ph3) AT=875.000000p
.measure tran VK3_1_0W2 FIND V(o3_1_0) AT=875.000000p
.measure tran VK3_1_1W2 FIND V(o3_1_1) AT=875.000000p
.measure tran VK3_1_2W2 FIND V(o3_1_2) AT=875.000000p
.measure tran VK3_1_3W2 FIND V(o3_1_3) AT=875.000000p
.measure tran VK3_1_4W2 FIND V(o3_1_4) AT=875.000000p
.measure tran VK3_1_5W2 FIND V(o3_1_5) AT=875.000000p
.measure tran VK3_1_6W2 FIND V(o3_1_6) AT=875.000000p
.measure tran VK3_1_7W2 FIND V(o3_1_7) AT=875.000000p
.measure tran VK3_2_0W2 FIND V(o3_2_0) AT=875.000000p
.measure tran VK3_2_1W2 FIND V(o3_2_1) AT=875.000000p
.measure tran VK3_2_2W2 FIND V(o3_2_2) AT=875.000000p
.measure tran VK3_2_3W2 FIND V(o3_2_3) AT=875.000000p
.measure tran VK3_2_4W2 FIND V(o3_2_4) AT=875.000000p
.measure tran VK3_2_5W2 FIND V(o3_2_5) AT=875.000000p
.measure tran VK3_2_6W2 FIND V(o3_2_6) AT=875.000000p
.measure tran VK3_2_7W2 FIND V(o3_2_7) AT=875.000000p
.measure tran VK3_3_0W2 FIND V(o3_3_0) AT=875.000000p
.measure tran VK3_3_1W2 FIND V(o3_3_1) AT=875.000000p
.measure tran VK3_3_2W2 FIND V(o3_3_2) AT=875.000000p
.measure tran VK3_3_3W2 FIND V(o3_3_3) AT=875.000000p
.measure tran VK3_3_4W2 FIND V(o3_3_4) AT=875.000000p
.measure tran VK3_3_5W2 FIND V(o3_3_5) AT=875.000000p
.measure tran VK3_3_6W2 FIND V(o3_3_6) AT=875.000000p
.measure tran VK3_3_7W2 FIND V(o3_3_7) AT=875.000000p
.measure tran VRK4W2 FIND V(ph4) AT=967.000000p
.measure tran VK4_1_0W2 FIND V(o4_1_0) AT=967.000000p
.measure tran VK4_1_1W2 FIND V(o4_1_1) AT=967.000000p
.measure tran VK4_1_2W2 FIND V(o4_1_2) AT=967.000000p
.measure tran VK4_1_3W2 FIND V(o4_1_3) AT=967.000000p
.measure tran VK4_1_4W2 FIND V(o4_1_4) AT=967.000000p
.measure tran VK4_1_5W2 FIND V(o4_1_5) AT=967.000000p
.measure tran VK4_1_6W2 FIND V(o4_1_6) AT=967.000000p
.measure tran VK4_1_7W2 FIND V(o4_1_7) AT=967.000000p
.measure tran VK4_2_0W2 FIND V(o4_2_0) AT=967.000000p
.measure tran VK4_2_1W2 FIND V(o4_2_1) AT=967.000000p
.measure tran VK4_2_2W2 FIND V(o4_2_2) AT=967.000000p
.measure tran VK4_2_3W2 FIND V(o4_2_3) AT=967.000000p
.measure tran VK4_2_4W2 FIND V(o4_2_4) AT=967.000000p
.measure tran VK4_2_5W2 FIND V(o4_2_5) AT=967.000000p
.measure tran VK4_2_6W2 FIND V(o4_2_6) AT=967.000000p
.measure tran VK4_2_7W2 FIND V(o4_2_7) AT=967.000000p
.measure tran VK4_3_0W2 FIND V(o4_3_0) AT=967.000000p
.measure tran VK4_3_1W2 FIND V(o4_3_1) AT=967.000000p
.measure tran VK4_3_2W2 FIND V(o4_3_2) AT=967.000000p
.measure tran VK4_3_3W2 FIND V(o4_3_3) AT=967.000000p
.measure tran VK4_3_4W2 FIND V(o4_3_4) AT=967.000000p
.measure tran VK4_3_5W2 FIND V(o4_3_5) AT=967.000000p
.measure tran VK4_3_6W2 FIND V(o4_3_6) AT=967.000000p
.measure tran VK4_3_7W2 FIND V(o4_3_7) AT=967.000000p
.measure tran VRK5W2 FIND V(ph5) AT=1059.000000p
.measure tran VK5_1_0W2 FIND V(o5_1_0) AT=1059.000000p
.measure tran VK5_1_1W2 FIND V(o5_1_1) AT=1059.000000p
.measure tran VK5_1_2W2 FIND V(o5_1_2) AT=1059.000000p
.measure tran VK5_1_3W2 FIND V(o5_1_3) AT=1059.000000p
.measure tran VK5_1_4W2 FIND V(o5_1_4) AT=1059.000000p
.measure tran VK5_1_5W2 FIND V(o5_1_5) AT=1059.000000p
.measure tran VK5_1_6W2 FIND V(o5_1_6) AT=1059.000000p
.measure tran VK5_1_7W2 FIND V(o5_1_7) AT=1059.000000p
.measure tran VK5_2_0W2 FIND V(o5_2_0) AT=1059.000000p
.measure tran VK5_2_1W2 FIND V(o5_2_1) AT=1059.000000p
.measure tran VK5_2_2W2 FIND V(o5_2_2) AT=1059.000000p
.measure tran VK5_2_3W2 FIND V(o5_2_3) AT=1059.000000p
.measure tran VK5_2_4W2 FIND V(o5_2_4) AT=1059.000000p
.measure tran VK5_2_5W2 FIND V(o5_2_5) AT=1059.000000p
.measure tran VK5_2_6W2 FIND V(o5_2_6) AT=1059.000000p
.measure tran VK5_2_7W2 FIND V(o5_2_7) AT=1059.000000p
.measure tran VK5_3_0W2 FIND V(o5_3_0) AT=1059.000000p
.measure tran VK5_3_1W2 FIND V(o5_3_1) AT=1059.000000p
.measure tran VK5_3_2W2 FIND V(o5_3_2) AT=1059.000000p
.measure tran VK5_3_3W2 FIND V(o5_3_3) AT=1059.000000p
.measure tran VK5_3_4W2 FIND V(o5_3_4) AT=1059.000000p
.measure tran VK5_3_5W2 FIND V(o5_3_5) AT=1059.000000p
.measure tran VK5_3_6W2 FIND V(o5_3_6) AT=1059.000000p
.measure tran VK5_3_7W2 FIND V(o5_3_7) AT=1059.000000p
.measure tran VRK6W2 FIND V(ph6) AT=1151.000000p
.measure tran VK6_1_0W2 FIND V(o6_1_0) AT=1151.000000p
.measure tran VK6_1_1W2 FIND V(o6_1_1) AT=1151.000000p
.measure tran VK6_1_2W2 FIND V(o6_1_2) AT=1151.000000p
.measure tran VK6_1_3W2 FIND V(o6_1_3) AT=1151.000000p
.measure tran VK6_1_4W2 FIND V(o6_1_4) AT=1151.000000p
.measure tran VK6_1_5W2 FIND V(o6_1_5) AT=1151.000000p
.measure tran VK6_1_6W2 FIND V(o6_1_6) AT=1151.000000p
.measure tran VK6_1_7W2 FIND V(o6_1_7) AT=1151.000000p
.measure tran VK6_2_0W2 FIND V(o6_2_0) AT=1151.000000p
.measure tran VK6_2_1W2 FIND V(o6_2_1) AT=1151.000000p
.measure tran VK6_2_2W2 FIND V(o6_2_2) AT=1151.000000p
.measure tran VK6_2_3W2 FIND V(o6_2_3) AT=1151.000000p
.measure tran VK6_2_4W2 FIND V(o6_2_4) AT=1151.000000p
.measure tran VK6_2_5W2 FIND V(o6_2_5) AT=1151.000000p
.measure tran VK6_2_6W2 FIND V(o6_2_6) AT=1151.000000p
.measure tran VK6_2_7W2 FIND V(o6_2_7) AT=1151.000000p
.measure tran VK6_3_0W2 FIND V(o6_3_0) AT=1151.000000p
.measure tran VK6_3_1W2 FIND V(o6_3_1) AT=1151.000000p
.measure tran VK6_3_2W2 FIND V(o6_3_2) AT=1151.000000p
.measure tran VK6_3_3W2 FIND V(o6_3_3) AT=1151.000000p
.measure tran VK6_3_4W2 FIND V(o6_3_4) AT=1151.000000p
.measure tran VK6_3_5W2 FIND V(o6_3_5) AT=1151.000000p
.measure tran VK6_3_6W2 FIND V(o6_3_6) AT=1151.000000p
.measure tran VK6_3_7W2 FIND V(o6_3_7) AT=1151.000000p
.measure tran VRK1W3 FIND V(ph1) AT=967.000000p
.measure tran VK1_1_0W3 FIND V(o1_1_0) AT=967.000000p
.measure tran VK1_1_1W3 FIND V(o1_1_1) AT=967.000000p
.measure tran VK1_1_2W3 FIND V(o1_1_2) AT=967.000000p
.measure tran VK1_1_3W3 FIND V(o1_1_3) AT=967.000000p
.measure tran VK1_1_4W3 FIND V(o1_1_4) AT=967.000000p
.measure tran VK1_1_5W3 FIND V(o1_1_5) AT=967.000000p
.measure tran VK1_1_6W3 FIND V(o1_1_6) AT=967.000000p
.measure tran VK1_1_7W3 FIND V(o1_1_7) AT=967.000000p
.measure tran VK1_2_0W3 FIND V(o1_2_0) AT=967.000000p
.measure tran VK1_2_1W3 FIND V(o1_2_1) AT=967.000000p
.measure tran VK1_2_2W3 FIND V(o1_2_2) AT=967.000000p
.measure tran VK1_2_3W3 FIND V(o1_2_3) AT=967.000000p
.measure tran VK1_2_4W3 FIND V(o1_2_4) AT=967.000000p
.measure tran VK1_2_5W3 FIND V(o1_2_5) AT=967.000000p
.measure tran VK1_2_6W3 FIND V(o1_2_6) AT=967.000000p
.measure tran VK1_2_7W3 FIND V(o1_2_7) AT=967.000000p
.measure tran VK1_3_0W3 FIND V(o1_3_0) AT=967.000000p
.measure tran VK1_3_1W3 FIND V(o1_3_1) AT=967.000000p
.measure tran VK1_3_2W3 FIND V(o1_3_2) AT=967.000000p
.measure tran VK1_3_3W3 FIND V(o1_3_3) AT=967.000000p
.measure tran VK1_3_4W3 FIND V(o1_3_4) AT=967.000000p
.measure tran VK1_3_5W3 FIND V(o1_3_5) AT=967.000000p
.measure tran VK1_3_6W3 FIND V(o1_3_6) AT=967.000000p
.measure tran VK1_3_7W3 FIND V(o1_3_7) AT=967.000000p
.measure tran VRK2W3 FIND V(ph2) AT=1059.000000p
.measure tran VK2_1_0W3 FIND V(o2_1_0) AT=1059.000000p
.measure tran VK2_1_1W3 FIND V(o2_1_1) AT=1059.000000p
.measure tran VK2_1_2W3 FIND V(o2_1_2) AT=1059.000000p
.measure tran VK2_1_3W3 FIND V(o2_1_3) AT=1059.000000p
.measure tran VK2_1_4W3 FIND V(o2_1_4) AT=1059.000000p
.measure tran VK2_1_5W3 FIND V(o2_1_5) AT=1059.000000p
.measure tran VK2_1_6W3 FIND V(o2_1_6) AT=1059.000000p
.measure tran VK2_1_7W3 FIND V(o2_1_7) AT=1059.000000p
.measure tran VK2_2_0W3 FIND V(o2_2_0) AT=1059.000000p
.measure tran VK2_2_1W3 FIND V(o2_2_1) AT=1059.000000p
.measure tran VK2_2_2W3 FIND V(o2_2_2) AT=1059.000000p
.measure tran VK2_2_3W3 FIND V(o2_2_3) AT=1059.000000p
.measure tran VK2_2_4W3 FIND V(o2_2_4) AT=1059.000000p
.measure tran VK2_2_5W3 FIND V(o2_2_5) AT=1059.000000p
.measure tran VK2_2_6W3 FIND V(o2_2_6) AT=1059.000000p
.measure tran VK2_2_7W3 FIND V(o2_2_7) AT=1059.000000p
.measure tran VK2_3_0W3 FIND V(o2_3_0) AT=1059.000000p
.measure tran VK2_3_1W3 FIND V(o2_3_1) AT=1059.000000p
.measure tran VK2_3_2W3 FIND V(o2_3_2) AT=1059.000000p
.measure tran VK2_3_3W3 FIND V(o2_3_3) AT=1059.000000p
.measure tran VK2_3_4W3 FIND V(o2_3_4) AT=1059.000000p
.measure tran VK2_3_5W3 FIND V(o2_3_5) AT=1059.000000p
.measure tran VK2_3_6W3 FIND V(o2_3_6) AT=1059.000000p
.measure tran VK2_3_7W3 FIND V(o2_3_7) AT=1059.000000p
.measure tran VRK3W3 FIND V(ph3) AT=1151.000000p
.measure tran VK3_1_0W3 FIND V(o3_1_0) AT=1151.000000p
.measure tran VK3_1_1W3 FIND V(o3_1_1) AT=1151.000000p
.measure tran VK3_1_2W3 FIND V(o3_1_2) AT=1151.000000p
.measure tran VK3_1_3W3 FIND V(o3_1_3) AT=1151.000000p
.measure tran VK3_1_4W3 FIND V(o3_1_4) AT=1151.000000p
.measure tran VK3_1_5W3 FIND V(o3_1_5) AT=1151.000000p
.measure tran VK3_1_6W3 FIND V(o3_1_6) AT=1151.000000p
.measure tran VK3_1_7W3 FIND V(o3_1_7) AT=1151.000000p
.measure tran VK3_2_0W3 FIND V(o3_2_0) AT=1151.000000p
.measure tran VK3_2_1W3 FIND V(o3_2_1) AT=1151.000000p
.measure tran VK3_2_2W3 FIND V(o3_2_2) AT=1151.000000p
.measure tran VK3_2_3W3 FIND V(o3_2_3) AT=1151.000000p
.measure tran VK3_2_4W3 FIND V(o3_2_4) AT=1151.000000p
.measure tran VK3_2_5W3 FIND V(o3_2_5) AT=1151.000000p
.measure tran VK3_2_6W3 FIND V(o3_2_6) AT=1151.000000p
.measure tran VK3_2_7W3 FIND V(o3_2_7) AT=1151.000000p
.measure tran VK3_3_0W3 FIND V(o3_3_0) AT=1151.000000p
.measure tran VK3_3_1W3 FIND V(o3_3_1) AT=1151.000000p
.measure tran VK3_3_2W3 FIND V(o3_3_2) AT=1151.000000p
.measure tran VK3_3_3W3 FIND V(o3_3_3) AT=1151.000000p
.measure tran VK3_3_4W3 FIND V(o3_3_4) AT=1151.000000p
.measure tran VK3_3_5W3 FIND V(o3_3_5) AT=1151.000000p
.measure tran VK3_3_6W3 FIND V(o3_3_6) AT=1151.000000p
.measure tran VK3_3_7W3 FIND V(o3_3_7) AT=1151.000000p
.measure tran VRK4W3 FIND V(ph4) AT=1243.000000p
.measure tran VK4_1_0W3 FIND V(o4_1_0) AT=1243.000000p
.measure tran VK4_1_1W3 FIND V(o4_1_1) AT=1243.000000p
.measure tran VK4_1_2W3 FIND V(o4_1_2) AT=1243.000000p
.measure tran VK4_1_3W3 FIND V(o4_1_3) AT=1243.000000p
.measure tran VK4_1_4W3 FIND V(o4_1_4) AT=1243.000000p
.measure tran VK4_1_5W3 FIND V(o4_1_5) AT=1243.000000p
.measure tran VK4_1_6W3 FIND V(o4_1_6) AT=1243.000000p
.measure tran VK4_1_7W3 FIND V(o4_1_7) AT=1243.000000p
.measure tran VK4_2_0W3 FIND V(o4_2_0) AT=1243.000000p
.measure tran VK4_2_1W3 FIND V(o4_2_1) AT=1243.000000p
.measure tran VK4_2_2W3 FIND V(o4_2_2) AT=1243.000000p
.measure tran VK4_2_3W3 FIND V(o4_2_3) AT=1243.000000p
.measure tran VK4_2_4W3 FIND V(o4_2_4) AT=1243.000000p
.measure tran VK4_2_5W3 FIND V(o4_2_5) AT=1243.000000p
.measure tran VK4_2_6W3 FIND V(o4_2_6) AT=1243.000000p
.measure tran VK4_2_7W3 FIND V(o4_2_7) AT=1243.000000p
.measure tran VK4_3_0W3 FIND V(o4_3_0) AT=1243.000000p
.measure tran VK4_3_1W3 FIND V(o4_3_1) AT=1243.000000p
.measure tran VK4_3_2W3 FIND V(o4_3_2) AT=1243.000000p
.measure tran VK4_3_3W3 FIND V(o4_3_3) AT=1243.000000p
.measure tran VK4_3_4W3 FIND V(o4_3_4) AT=1243.000000p
.measure tran VK4_3_5W3 FIND V(o4_3_5) AT=1243.000000p
.measure tran VK4_3_6W3 FIND V(o4_3_6) AT=1243.000000p
.measure tran VK4_3_7W3 FIND V(o4_3_7) AT=1243.000000p
.measure tran VRK5W3 FIND V(ph5) AT=1335.000000p
.measure tran VK5_1_0W3 FIND V(o5_1_0) AT=1335.000000p
.measure tran VK5_1_1W3 FIND V(o5_1_1) AT=1335.000000p
.measure tran VK5_1_2W3 FIND V(o5_1_2) AT=1335.000000p
.measure tran VK5_1_3W3 FIND V(o5_1_3) AT=1335.000000p
.measure tran VK5_1_4W3 FIND V(o5_1_4) AT=1335.000000p
.measure tran VK5_1_5W3 FIND V(o5_1_5) AT=1335.000000p
.measure tran VK5_1_6W3 FIND V(o5_1_6) AT=1335.000000p
.measure tran VK5_1_7W3 FIND V(o5_1_7) AT=1335.000000p
.measure tran VK5_2_0W3 FIND V(o5_2_0) AT=1335.000000p
.measure tran VK5_2_1W3 FIND V(o5_2_1) AT=1335.000000p
.measure tran VK5_2_2W3 FIND V(o5_2_2) AT=1335.000000p
.measure tran VK5_2_3W3 FIND V(o5_2_3) AT=1335.000000p
.measure tran VK5_2_4W3 FIND V(o5_2_4) AT=1335.000000p
.measure tran VK5_2_5W3 FIND V(o5_2_5) AT=1335.000000p
.measure tran VK5_2_6W3 FIND V(o5_2_6) AT=1335.000000p
.measure tran VK5_2_7W3 FIND V(o5_2_7) AT=1335.000000p
.measure tran VK5_3_0W3 FIND V(o5_3_0) AT=1335.000000p
.measure tran VK5_3_1W3 FIND V(o5_3_1) AT=1335.000000p
.measure tran VK5_3_2W3 FIND V(o5_3_2) AT=1335.000000p
.measure tran VK5_3_3W3 FIND V(o5_3_3) AT=1335.000000p
.measure tran VK5_3_4W3 FIND V(o5_3_4) AT=1335.000000p
.measure tran VK5_3_5W3 FIND V(o5_3_5) AT=1335.000000p
.measure tran VK5_3_6W3 FIND V(o5_3_6) AT=1335.000000p
.measure tran VK5_3_7W3 FIND V(o5_3_7) AT=1335.000000p
.measure tran VRK6W3 FIND V(ph6) AT=1427.000000p
.measure tran VK6_1_0W3 FIND V(o6_1_0) AT=1427.000000p
.measure tran VK6_1_1W3 FIND V(o6_1_1) AT=1427.000000p
.measure tran VK6_1_2W3 FIND V(o6_1_2) AT=1427.000000p
.measure tran VK6_1_3W3 FIND V(o6_1_3) AT=1427.000000p
.measure tran VK6_1_4W3 FIND V(o6_1_4) AT=1427.000000p
.measure tran VK6_1_5W3 FIND V(o6_1_5) AT=1427.000000p
.measure tran VK6_1_6W3 FIND V(o6_1_6) AT=1427.000000p
.measure tran VK6_1_7W3 FIND V(o6_1_7) AT=1427.000000p
.measure tran VK6_2_0W3 FIND V(o6_2_0) AT=1427.000000p
.measure tran VK6_2_1W3 FIND V(o6_2_1) AT=1427.000000p
.measure tran VK6_2_2W3 FIND V(o6_2_2) AT=1427.000000p
.measure tran VK6_2_3W3 FIND V(o6_2_3) AT=1427.000000p
.measure tran VK6_2_4W3 FIND V(o6_2_4) AT=1427.000000p
.measure tran VK6_2_5W3 FIND V(o6_2_5) AT=1427.000000p
.measure tran VK6_2_6W3 FIND V(o6_2_6) AT=1427.000000p
.measure tran VK6_2_7W3 FIND V(o6_2_7) AT=1427.000000p
.measure tran VK6_3_0W3 FIND V(o6_3_0) AT=1427.000000p
.measure tran VK6_3_1W3 FIND V(o6_3_1) AT=1427.000000p
.measure tran VK6_3_2W3 FIND V(o6_3_2) AT=1427.000000p
.measure tran VK6_3_3W3 FIND V(o6_3_3) AT=1427.000000p
.measure tran VK6_3_4W3 FIND V(o6_3_4) AT=1427.000000p
.measure tran VK6_3_5W3 FIND V(o6_3_5) AT=1427.000000p
.measure tran VK6_3_6W3 FIND V(o6_3_6) AT=1427.000000p
.measure tran VK6_3_7W3 FIND V(o6_3_7) AT=1427.000000p
.measure tran VRK1W4 FIND V(ph1) AT=1243.000000p
.measure tran VK1_1_0W4 FIND V(o1_1_0) AT=1243.000000p
.measure tran VK1_1_1W4 FIND V(o1_1_1) AT=1243.000000p
.measure tran VK1_1_2W4 FIND V(o1_1_2) AT=1243.000000p
.measure tran VK1_1_3W4 FIND V(o1_1_3) AT=1243.000000p
.measure tran VK1_1_4W4 FIND V(o1_1_4) AT=1243.000000p
.measure tran VK1_1_5W4 FIND V(o1_1_5) AT=1243.000000p
.measure tran VK1_1_6W4 FIND V(o1_1_6) AT=1243.000000p
.measure tran VK1_1_7W4 FIND V(o1_1_7) AT=1243.000000p
.measure tran VK1_2_0W4 FIND V(o1_2_0) AT=1243.000000p
.measure tran VK1_2_1W4 FIND V(o1_2_1) AT=1243.000000p
.measure tran VK1_2_2W4 FIND V(o1_2_2) AT=1243.000000p
.measure tran VK1_2_3W4 FIND V(o1_2_3) AT=1243.000000p
.measure tran VK1_2_4W4 FIND V(o1_2_4) AT=1243.000000p
.measure tran VK1_2_5W4 FIND V(o1_2_5) AT=1243.000000p
.measure tran VK1_2_6W4 FIND V(o1_2_6) AT=1243.000000p
.measure tran VK1_2_7W4 FIND V(o1_2_7) AT=1243.000000p
.measure tran VK1_3_0W4 FIND V(o1_3_0) AT=1243.000000p
.measure tran VK1_3_1W4 FIND V(o1_3_1) AT=1243.000000p
.measure tran VK1_3_2W4 FIND V(o1_3_2) AT=1243.000000p
.measure tran VK1_3_3W4 FIND V(o1_3_3) AT=1243.000000p
.measure tran VK1_3_4W4 FIND V(o1_3_4) AT=1243.000000p
.measure tran VK1_3_5W4 FIND V(o1_3_5) AT=1243.000000p
.measure tran VK1_3_6W4 FIND V(o1_3_6) AT=1243.000000p
.measure tran VK1_3_7W4 FIND V(o1_3_7) AT=1243.000000p
.measure tran VRK2W4 FIND V(ph2) AT=1335.000000p
.measure tran VK2_1_0W4 FIND V(o2_1_0) AT=1335.000000p
.measure tran VK2_1_1W4 FIND V(o2_1_1) AT=1335.000000p
.measure tran VK2_1_2W4 FIND V(o2_1_2) AT=1335.000000p
.measure tran VK2_1_3W4 FIND V(o2_1_3) AT=1335.000000p
.measure tran VK2_1_4W4 FIND V(o2_1_4) AT=1335.000000p
.measure tran VK2_1_5W4 FIND V(o2_1_5) AT=1335.000000p
.measure tran VK2_1_6W4 FIND V(o2_1_6) AT=1335.000000p
.measure tran VK2_1_7W4 FIND V(o2_1_7) AT=1335.000000p
.measure tran VK2_2_0W4 FIND V(o2_2_0) AT=1335.000000p
.measure tran VK2_2_1W4 FIND V(o2_2_1) AT=1335.000000p
.measure tran VK2_2_2W4 FIND V(o2_2_2) AT=1335.000000p
.measure tran VK2_2_3W4 FIND V(o2_2_3) AT=1335.000000p
.measure tran VK2_2_4W4 FIND V(o2_2_4) AT=1335.000000p
.measure tran VK2_2_5W4 FIND V(o2_2_5) AT=1335.000000p
.measure tran VK2_2_6W4 FIND V(o2_2_6) AT=1335.000000p
.measure tran VK2_2_7W4 FIND V(o2_2_7) AT=1335.000000p
.measure tran VK2_3_0W4 FIND V(o2_3_0) AT=1335.000000p
.measure tran VK2_3_1W4 FIND V(o2_3_1) AT=1335.000000p
.measure tran VK2_3_2W4 FIND V(o2_3_2) AT=1335.000000p
.measure tran VK2_3_3W4 FIND V(o2_3_3) AT=1335.000000p
.measure tran VK2_3_4W4 FIND V(o2_3_4) AT=1335.000000p
.measure tran VK2_3_5W4 FIND V(o2_3_5) AT=1335.000000p
.measure tran VK2_3_6W4 FIND V(o2_3_6) AT=1335.000000p
.measure tran VK2_3_7W4 FIND V(o2_3_7) AT=1335.000000p
.measure tran VRK3W4 FIND V(ph3) AT=1427.000000p
.measure tran VK3_1_0W4 FIND V(o3_1_0) AT=1427.000000p
.measure tran VK3_1_1W4 FIND V(o3_1_1) AT=1427.000000p
.measure tran VK3_1_2W4 FIND V(o3_1_2) AT=1427.000000p
.measure tran VK3_1_3W4 FIND V(o3_1_3) AT=1427.000000p
.measure tran VK3_1_4W4 FIND V(o3_1_4) AT=1427.000000p
.measure tran VK3_1_5W4 FIND V(o3_1_5) AT=1427.000000p
.measure tran VK3_1_6W4 FIND V(o3_1_6) AT=1427.000000p
.measure tran VK3_1_7W4 FIND V(o3_1_7) AT=1427.000000p
.measure tran VK3_2_0W4 FIND V(o3_2_0) AT=1427.000000p
.measure tran VK3_2_1W4 FIND V(o3_2_1) AT=1427.000000p
.measure tran VK3_2_2W4 FIND V(o3_2_2) AT=1427.000000p
.measure tran VK3_2_3W4 FIND V(o3_2_3) AT=1427.000000p
.measure tran VK3_2_4W4 FIND V(o3_2_4) AT=1427.000000p
.measure tran VK3_2_5W4 FIND V(o3_2_5) AT=1427.000000p
.measure tran VK3_2_6W4 FIND V(o3_2_6) AT=1427.000000p
.measure tran VK3_2_7W4 FIND V(o3_2_7) AT=1427.000000p
.measure tran VK3_3_0W4 FIND V(o3_3_0) AT=1427.000000p
.measure tran VK3_3_1W4 FIND V(o3_3_1) AT=1427.000000p
.measure tran VK3_3_2W4 FIND V(o3_3_2) AT=1427.000000p
.measure tran VK3_3_3W4 FIND V(o3_3_3) AT=1427.000000p
.measure tran VK3_3_4W4 FIND V(o3_3_4) AT=1427.000000p
.measure tran VK3_3_5W4 FIND V(o3_3_5) AT=1427.000000p
.measure tran VK3_3_6W4 FIND V(o3_3_6) AT=1427.000000p
.measure tran VK3_3_7W4 FIND V(o3_3_7) AT=1427.000000p
.measure tran VRK4W4 FIND V(ph4) AT=1519.000000p
.measure tran VK4_1_0W4 FIND V(o4_1_0) AT=1519.000000p
.measure tran VK4_1_1W4 FIND V(o4_1_1) AT=1519.000000p
.measure tran VK4_1_2W4 FIND V(o4_1_2) AT=1519.000000p
.measure tran VK4_1_3W4 FIND V(o4_1_3) AT=1519.000000p
.measure tran VK4_1_4W4 FIND V(o4_1_4) AT=1519.000000p
.measure tran VK4_1_5W4 FIND V(o4_1_5) AT=1519.000000p
.measure tran VK4_1_6W4 FIND V(o4_1_6) AT=1519.000000p
.measure tran VK4_1_7W4 FIND V(o4_1_7) AT=1519.000000p
.measure tran VK4_2_0W4 FIND V(o4_2_0) AT=1519.000000p
.measure tran VK4_2_1W4 FIND V(o4_2_1) AT=1519.000000p
.measure tran VK4_2_2W4 FIND V(o4_2_2) AT=1519.000000p
.measure tran VK4_2_3W4 FIND V(o4_2_3) AT=1519.000000p
.measure tran VK4_2_4W4 FIND V(o4_2_4) AT=1519.000000p
.measure tran VK4_2_5W4 FIND V(o4_2_5) AT=1519.000000p
.measure tran VK4_2_6W4 FIND V(o4_2_6) AT=1519.000000p
.measure tran VK4_2_7W4 FIND V(o4_2_7) AT=1519.000000p
.measure tran VK4_3_0W4 FIND V(o4_3_0) AT=1519.000000p
.measure tran VK4_3_1W4 FIND V(o4_3_1) AT=1519.000000p
.measure tran VK4_3_2W4 FIND V(o4_3_2) AT=1519.000000p
.measure tran VK4_3_3W4 FIND V(o4_3_3) AT=1519.000000p
.measure tran VK4_3_4W4 FIND V(o4_3_4) AT=1519.000000p
.measure tran VK4_3_5W4 FIND V(o4_3_5) AT=1519.000000p
.measure tran VK4_3_6W4 FIND V(o4_3_6) AT=1519.000000p
.measure tran VK4_3_7W4 FIND V(o4_3_7) AT=1519.000000p
.measure tran VRK5W4 FIND V(ph5) AT=1611.000000p
.measure tran VK5_1_0W4 FIND V(o5_1_0) AT=1611.000000p
.measure tran VK5_1_1W4 FIND V(o5_1_1) AT=1611.000000p
.measure tran VK5_1_2W4 FIND V(o5_1_2) AT=1611.000000p
.measure tran VK5_1_3W4 FIND V(o5_1_3) AT=1611.000000p
.measure tran VK5_1_4W4 FIND V(o5_1_4) AT=1611.000000p
.measure tran VK5_1_5W4 FIND V(o5_1_5) AT=1611.000000p
.measure tran VK5_1_6W4 FIND V(o5_1_6) AT=1611.000000p
.measure tran VK5_1_7W4 FIND V(o5_1_7) AT=1611.000000p
.measure tran VK5_2_0W4 FIND V(o5_2_0) AT=1611.000000p
.measure tran VK5_2_1W4 FIND V(o5_2_1) AT=1611.000000p
.measure tran VK5_2_2W4 FIND V(o5_2_2) AT=1611.000000p
.measure tran VK5_2_3W4 FIND V(o5_2_3) AT=1611.000000p
.measure tran VK5_2_4W4 FIND V(o5_2_4) AT=1611.000000p
.measure tran VK5_2_5W4 FIND V(o5_2_5) AT=1611.000000p
.measure tran VK5_2_6W4 FIND V(o5_2_6) AT=1611.000000p
.measure tran VK5_2_7W4 FIND V(o5_2_7) AT=1611.000000p
.measure tran VK5_3_0W4 FIND V(o5_3_0) AT=1611.000000p
.measure tran VK5_3_1W4 FIND V(o5_3_1) AT=1611.000000p
.measure tran VK5_3_2W4 FIND V(o5_3_2) AT=1611.000000p
.measure tran VK5_3_3W4 FIND V(o5_3_3) AT=1611.000000p
.measure tran VK5_3_4W4 FIND V(o5_3_4) AT=1611.000000p
.measure tran VK5_3_5W4 FIND V(o5_3_5) AT=1611.000000p
.measure tran VK5_3_6W4 FIND V(o5_3_6) AT=1611.000000p
.measure tran VK5_3_7W4 FIND V(o5_3_7) AT=1611.000000p
.measure tran VRK6W4 FIND V(ph6) AT=1703.000000p
.measure tran VK6_1_0W4 FIND V(o6_1_0) AT=1703.000000p
.measure tran VK6_1_1W4 FIND V(o6_1_1) AT=1703.000000p
.measure tran VK6_1_2W4 FIND V(o6_1_2) AT=1703.000000p
.measure tran VK6_1_3W4 FIND V(o6_1_3) AT=1703.000000p
.measure tran VK6_1_4W4 FIND V(o6_1_4) AT=1703.000000p
.measure tran VK6_1_5W4 FIND V(o6_1_5) AT=1703.000000p
.measure tran VK6_1_6W4 FIND V(o6_1_6) AT=1703.000000p
.measure tran VK6_1_7W4 FIND V(o6_1_7) AT=1703.000000p
.measure tran VK6_2_0W4 FIND V(o6_2_0) AT=1703.000000p
.measure tran VK6_2_1W4 FIND V(o6_2_1) AT=1703.000000p
.measure tran VK6_2_2W4 FIND V(o6_2_2) AT=1703.000000p
.measure tran VK6_2_3W4 FIND V(o6_2_3) AT=1703.000000p
.measure tran VK6_2_4W4 FIND V(o6_2_4) AT=1703.000000p
.measure tran VK6_2_5W4 FIND V(o6_2_5) AT=1703.000000p
.measure tran VK6_2_6W4 FIND V(o6_2_6) AT=1703.000000p
.measure tran VK6_2_7W4 FIND V(o6_2_7) AT=1703.000000p
.measure tran VK6_3_0W4 FIND V(o6_3_0) AT=1703.000000p
.measure tran VK6_3_1W4 FIND V(o6_3_1) AT=1703.000000p
.measure tran VK6_3_2W4 FIND V(o6_3_2) AT=1703.000000p
.measure tran VK6_3_3W4 FIND V(o6_3_3) AT=1703.000000p
.measure tran VK6_3_4W4 FIND V(o6_3_4) AT=1703.000000p
.measure tran VK6_3_5W4 FIND V(o6_3_5) AT=1703.000000p
.measure tran VK6_3_6W4 FIND V(o6_3_6) AT=1703.000000p
.measure tran VK6_3_7W4 FIND V(o6_3_7) AT=1703.000000p
.measure tran QPH1T2 FIND V(xqph1) AT=553.000000p
.measure tran EPH1T2 FIND V(xeph1) AT=553.000000p
.measure tran QPH1R2 FIND V(xqph1) AT=645.000000p
.measure tran EPH1R2 FIND V(xeph1) AT=645.000000p
.measure tran QPH1H2 FIND V(xqph1) AT=737.000000p
.measure tran EPH1H2 FIND V(xeph1) AT=737.000000p
.measure tran QPH1T3 FIND V(xqph1) AT=829.000000p
.measure tran EPH1T3 FIND V(xeph1) AT=829.000000p
.measure tran QPH1R3 FIND V(xqph1) AT=921.000000p
.measure tran EPH1R3 FIND V(xeph1) AT=921.000000p
.measure tran QPH1H3 FIND V(xqph1) AT=1013.000000p
.measure tran EPH1H3 FIND V(xeph1) AT=1013.000000p
.measure tran QPH1T4 FIND V(xqph1) AT=1105.000000p
.measure tran EPH1T4 FIND V(xeph1) AT=1105.000000p
.measure tran QPH1R4 FIND V(xqph1) AT=1197.000000p
.measure tran EPH1R4 FIND V(xeph1) AT=1197.000000p
.measure tran QPH1H4 FIND V(xqph1) AT=1289.000000p
.measure tran EPH1H4 FIND V(xeph1) AT=1289.000000p
.measure tran QPH1T5 FIND V(xqph1) AT=1381.000000p
.measure tran EPH1T5 FIND V(xeph1) AT=1381.000000p
.measure tran QPH2T2 FIND V(xqph2) AT=645.000000p
.measure tran EPH2T2 FIND V(xeph2) AT=645.000000p
.measure tran QPH2R2 FIND V(xqph2) AT=737.000000p
.measure tran EPH2R2 FIND V(xeph2) AT=737.000000p
.measure tran QPH2H2 FIND V(xqph2) AT=829.000000p
.measure tran EPH2H2 FIND V(xeph2) AT=829.000000p
.measure tran QPH2T3 FIND V(xqph2) AT=921.000000p
.measure tran EPH2T3 FIND V(xeph2) AT=921.000000p
.measure tran QPH2R3 FIND V(xqph2) AT=1013.000000p
.measure tran EPH2R3 FIND V(xeph2) AT=1013.000000p
.measure tran QPH2H3 FIND V(xqph2) AT=1105.000000p
.measure tran EPH2H3 FIND V(xeph2) AT=1105.000000p
.measure tran QPH2T4 FIND V(xqph2) AT=1197.000000p
.measure tran EPH2T4 FIND V(xeph2) AT=1197.000000p
.measure tran QPH2R4 FIND V(xqph2) AT=1289.000000p
.measure tran EPH2R4 FIND V(xeph2) AT=1289.000000p
.measure tran QPH2H4 FIND V(xqph2) AT=1381.000000p
.measure tran EPH2H4 FIND V(xeph2) AT=1381.000000p
.measure tran QPH2T5 FIND V(xqph2) AT=1473.000000p
.measure tran EPH2T5 FIND V(xeph2) AT=1473.000000p
.measure tran QPH3T2 FIND V(xqph3) AT=737.000000p
.measure tran EPH3T2 FIND V(xeph3) AT=737.000000p
.measure tran QPH3R2 FIND V(xqph3) AT=829.000000p
.measure tran EPH3R2 FIND V(xeph3) AT=829.000000p
.measure tran QPH3H2 FIND V(xqph3) AT=921.000000p
.measure tran EPH3H2 FIND V(xeph3) AT=921.000000p
.measure tran QPH3T3 FIND V(xqph3) AT=1013.000000p
.measure tran EPH3T3 FIND V(xeph3) AT=1013.000000p
.measure tran QPH3R3 FIND V(xqph3) AT=1105.000000p
.measure tran EPH3R3 FIND V(xeph3) AT=1105.000000p
.measure tran QPH3H3 FIND V(xqph3) AT=1197.000000p
.measure tran EPH3H3 FIND V(xeph3) AT=1197.000000p
.measure tran QPH3T4 FIND V(xqph3) AT=1289.000000p
.measure tran EPH3T4 FIND V(xeph3) AT=1289.000000p
.measure tran QPH3R4 FIND V(xqph3) AT=1381.000000p
.measure tran EPH3R4 FIND V(xeph3) AT=1381.000000p
.measure tran QPH3H4 FIND V(xqph3) AT=1473.000000p
.measure tran EPH3H4 FIND V(xeph3) AT=1473.000000p
.measure tran QPH3T5 FIND V(xqph3) AT=1565.000000p
.measure tran EPH3T5 FIND V(xeph3) AT=1565.000000p
.measure tran QPH4T2 FIND V(xqph4) AT=829.000000p
.measure tran EPH4T2 FIND V(xeph4) AT=829.000000p
.measure tran QPH4R2 FIND V(xqph4) AT=921.000000p
.measure tran EPH4R2 FIND V(xeph4) AT=921.000000p
.measure tran QPH4H2 FIND V(xqph4) AT=1013.000000p
.measure tran EPH4H2 FIND V(xeph4) AT=1013.000000p
.measure tran QPH4T3 FIND V(xqph4) AT=1105.000000p
.measure tran EPH4T3 FIND V(xeph4) AT=1105.000000p
.measure tran QPH4R3 FIND V(xqph4) AT=1197.000000p
.measure tran EPH4R3 FIND V(xeph4) AT=1197.000000p
.measure tran QPH4H3 FIND V(xqph4) AT=1289.000000p
.measure tran EPH4H3 FIND V(xeph4) AT=1289.000000p
.measure tran QPH4T4 FIND V(xqph4) AT=1381.000000p
.measure tran EPH4T4 FIND V(xeph4) AT=1381.000000p
.measure tran QPH4R4 FIND V(xqph4) AT=1473.000000p
.measure tran EPH4R4 FIND V(xeph4) AT=1473.000000p
.measure tran QPH4H4 FIND V(xqph4) AT=1565.000000p
.measure tran EPH4H4 FIND V(xeph4) AT=1565.000000p
.measure tran QPH4T5 FIND V(xqph4) AT=1657.000000p
.measure tran EPH4T5 FIND V(xeph4) AT=1657.000000p
.measure tran QPH5T2 FIND V(xqph5) AT=921.000000p
.measure tran EPH5T2 FIND V(xeph5) AT=921.000000p
.measure tran QPH5R2 FIND V(xqph5) AT=1013.000000p
.measure tran EPH5R2 FIND V(xeph5) AT=1013.000000p
.measure tran QPH5H2 FIND V(xqph5) AT=1105.000000p
.measure tran EPH5H2 FIND V(xeph5) AT=1105.000000p
.measure tran QPH5T3 FIND V(xqph5) AT=1197.000000p
.measure tran EPH5T3 FIND V(xeph5) AT=1197.000000p
.measure tran QPH5R3 FIND V(xqph5) AT=1289.000000p
.measure tran EPH5R3 FIND V(xeph5) AT=1289.000000p
.measure tran QPH5H3 FIND V(xqph5) AT=1381.000000p
.measure tran EPH5H3 FIND V(xeph5) AT=1381.000000p
.measure tran QPH5T4 FIND V(xqph5) AT=1473.000000p
.measure tran EPH5T4 FIND V(xeph5) AT=1473.000000p
.measure tran QPH5R4 FIND V(xqph5) AT=1565.000000p
.measure tran EPH5R4 FIND V(xeph5) AT=1565.000000p
.measure tran QPH5H4 FIND V(xqph5) AT=1657.000000p
.measure tran EPH5H4 FIND V(xeph5) AT=1657.000000p
.measure tran QPH5T5 FIND V(xqph5) AT=1749.000000p
.measure tran EPH5T5 FIND V(xeph5) AT=1749.000000p
.measure tran QPH6T2 FIND V(xqph6) AT=1013.000000p
.measure tran EPH6T2 FIND V(xeph6) AT=1013.000000p
.measure tran QPH6R2 FIND V(xqph6) AT=1105.000000p
.measure tran EPH6R2 FIND V(xeph6) AT=1105.000000p
.measure tran QPH6H2 FIND V(xqph6) AT=1197.000000p
.measure tran EPH6H2 FIND V(xeph6) AT=1197.000000p
.measure tran QPH6T3 FIND V(xqph6) AT=1289.000000p
.measure tran EPH6T3 FIND V(xeph6) AT=1289.000000p
.measure tran QPH6R3 FIND V(xqph6) AT=1381.000000p
.measure tran EPH6R3 FIND V(xeph6) AT=1381.000000p
.measure tran QPH6H3 FIND V(xqph6) AT=1473.000000p
.measure tran EPH6H3 FIND V(xeph6) AT=1473.000000p
.measure tran QPH6T4 FIND V(xqph6) AT=1565.000000p
.measure tran EPH6T4 FIND V(xeph6) AT=1565.000000p
.measure tran QPH6R4 FIND V(xqph6) AT=1657.000000p
.measure tran EPH6R4 FIND V(xeph6) AT=1657.000000p
.measure tran QPH6H4 FIND V(xqph6) AT=1749.000000p
.measure tran EPH6H4 FIND V(xeph6) AT=1749.000000p
.measure tran QPH6T5 FIND V(xqph6) AT=1841.000000p
.measure tran EPH6T5 FIND V(xeph6) AT=1841.000000p
.measure tran IL_T2 FIND I(L1) AT=553.000000p
.measure tran QDD_T2 FIND V(xqdd) AT=553.000000p
.measure tran QZR_T2 FIND V(xqzr) AT=553.000000p
.measure tran ERL_T2 FIND V(xerl) AT=553.000000p
.measure tran ESW_T2 FIND V(xesw) AT=553.000000p
.measure tran IL_T3 FIND I(L1) AT=829.000000p
.measure tran QDD_T3 FIND V(xqdd) AT=829.000000p
.measure tran QZR_T3 FIND V(xqzr) AT=829.000000p
.measure tran ERL_T3 FIND V(xerl) AT=829.000000p
.measure tran ESW_T3 FIND V(xesw) AT=829.000000p
.measure tran IL_T4 FIND I(L1) AT=1105.000000p
.measure tran QDD_T4 FIND V(xqdd) AT=1105.000000p
.measure tran QZR_T4 FIND V(xqzr) AT=1105.000000p
.measure tran ERL_T4 FIND V(xerl) AT=1105.000000p
.measure tran ESW_T4 FIND V(xesw) AT=1105.000000p
.measure tran IL_T5 FIND I(L1) AT=1381.000000p
.measure tran QDD_T5 FIND V(xqdd) AT=1381.000000p
.measure tran QZR_T5 FIND V(xqzr) AT=1381.000000p
.measure tran ERL_T5 FIND V(xerl) AT=1381.000000p
.measure tran ESW_T5 FIND V(xesw) AT=1381.000000p
.print tran V(ph1) V(ph2) V(ph3) V(ph4) V(ph5) V(ph6) V(o1_1_0) V(o1_1_1) V(o1_1_2) V(o1_1_3) V(o1_1_4) V(o1_1_5) V(o1_1_6) V(o1_1_7) V(o1_2_0) V(o1_2_1) V(o1_2_2) V(o1_2_3) V(o1_2_4) V(o1_2_5) V(o1_2_6) V(o1_2_7) V(o1_3_0) V(o1_3_1) V(o1_3_2) V(o1_3_3) V(o1_3_4) V(o1_3_5) V(o1_3_6) V(o1_3_7) V(o2_1_0) V(o2_1_1) V(o2_1_2) V(o2_1_3) V(o2_1_4) V(o2_1_5) V(o2_1_6) V(o2_1_7) V(o2_2_0) V(o2_2_1) V(o2_2_2) V(o2_2_3) V(o2_2_4) V(o2_2_5) V(o2_2_6) V(o2_2_7) V(o2_3_0) V(o2_3_1) V(o2_3_2) V(o2_3_3) V(o2_3_4) V(o2_3_5) V(o2_3_6) V(o2_3_7) V(o3_1_0) V(o3_1_1) V(o3_1_2) V(o3_1_3) V(o3_1_4) V(o3_1_5) V(o3_1_6) V(o3_1_7) V(o3_2_0) V(o3_2_1) V(o3_2_2) V(o3_2_3) V(o3_2_4) V(o3_2_5) V(o3_2_6) V(o3_2_7) V(o3_3_0) V(o3_3_1) V(o3_3_2) V(o3_3_3) V(o3_3_4) V(o3_3_5) V(o3_3_6) V(o3_3_7) V(o4_1_0) V(o4_1_1) V(o4_1_2) V(o4_1_3) V(o4_1_4) V(o4_1_5) V(o4_1_6) V(o4_1_7) V(o4_2_0) V(o4_2_1) V(o4_2_2) V(o4_2_3) V(o4_2_4) V(o4_2_5) V(o4_2_6) V(o4_2_7) V(o4_3_0) V(o4_3_1) V(o4_3_2) V(o4_3_3) V(o4_3_4) V(o4_3_5) V(o4_3_6) V(o4_3_7) V(o5_1_0) V(o5_1_1) V(o5_1_2) V(o5_1_3) V(o5_1_4) V(o5_1_5) V(o5_1_6) V(o5_1_7) V(o5_2_0) V(o5_2_1) V(o5_2_2) V(o5_2_3) V(o5_2_4) V(o5_2_5) V(o5_2_6) V(o5_2_7) V(o5_3_0) V(o5_3_1) V(o5_3_2) V(o5_3_3) V(o5_3_4) V(o5_3_5) V(o5_3_6) V(o5_3_7) V(o6_1_0) V(o6_1_1) V(o6_1_2) V(o6_1_3) V(o6_1_4) V(o6_1_5) V(o6_1_6) V(o6_1_7) V(o6_2_0) V(o6_2_1) V(o6_2_2) V(o6_2_3) V(o6_2_4) V(o6_2_5) V(o6_2_6) V(o6_2_7) V(o6_3_0) V(o6_3_1) V(o6_3_2) V(o6_3_3) V(o6_3_4) V(o6_3_5) V(o6_3_6) V(o6_3_7) I(VPH1) I(VPH2) I(VPH3) I(VPH4) I(VPH5) I(VPH6) I(VMG1) I(VMG2) I(VMG3) I(VMG4) I(VMG5) I(VMG6) I(L1) V(lin) V(lout) I(VDDH) I(VZR) I(VML) V(pA) V(pB) V(pC)
.end
