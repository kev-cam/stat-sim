.hdl "/usr/local/share/xyce/verilog-a/psp103/psp103.va"
.include "/usr/local/src/kestrel/sim/models/sg13g2_psp103_tt.lib"
.include "/usr/local/src/stat-sim/qal/sg13lv_compat.sp"
.OPTIONS TIMEINT METHOD=GEAR RELTOL=1e-6 ABSTOL=1e-15 CHGTOL=1e-17
.param LT=15n RS=10
VHI vhi 0 1.5
VRES vres 0 1.2
CRES1 res1 0 35.979f
XRP1_0a rm1_0 o6_0 vres vres sg13_lv_pmos w=0.15u l=0.13u
XRN1_0a rm1_0 o6_0 0 0 sg13_lv_nmos w=1.48u l=0.13u
CRM1_0 rm1_0 0 2f
XRP1_0b rb1_0 rm1_0 vres vres sg13_lv_pmos w=1.12u l=0.13u
XRN1_0b rb1_0 rm1_0 0 0 sg13_lv_nmos w=0.74u l=0.13u
CRB1_0 rb1_0 0 2f
XRP1_1a rm1_1 o6_1 vres vres sg13_lv_pmos w=0.15u l=0.13u
XRN1_1a rm1_1 o6_1 0 0 sg13_lv_nmos w=1.48u l=0.13u
CRM1_1 rm1_1 0 2f
XRP1_1b rb1_1 rm1_1 vres vres sg13_lv_pmos w=1.12u l=0.13u
XRN1_1b rb1_1 rm1_1 0 0 sg13_lv_nmos w=0.74u l=0.13u
CRB1_1 rb1_1 0 2f
XRP1_2a rm1_2 o6_2 vres vres sg13_lv_pmos w=0.15u l=0.13u
XRN1_2a rm1_2 o6_2 0 0 sg13_lv_nmos w=1.48u l=0.13u
CRM1_2 rm1_2 0 2f
XRP1_2b rb1_2 rm1_2 vres vres sg13_lv_pmos w=1.12u l=0.13u
XRN1_2b rb1_2 rm1_2 0 0 sg13_lv_nmos w=0.74u l=0.13u
CRB1_2 rb1_2 0 2f
XRP1_3a rm1_3 o6_3 vres vres sg13_lv_pmos w=0.15u l=0.13u
XRN1_3a rm1_3 o6_3 0 0 sg13_lv_nmos w=1.48u l=0.13u
CRM1_3 rm1_3 0 2f
XRP1_3b rb1_3 rm1_3 vres vres sg13_lv_pmos w=1.12u l=0.13u
XRN1_3b rb1_3 rm1_3 0 0 sg13_lv_nmos w=0.74u l=0.13u
CRB1_3 rb1_3 0 2f
XRP1_4a rm1_4 o6_4 vres vres sg13_lv_pmos w=0.15u l=0.13u
XRN1_4a rm1_4 o6_4 0 0 sg13_lv_nmos w=1.48u l=0.13u
CRM1_4 rm1_4 0 2f
XRP1_4b rb1_4 rm1_4 vres vres sg13_lv_pmos w=1.12u l=0.13u
XRN1_4b rb1_4 rm1_4 0 0 sg13_lv_nmos w=0.74u l=0.13u
CRB1_4 rb1_4 0 2f
XRP1_5a rm1_5 o6_5 vres vres sg13_lv_pmos w=0.15u l=0.13u
XRN1_5a rm1_5 o6_5 0 0 sg13_lv_nmos w=1.48u l=0.13u
CRM1_5 rm1_5 0 2f
XRP1_5b rb1_5 rm1_5 vres vres sg13_lv_pmos w=1.12u l=0.13u
XRN1_5b rb1_5 rm1_5 0 0 sg13_lv_nmos w=0.74u l=0.13u
CRB1_5 rb1_5 0 2f
XRP1_6a rm1_6 o6_6 vres vres sg13_lv_pmos w=0.15u l=0.13u
XRN1_6a rm1_6 o6_6 0 0 sg13_lv_nmos w=1.48u l=0.13u
CRM1_6 rm1_6 0 2f
XRP1_6b rb1_6 rm1_6 vres vres sg13_lv_pmos w=1.12u l=0.13u
XRN1_6b rb1_6 rm1_6 0 0 sg13_lv_nmos w=0.74u l=0.13u
CRB1_6 rb1_6 0 2f
XRP1_7a rm1_7 o6_7 vres vres sg13_lv_pmos w=0.15u l=0.13u
XRN1_7a rm1_7 o6_7 0 0 sg13_lv_nmos w=1.48u l=0.13u
CRM1_7 rm1_7 0 2f
XRP1_7b rb1_7 rm1_7 vres vres sg13_lv_pmos w=1.12u l=0.13u
XRN1_7b rb1_7 rm1_7 0 0 sg13_lv_nmos w=0.74u l=0.13u
CRB1_7 rb1_7 0 2f
VMG1 gn1 0 0
VI1_0 in1_0 0 1.2
VI1_1 in1_1 0 0
VI1_2 in1_2 0 1.2
VI1_3 in1_3 0 0
VI1_4 in1_4 0 1.2
VI1_5 in1_5 0 0
VI1_6 in1_6 0 1.2
VI1_7 in1_7 0 0
XP1_0 o1_0 in1_0 rail1 rail1 sg13_lv_pmos w=1.12u l=0.13u
XN1_0 o1_0 in1_0 gn1 gn1 sg13_lv_nmos w=0.74u l=0.13u
CL1_0 o1_0 gn1 2f
XP1_1 o1_1 in1_1 rail1 rail1 sg13_lv_pmos w=1.12u l=0.13u
XN1_1 o1_1 in1_1 gn1 gn1 sg13_lv_nmos w=0.74u l=0.13u
CL1_1 o1_1 gn1 2f
XP1_2 o1_2 in1_2 rail1 rail1 sg13_lv_pmos w=1.12u l=0.13u
XN1_2 o1_2 in1_2 gn1 gn1 sg13_lv_nmos w=0.74u l=0.13u
CL1_2 o1_2 gn1 2f
XP1_3 o1_3 in1_3 rail1 rail1 sg13_lv_pmos w=1.12u l=0.13u
XN1_3 o1_3 in1_3 gn1 gn1 sg13_lv_nmos w=0.74u l=0.13u
CL1_3 o1_3 gn1 2f
XP1_4 o1_4 in1_4 rail1 rail1 sg13_lv_pmos w=1.12u l=0.13u
XN1_4 o1_4 in1_4 gn1 gn1 sg13_lv_nmos w=0.74u l=0.13u
CL1_4 o1_4 gn1 2f
XP1_5 o1_5 in1_5 rail1 rail1 sg13_lv_pmos w=1.12u l=0.13u
XN1_5 o1_5 in1_5 gn1 gn1 sg13_lv_nmos w=0.74u l=0.13u
CL1_5 o1_5 gn1 2f
XP1_6 o1_6 in1_6 rail1 rail1 sg13_lv_pmos w=1.12u l=0.13u
XN1_6 o1_6 in1_6 gn1 gn1 sg13_lv_nmos w=0.74u l=0.13u
CL1_6 o1_6 gn1 2f
XP1_7 o1_7 in1_7 rail1 rail1 sg13_lv_pmos w=1.12u l=0.13u
XN1_7 o1_7 in1_7 gn1 gn1 sg13_lv_nmos w=0.74u l=0.13u
CL1_7 o1_7 gn1 2f
VMG2 gn2 0 0
XP2_0 o2_0 o1_0 rail2 rail2 sg13_lv_pmos w=1.12u l=0.13u
XN2_0 o2_0 o1_0 gn2 gn2 sg13_lv_nmos w=0.74u l=0.13u
CL2_0 o2_0 gn2 2f
XP2_1 o2_1 o1_1 rail2 rail2 sg13_lv_pmos w=1.12u l=0.13u
XN2_1 o2_1 o1_1 gn2 gn2 sg13_lv_nmos w=0.74u l=0.13u
CL2_1 o2_1 gn2 2f
XP2_2 o2_2 o1_2 rail2 rail2 sg13_lv_pmos w=1.12u l=0.13u
XN2_2 o2_2 o1_2 gn2 gn2 sg13_lv_nmos w=0.74u l=0.13u
CL2_2 o2_2 gn2 2f
XP2_3 o2_3 o1_3 rail2 rail2 sg13_lv_pmos w=1.12u l=0.13u
XN2_3 o2_3 o1_3 gn2 gn2 sg13_lv_nmos w=0.74u l=0.13u
CL2_3 o2_3 gn2 2f
XP2_4 o2_4 o1_4 rail2 rail2 sg13_lv_pmos w=1.12u l=0.13u
XN2_4 o2_4 o1_4 gn2 gn2 sg13_lv_nmos w=0.74u l=0.13u
CL2_4 o2_4 gn2 2f
XP2_5 o2_5 o1_5 rail2 rail2 sg13_lv_pmos w=1.12u l=0.13u
XN2_5 o2_5 o1_5 gn2 gn2 sg13_lv_nmos w=0.74u l=0.13u
CL2_5 o2_5 gn2 2f
XP2_6 o2_6 o1_6 rail2 rail2 sg13_lv_pmos w=1.12u l=0.13u
XN2_6 o2_6 o1_6 gn2 gn2 sg13_lv_nmos w=0.74u l=0.13u
CL2_6 o2_6 gn2 2f
XP2_7 o2_7 o1_7 rail2 rail2 sg13_lv_pmos w=1.12u l=0.13u
XN2_7 o2_7 o1_7 gn2 gn2 sg13_lv_nmos w=0.74u l=0.13u
CL2_7 o2_7 gn2 2f
VMG3 gn3 0 0
XP3_0 o3_0 o2_0 rail3 rail3 sg13_lv_pmos w=1.12u l=0.13u
XN3_0 o3_0 o2_0 gn3 gn3 sg13_lv_nmos w=0.74u l=0.13u
CL3_0 o3_0 gn3 2f
XP3_1 o3_1 o2_1 rail3 rail3 sg13_lv_pmos w=1.12u l=0.13u
XN3_1 o3_1 o2_1 gn3 gn3 sg13_lv_nmos w=0.74u l=0.13u
CL3_1 o3_1 gn3 2f
XP3_2 o3_2 o2_2 rail3 rail3 sg13_lv_pmos w=1.12u l=0.13u
XN3_2 o3_2 o2_2 gn3 gn3 sg13_lv_nmos w=0.74u l=0.13u
CL3_2 o3_2 gn3 2f
XP3_3 o3_3 o2_3 rail3 rail3 sg13_lv_pmos w=1.12u l=0.13u
XN3_3 o3_3 o2_3 gn3 gn3 sg13_lv_nmos w=0.74u l=0.13u
CL3_3 o3_3 gn3 2f
XP3_4 o3_4 o2_4 rail3 rail3 sg13_lv_pmos w=1.12u l=0.13u
XN3_4 o3_4 o2_4 gn3 gn3 sg13_lv_nmos w=0.74u l=0.13u
CL3_4 o3_4 gn3 2f
XP3_5 o3_5 o2_5 rail3 rail3 sg13_lv_pmos w=1.12u l=0.13u
XN3_5 o3_5 o2_5 gn3 gn3 sg13_lv_nmos w=0.74u l=0.13u
CL3_5 o3_5 gn3 2f
XP3_6 o3_6 o2_6 rail3 rail3 sg13_lv_pmos w=1.12u l=0.13u
XN3_6 o3_6 o2_6 gn3 gn3 sg13_lv_nmos w=0.74u l=0.13u
CL3_6 o3_6 gn3 2f
XP3_7 o3_7 o2_7 rail3 rail3 sg13_lv_pmos w=1.12u l=0.13u
XN3_7 o3_7 o2_7 gn3 gn3 sg13_lv_nmos w=0.74u l=0.13u
CL3_7 o3_7 gn3 2f
VMG4 gn4 0 0
XP4_0 o4_0 o3_0 rail4 rail4 sg13_lv_pmos w=1.12u l=0.13u
XN4_0 o4_0 o3_0 gn4 gn4 sg13_lv_nmos w=0.74u l=0.13u
CL4_0 o4_0 gn4 2f
XP4_1 o4_1 o3_1 rail4 rail4 sg13_lv_pmos w=1.12u l=0.13u
XN4_1 o4_1 o3_1 gn4 gn4 sg13_lv_nmos w=0.74u l=0.13u
CL4_1 o4_1 gn4 2f
XP4_2 o4_2 o3_2 rail4 rail4 sg13_lv_pmos w=1.12u l=0.13u
XN4_2 o4_2 o3_2 gn4 gn4 sg13_lv_nmos w=0.74u l=0.13u
CL4_2 o4_2 gn4 2f
XP4_3 o4_3 o3_3 rail4 rail4 sg13_lv_pmos w=1.12u l=0.13u
XN4_3 o4_3 o3_3 gn4 gn4 sg13_lv_nmos w=0.74u l=0.13u
CL4_3 o4_3 gn4 2f
XP4_4 o4_4 o3_4 rail4 rail4 sg13_lv_pmos w=1.12u l=0.13u
XN4_4 o4_4 o3_4 gn4 gn4 sg13_lv_nmos w=0.74u l=0.13u
CL4_4 o4_4 gn4 2f
XP4_5 o4_5 o3_5 rail4 rail4 sg13_lv_pmos w=1.12u l=0.13u
XN4_5 o4_5 o3_5 gn4 gn4 sg13_lv_nmos w=0.74u l=0.13u
CL4_5 o4_5 gn4 2f
XP4_6 o4_6 o3_6 rail4 rail4 sg13_lv_pmos w=1.12u l=0.13u
XN4_6 o4_6 o3_6 gn4 gn4 sg13_lv_nmos w=0.74u l=0.13u
CL4_6 o4_6 gn4 2f
XP4_7 o4_7 o3_7 rail4 rail4 sg13_lv_pmos w=1.12u l=0.13u
XN4_7 o4_7 o3_7 gn4 gn4 sg13_lv_nmos w=0.74u l=0.13u
CL4_7 o4_7 gn4 2f
VMG5 gn5 0 0
XP5_0 o5_0 o4_0 rail5 rail5 sg13_lv_pmos w=1.12u l=0.13u
XN5_0 o5_0 o4_0 gn5 gn5 sg13_lv_nmos w=0.74u l=0.13u
CL5_0 o5_0 gn5 2f
XP5_1 o5_1 o4_1 rail5 rail5 sg13_lv_pmos w=1.12u l=0.13u
XN5_1 o5_1 o4_1 gn5 gn5 sg13_lv_nmos w=0.74u l=0.13u
CL5_1 o5_1 gn5 2f
XP5_2 o5_2 o4_2 rail5 rail5 sg13_lv_pmos w=1.12u l=0.13u
XN5_2 o5_2 o4_2 gn5 gn5 sg13_lv_nmos w=0.74u l=0.13u
CL5_2 o5_2 gn5 2f
XP5_3 o5_3 o4_3 rail5 rail5 sg13_lv_pmos w=1.12u l=0.13u
XN5_3 o5_3 o4_3 gn5 gn5 sg13_lv_nmos w=0.74u l=0.13u
CL5_3 o5_3 gn5 2f
XP5_4 o5_4 o4_4 rail5 rail5 sg13_lv_pmos w=1.12u l=0.13u
XN5_4 o5_4 o4_4 gn5 gn5 sg13_lv_nmos w=0.74u l=0.13u
CL5_4 o5_4 gn5 2f
XP5_5 o5_5 o4_5 rail5 rail5 sg13_lv_pmos w=1.12u l=0.13u
XN5_5 o5_5 o4_5 gn5 gn5 sg13_lv_nmos w=0.74u l=0.13u
CL5_5 o5_5 gn5 2f
XP5_6 o5_6 o4_6 rail5 rail5 sg13_lv_pmos w=1.12u l=0.13u
XN5_6 o5_6 o4_6 gn5 gn5 sg13_lv_nmos w=0.74u l=0.13u
CL5_6 o5_6 gn5 2f
XP5_7 o5_7 o4_7 rail5 rail5 sg13_lv_pmos w=1.12u l=0.13u
XN5_7 o5_7 o4_7 gn5 gn5 sg13_lv_nmos w=0.74u l=0.13u
CL5_7 o5_7 gn5 2f
VMG6 gn6 0 0
XP6_0 o6_0 o5_0 rail6 rail6 sg13_lv_pmos w=1.12u l=0.13u
XN6_0 o6_0 o5_0 gn6 gn6 sg13_lv_nmos w=0.74u l=0.13u
CL6_0 o6_0 gn6 2f
XP6_1 o6_1 o5_1 rail6 rail6 sg13_lv_pmos w=1.12u l=0.13u
XN6_1 o6_1 o5_1 gn6 gn6 sg13_lv_nmos w=0.74u l=0.13u
CL6_1 o6_1 gn6 2f
XP6_2 o6_2 o5_2 rail6 rail6 sg13_lv_pmos w=1.12u l=0.13u
XN6_2 o6_2 o5_2 gn6 gn6 sg13_lv_nmos w=0.74u l=0.13u
CL6_2 o6_2 gn6 2f
XP6_3 o6_3 o5_3 rail6 rail6 sg13_lv_pmos w=1.12u l=0.13u
XN6_3 o6_3 o5_3 gn6 gn6 sg13_lv_nmos w=0.74u l=0.13u
CL6_3 o6_3 gn6 2f
XP6_4 o6_4 o5_4 rail6 rail6 sg13_lv_pmos w=1.12u l=0.13u
XN6_4 o6_4 o5_4 gn6 gn6 sg13_lv_nmos w=0.74u l=0.13u
CL6_4 o6_4 gn6 2f
XP6_5 o6_5 o5_5 rail6 rail6 sg13_lv_pmos w=1.12u l=0.13u
XN6_5 o6_5 o5_5 gn6 gn6 sg13_lv_nmos w=0.74u l=0.13u
CL6_5 o6_5 gn6 2f
XP6_6 o6_6 o5_6 rail6 rail6 sg13_lv_pmos w=1.12u l=0.13u
XN6_6 o6_6 o5_6 gn6 gn6 sg13_lv_nmos w=0.74u l=0.13u
CL6_6 o6_6 gn6 2f
XP6_7 o6_7 o5_7 rail6 rail6 sg13_lv_pmos w=1.12u l=0.13u
XN6_7 o6_7 o5_7 gn6 gn6 sg13_lv_nmos w=0.74u l=0.13u
CL6_7 o6_7 gn6 2f
L1 res1 mid1 {LT}
R1 mid1 sw1 {RS}
XSWN1 sw1 gt1 rail1 0 sg13_lv_nmos w=10u l=0.13u
XSWP1 sw1 gtp1 rail1 vhi sg13_lv_pmos w=20u l=0.13u
XPK1 sw1 pk1 0 0 sg13_lv_nmos w=2u l=0.13u
L2 a2 mid2 {LT}
R2 mid2 sw2 {RS}
XSWN2 sw2 gt2 rail2 0 sg13_lv_nmos w=10u l=0.13u
XSWP2 sw2 gtp2 rail2 vhi sg13_lv_pmos w=20u l=0.13u
XPK2 sw2 pk2 0 0 sg13_lv_nmos w=2u l=0.13u
XSWSN2 a2 gt2 rail1 0 sg13_lv_nmos w=10u l=0.13u
XSWSP2 a2 gtp2 rail1 vhi sg13_lv_pmos w=20u l=0.13u
L3 a3 mid3 {LT}
R3 mid3 sw3 {RS}
XSWN3 sw3 gt3 rail3 0 sg13_lv_nmos w=10u l=0.13u
XSWP3 sw3 gtp3 rail3 vhi sg13_lv_pmos w=20u l=0.13u
XPK3 sw3 pk3 0 0 sg13_lv_nmos w=2u l=0.13u
XSWSN3 a3 gt3 rail2 0 sg13_lv_nmos w=10u l=0.13u
XSWSP3 a3 gtp3 rail2 vhi sg13_lv_pmos w=20u l=0.13u
L4 a4 mid4 {LT}
R4 mid4 sw4 {RS}
XSWN4 sw4 gt4 rail4 0 sg13_lv_nmos w=10u l=0.13u
XSWP4 sw4 gtp4 rail4 vhi sg13_lv_pmos w=20u l=0.13u
XPK4 sw4 pk4 0 0 sg13_lv_nmos w=2u l=0.13u
XSWSN4 a4 gt4 rail3 0 sg13_lv_nmos w=10u l=0.13u
XSWSP4 a4 gtp4 rail3 vhi sg13_lv_pmos w=20u l=0.13u
L5 a5 mid5 {LT}
R5 mid5 sw5 {RS}
XSWN5 sw5 gt5 rail5 0 sg13_lv_nmos w=10u l=0.13u
XSWP5 sw5 gtp5 rail5 vhi sg13_lv_pmos w=20u l=0.13u
XPK5 sw5 pk5 0 0 sg13_lv_nmos w=2u l=0.13u
XSWSN5 a5 gt5 rail4 0 sg13_lv_nmos w=10u l=0.13u
XSWSP5 a5 gtp5 rail4 vhi sg13_lv_pmos w=20u l=0.13u
L6 a6 mid6 {LT}
R6 mid6 sw6 {RS}
XSWN6 sw6 gt6 rail6 0 sg13_lv_nmos w=10u l=0.13u
XSWP6 sw6 gtp6 rail6 vhi sg13_lv_pmos w=20u l=0.13u
XPK6 sw6 pk6 0 0 sg13_lv_nmos w=2u l=0.13u
XSWSN6 a6 gt6 rail5 0 sg13_lv_nmos w=10u l=0.13u
XSWSP6 a6 gtp6 rail5 vhi sg13_lv_pmos w=20u l=0.13u
VGT1 gt1 0 PWL(0 0 198p 0 200p 1.5 266.695p 1.5 268.695p 0)
VGTP1 gtp1 0 PWL(0 1.5 198p 1.5 200p 0 266.695p 0 268.695p 1.5)
VPK1 pk1 0 PWL(0 0 268.695p 0 270.695p 1.5)
VGT2 gt2 0 PWL(0 0 498p 0 500p 1.5 604.594p 1.5 606.594p 0)
VGTP2 gtp2 0 PWL(0 1.5 498p 1.5 500p 0 604.594p 0 606.594p 1.5)
VPK2 pk2 0 PWL(0 1.5 500p 1.5 502p 0 606.594p 0 608.594p 1.5)
VGT3 gt3 0 PWL(0 0 798p 0 800p 1.5 902.555p 1.5 904.555p 0)
VGTP3 gtp3 0 PWL(0 1.5 798p 1.5 800p 0 902.555p 0 904.555p 1.5)
VPK3 pk3 0 PWL(0 1.5 800p 1.5 802p 0 904.555p 0 906.555p 1.5)
VGT4 gt4 0 PWL(0 0 1098p 0 1100p 1.5 10000p 1.5)
VGTP4 gtp4 0 PWL(0 1.5 1098p 1.5 1100p 0 10000p 0)
VPK4 pk4 0 PWL(0 1.5 1100p 1.5 1102p 0)
VGT5 gt5 0 0
VGTP5 gtp5 0 1.5
VPK5 pk5 0 1.5
VGT6 gt6 0 0
VGTP6 gtp6 0 1.5
VPK6 pk6 0 1.5
.ic V(res1)=1.2 V(rail1)=0 V(rail2)=0 V(rail3)=0 V(rail4)=0 V(rail5)=0 V(rail6)=0 V(a2)=0 V(a3)=0 V(a4)=0 V(a5)=0 V(a6)=0
.tran 0.1p 1259.15p 0 0.0884183p
.print tran I(L1) I(L2) I(L3) I(L4) I(L5) I(L6) V(rail1) V(rail2) V(rail3) V(rail4) V(rail5) V(rail6) V(res1) V(sw1) V(sw2) V(sw3) V(sw4) V(sw5) V(sw6) V(a2) V(a3) V(a4) V(a5) V(a6) V(rm1_0) V(rb1_0) V(rm1_1) V(rb1_1)
.end
