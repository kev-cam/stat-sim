.hdl "/usr/local/share/xyce/verilog-a/psp103/psp103.va"
.include "/usr/local/src/kestrel/sim/models/sg13g2_psp103_tt.lib"
.include "/usr/local/src/stat-sim/qal/sg13lv_compat.sp"
.OPTIONS TIMEINT METHOD=GEAR RELTOL=1e-6 ABSTOL=1e-15 CHGTOL=1e-17
.param LT=60n RS=10
VHI vhi 0 1.5
VDV vdv 0 1
VMG1 gn1 0 0
VI1_0 in1_0 0 1
VI1_1 in1_1 0 0
VI1_2 in1_2 0 1
VI1_3 in1_3 0 0
VI1_4 in1_4 0 1
VI1_5 in1_5 0 0
VI1_6 in1_6 0 1
VI1_7 in1_7 0 0
XP1_0 o1_0 in1_0 rail1 rail1 sg13_lv_pmos w=1.12u l=0.13u
XN1_0 o1_0 in1_0 gn1 gn1 sg13_lv_nmos w=0.74u l=0.13u
CL1_0 o1_0 gn1 2f
XP1_1 o1_1 in1_1 rail1 rail1 sg13_lv_pmos w=1.12u l=0.13u
XN1_1 o1_1 in1_1 gn1 gn1 sg13_lv_nmos w=0.74u l=0.13u
CL1_1 o1_1 gn1 2f
XP1_2 o1_2 in1_2 rail1 rail1 sg13_lv_pmos w=1.12u l=0.13u
XN1_2 o1_2 in1_2 gn1 gn1 sg13_lv_nmos w=0.74u l=0.13u
CL1_2 o1_2 gn1 2f
XP1_3 o1_3 in1_3 rail1 rail1 sg13_lv_pmos w=1.12u l=0.13u
XN1_3 o1_3 in1_3 gn1 gn1 sg13_lv_nmos w=0.74u l=0.13u
CL1_3 o1_3 gn1 2f
XP1_4 o1_4 in1_4 rail1 rail1 sg13_lv_pmos w=1.12u l=0.13u
XN1_4 o1_4 in1_4 gn1 gn1 sg13_lv_nmos w=0.74u l=0.13u
CL1_4 o1_4 gn1 2f
XP1_5 o1_5 in1_5 rail1 rail1 sg13_lv_pmos w=1.12u l=0.13u
XN1_5 o1_5 in1_5 gn1 gn1 sg13_lv_nmos w=0.74u l=0.13u
CL1_5 o1_5 gn1 2f
XP1_6 o1_6 in1_6 rail1 rail1 sg13_lv_pmos w=1.12u l=0.13u
XN1_6 o1_6 in1_6 gn1 gn1 sg13_lv_nmos w=0.74u l=0.13u
CL1_6 o1_6 gn1 2f
XP1_7 o1_7 in1_7 rail1 rail1 sg13_lv_pmos w=1.12u l=0.13u
XN1_7 o1_7 in1_7 gn1 gn1 sg13_lv_nmos w=0.74u l=0.13u
CL1_7 o1_7 gn1 2f
VMG2 gn2 0 0
XP2_0 o2_0 o1_0 rail2 rail2 sg13_lv_pmos w=1.12u l=0.13u
XN2_0 o2_0 o1_0 gn2 gn2 sg13_lv_nmos w=0.74u l=0.13u
CL2_0 o2_0 gn2 2f
XP2_1 o2_1 o1_1 rail2 rail2 sg13_lv_pmos w=1.12u l=0.13u
XN2_1 o2_1 o1_1 gn2 gn2 sg13_lv_nmos w=0.74u l=0.13u
CL2_1 o2_1 gn2 2f
XP2_2 o2_2 o1_2 rail2 rail2 sg13_lv_pmos w=1.12u l=0.13u
XN2_2 o2_2 o1_2 gn2 gn2 sg13_lv_nmos w=0.74u l=0.13u
CL2_2 o2_2 gn2 2f
XP2_3 o2_3 o1_3 rail2 rail2 sg13_lv_pmos w=1.12u l=0.13u
XN2_3 o2_3 o1_3 gn2 gn2 sg13_lv_nmos w=0.74u l=0.13u
CL2_3 o2_3 gn2 2f
XP2_4 o2_4 o1_4 rail2 rail2 sg13_lv_pmos w=1.12u l=0.13u
XN2_4 o2_4 o1_4 gn2 gn2 sg13_lv_nmos w=0.74u l=0.13u
CL2_4 o2_4 gn2 2f
XP2_5 o2_5 o1_5 rail2 rail2 sg13_lv_pmos w=1.12u l=0.13u
XN2_5 o2_5 o1_5 gn2 gn2 sg13_lv_nmos w=0.74u l=0.13u
CL2_5 o2_5 gn2 2f
XP2_6 o2_6 o1_6 rail2 rail2 sg13_lv_pmos w=1.12u l=0.13u
XN2_6 o2_6 o1_6 gn2 gn2 sg13_lv_nmos w=0.74u l=0.13u
CL2_6 o2_6 gn2 2f
XP2_7 o2_7 o1_7 rail2 rail2 sg13_lv_pmos w=1.12u l=0.13u
XN2_7 o2_7 o1_7 gn2 gn2 sg13_lv_nmos w=0.74u l=0.13u
CL2_7 o2_7 gn2 2f
VMG3 gn3 0 0
XP3_0 o3_0 o2_0 rail3 rail3 sg13_lv_pmos w=1.12u l=0.13u
XN3_0 o3_0 o2_0 gn3 gn3 sg13_lv_nmos w=0.74u l=0.13u
CL3_0 o3_0 gn3 2f
XP3_1 o3_1 o2_1 rail3 rail3 sg13_lv_pmos w=1.12u l=0.13u
XN3_1 o3_1 o2_1 gn3 gn3 sg13_lv_nmos w=0.74u l=0.13u
CL3_1 o3_1 gn3 2f
XP3_2 o3_2 o2_2 rail3 rail3 sg13_lv_pmos w=1.12u l=0.13u
XN3_2 o3_2 o2_2 gn3 gn3 sg13_lv_nmos w=0.74u l=0.13u
CL3_2 o3_2 gn3 2f
XP3_3 o3_3 o2_3 rail3 rail3 sg13_lv_pmos w=1.12u l=0.13u
XN3_3 o3_3 o2_3 gn3 gn3 sg13_lv_nmos w=0.74u l=0.13u
CL3_3 o3_3 gn3 2f
XP3_4 o3_4 o2_4 rail3 rail3 sg13_lv_pmos w=1.12u l=0.13u
XN3_4 o3_4 o2_4 gn3 gn3 sg13_lv_nmos w=0.74u l=0.13u
CL3_4 o3_4 gn3 2f
XP3_5 o3_5 o2_5 rail3 rail3 sg13_lv_pmos w=1.12u l=0.13u
XN3_5 o3_5 o2_5 gn3 gn3 sg13_lv_nmos w=0.74u l=0.13u
CL3_5 o3_5 gn3 2f
XP3_6 o3_6 o2_6 rail3 rail3 sg13_lv_pmos w=1.12u l=0.13u
XN3_6 o3_6 o2_6 gn3 gn3 sg13_lv_nmos w=0.74u l=0.13u
CL3_6 o3_6 gn3 2f
XP3_7 o3_7 o2_7 rail3 rail3 sg13_lv_pmos w=1.12u l=0.13u
XN3_7 o3_7 o2_7 gn3 gn3 sg13_lv_nmos w=0.74u l=0.13u
CL3_7 o3_7 gn3 2f
XTUN1 rail1 tun1 vdv 0 sg13_lv_nmos w=1u l=0.13u
XTUP1 rail1 tup1 vdv vhi sg13_lv_pmos w=1.12u l=0.13u
VTUN1 tun1 0 PWL(0 1.5 160p 1.5 180p 0)
VTUP1 tup1 0 PWL(0 0 160p 0 180p 1.5)
XTUN2 rail2 tun2 vdv 0 sg13_lv_nmos w=5u l=0.13u
XTUP2 rail2 tup2 vdv vhi sg13_lv_pmos w=10u l=0.13u
VTUN2 tun2 0 PWL(0 0 374.925p 0 376.925p 1.5 394.925p 1.5 396.925p 0)
VTUP2 tup2 0 PWL(0 1.5 374.925p 1.5 376.925p 0 394.925p 0 396.925p 1.5)
XTUN3 rail3 tun3 vdv 0 sg13_lv_nmos w=5u l=0.13u
XTUP3 rail3 tup3 vdv vhi sg13_lv_pmos w=10u l=0.13u
VTUN3 tun3 0 PWL(0 0 845.247p 0 847.247p 1.5 865.247p 1.5 867.247p 0)
VTUP3 tup3 0 PWL(0 1.5 845.247p 1.5 847.247p 0 865.247p 0 867.247p 1.5)
L1 a1 mid1 {LT}
R1 mid1 sw1 {RS}
XSWN1 sw1 gt1 rail2 0 sg13_lv_nmos w=5u l=0.13u
XSWP1 sw1 gtp1 rail2 vhi sg13_lv_pmos w=10u l=0.13u
XPK1 sw1 pk1 0 0 sg13_lv_nmos w=1u l=0.13u
XSWSN1 a1 gt1 rail1 0 sg13_lv_nmos w=5u l=0.13u
XSWSP1 a1 gtp1 rail1 vhi sg13_lv_pmos w=10u l=0.13u
L2 a2 mid2 {LT}
R2 mid2 sw2 {RS}
XSWN2 sw2 gt2 rail3 0 sg13_lv_nmos w=5u l=0.13u
XSWP2 sw2 gtp2 rail3 vhi sg13_lv_pmos w=10u l=0.13u
XPK2 sw2 pk2 0 0 sg13_lv_nmos w=1u l=0.13u
XSWSN2 a2 gt2 rail2 0 sg13_lv_nmos w=5u l=0.13u
XSWSP2 a2 gtp2 rail2 vhi sg13_lv_pmos w=10u l=0.13u
VGT1 gt1 0 PWL(0 0 198p 0 200p 1.5 370.925p 1.5 372.925p 0)
VGTP1 gtp1 0 PWL(0 1.5 198p 1.5 200p 0 370.925p 0 372.925p 1.5)
VPK1 pk1 0 PWL(0 1.5 200p 1.5 202p 0 372.925p 0 374.925p 1.5)
VGT2 gt2 0 PWL(0 0 668.925p 0 670.925p 1.5 841.247p 1.5 843.247p 0)
VGTP2 gtp2 0 PWL(0 1.5 668.925p 1.5 670.925p 0 841.247p 0 843.247p 1.5)
VPK2 pk2 0 PWL(0 1.5 670.925p 1.5 672.925p 0 843.247p 0 845.247p 1.5)
CXqlt1 xqlt1 0 1
BXqlt1 0 xqlt1 I={ I(L1) }
RXqlt1 xqlt1 0 0.01
CXea1 xea1 0 1
BXea1 0 xea1 I={ V(rail1)*I(L1) }
RXea1 xea1 0 0.01
CXean1 xean1 0 1
BXean1 0 xean1 I={ V(a1)*I(L1) }
RXean1 xean1 0 0.01
CXeb1 xeb1 0 1
BXeb1 0 xeb1 I={ V(rail2)*I(L1) }
RXeb1 xeb1 0 0.01
CXer1 xer1 0 1
BXer1 0 xer1 I={ I(L1)*I(L1)*10 }
RXer1 xer1 0 0.01
CXesw1 xesw1 0 1
BXesw1 0 xesw1 I={ V(sw1)*I(L1) }
RXesw1 xesw1 0 0.01
CXqlt2 xqlt2 0 1
BXqlt2 0 xqlt2 I={ I(L2) }
RXqlt2 xqlt2 0 0.01
CXea2 xea2 0 1
BXea2 0 xea2 I={ V(rail2)*I(L2) }
RXea2 xea2 0 0.01
CXean2 xean2 0 1
BXean2 0 xean2 I={ V(a2)*I(L2) }
RXean2 xean2 0 0.01
CXeb2 xeb2 0 1
BXeb2 0 xeb2 I={ V(rail3)*I(L2) }
RXeb2 xeb2 0 0.01
CXer2 xer2 0 1
BXer2 0 xer2 I={ I(L2)*I(L2)*10 }
RXer2 xer2 0 0.01
CXesw2 xesw2 0 1
BXesw2 0 xesw2 I={ V(sw2)*I(L2) }
RXesw2 xesw2 0 0.01
CXqg1 xqg1 0 1
BXqg1 0 xqg1 I={ I(VMG1) }
RXqg1 xqg1 0 0.01
CXegtu1 xegtu1 0 1
BXegtu1 0 xegtu1 I={ -V(tun1)*I(VTUN1)-V(tup1)*I(VTUP1) }
RXegtu1 xegtu1 0 0.01
CXqg2 xqg2 0 1
BXqg2 0 xqg2 I={ I(VMG2) }
RXqg2 xqg2 0 0.01
CXegtu2 xegtu2 0 1
BXegtu2 0 xegtu2 I={ -V(tun2)*I(VTUN2)-V(tup2)*I(VTUP2) }
RXegtu2 xegtu2 0 0.01
CXqg3 xqg3 0 1
BXqg3 0 xqg3 I={ I(VMG3) }
RXqg3 xqg3 0 0.01
CXegtu3 xegtu3 0 1
BXegtu3 0 xegtu3 I={ -V(tun3)*I(VTUN3)-V(tup3)*I(VTUP3) }
RXegtu3 xegtu3 0 0.01
CXqdv xqdv 0 1
BXqdv 0 xqdv I={ -I(VDV) }
RXqdv xqdv 0 0.01
CXqi1 xqi1 0 1
BXqi1 0 xqi1 I={ -(I(VI1_0)+I(VI1_1)+I(VI1_2)+I(VI1_3)+I(VI1_4)+I(VI1_5)+I(VI1_6)+I(VI1_7)) }
RXqi1 xqi1 0 0.01
CXegt xegt 0 1
BXegt 0 xegt I={ -V(gt1)*I(VGT1)-V(gtp1)*I(VGTP1)-V(pk1)*I(VPK1)-V(gt2)*I(VGT2)-V(gtp2)*I(VGTP2)-V(pk2)*I(VPK2) }
RXegt xegt 0 0.01
.ic V(rail1)=1 V(rail2)=0 V(rail3)=0 V(a1)=0 V(a2)=0
.tran 0.0619858p 1641.25p 0 0.123972p
.measure tran QLT1_Z FIND V(xqlt1) AT=1.500000p
.measure tran QLT1_B1 FIND V(xqlt1) AT=371.925257p
.measure tran QLT1_C1 FIND V(xqlt1) AT=378.925257p
.measure tran QLT1_B2 FIND V(xqlt1) AT=842.246683p
.measure tran QLT1_C2 FIND V(xqlt1) AT=849.246683p
.measure tran QLT1_K1 FIND V(xqlt1) AT=199.000000p
.measure tran QLT1_K2 FIND V(xqlt1) AT=669.925257p
.measure tran QLT1_K3 FIND V(xqlt1) AT=1142.246683p
.measure tran QLT1_D FIND V(xqlt1) AT=1637.246683p
.measure tran EA1_Z FIND V(xea1) AT=1.500000p
.measure tran EA1_B1 FIND V(xea1) AT=371.925257p
.measure tran EA1_C1 FIND V(xea1) AT=378.925257p
.measure tran EA1_B2 FIND V(xea1) AT=842.246683p
.measure tran EA1_C2 FIND V(xea1) AT=849.246683p
.measure tran EA1_K1 FIND V(xea1) AT=199.000000p
.measure tran EA1_K2 FIND V(xea1) AT=669.925257p
.measure tran EA1_K3 FIND V(xea1) AT=1142.246683p
.measure tran EA1_D FIND V(xea1) AT=1637.246683p
.measure tran EAN1_Z FIND V(xean1) AT=1.500000p
.measure tran EAN1_B1 FIND V(xean1) AT=371.925257p
.measure tran EAN1_C1 FIND V(xean1) AT=378.925257p
.measure tran EAN1_B2 FIND V(xean1) AT=842.246683p
.measure tran EAN1_C2 FIND V(xean1) AT=849.246683p
.measure tran EAN1_K1 FIND V(xean1) AT=199.000000p
.measure tran EAN1_K2 FIND V(xean1) AT=669.925257p
.measure tran EAN1_K3 FIND V(xean1) AT=1142.246683p
.measure tran EAN1_D FIND V(xean1) AT=1637.246683p
.measure tran EB1_Z FIND V(xeb1) AT=1.500000p
.measure tran EB1_B1 FIND V(xeb1) AT=371.925257p
.measure tran EB1_C1 FIND V(xeb1) AT=378.925257p
.measure tran EB1_B2 FIND V(xeb1) AT=842.246683p
.measure tran EB1_C2 FIND V(xeb1) AT=849.246683p
.measure tran EB1_K1 FIND V(xeb1) AT=199.000000p
.measure tran EB1_K2 FIND V(xeb1) AT=669.925257p
.measure tran EB1_K3 FIND V(xeb1) AT=1142.246683p
.measure tran EB1_D FIND V(xeb1) AT=1637.246683p
.measure tran ER1_Z FIND V(xer1) AT=1.500000p
.measure tran ER1_B1 FIND V(xer1) AT=371.925257p
.measure tran ER1_C1 FIND V(xer1) AT=378.925257p
.measure tran ER1_B2 FIND V(xer1) AT=842.246683p
.measure tran ER1_C2 FIND V(xer1) AT=849.246683p
.measure tran ER1_K1 FIND V(xer1) AT=199.000000p
.measure tran ER1_K2 FIND V(xer1) AT=669.925257p
.measure tran ER1_K3 FIND V(xer1) AT=1142.246683p
.measure tran ER1_D FIND V(xer1) AT=1637.246683p
.measure tran ESW1_Z FIND V(xesw1) AT=1.500000p
.measure tran ESW1_B1 FIND V(xesw1) AT=371.925257p
.measure tran ESW1_C1 FIND V(xesw1) AT=378.925257p
.measure tran ESW1_B2 FIND V(xesw1) AT=842.246683p
.measure tran ESW1_C2 FIND V(xesw1) AT=849.246683p
.measure tran ESW1_K1 FIND V(xesw1) AT=199.000000p
.measure tran ESW1_K2 FIND V(xesw1) AT=669.925257p
.measure tran ESW1_K3 FIND V(xesw1) AT=1142.246683p
.measure tran ESW1_D FIND V(xesw1) AT=1637.246683p
.measure tran QLT2_Z FIND V(xqlt2) AT=1.500000p
.measure tran QLT2_B1 FIND V(xqlt2) AT=371.925257p
.measure tran QLT2_C1 FIND V(xqlt2) AT=378.925257p
.measure tran QLT2_B2 FIND V(xqlt2) AT=842.246683p
.measure tran QLT2_C2 FIND V(xqlt2) AT=849.246683p
.measure tran QLT2_K1 FIND V(xqlt2) AT=199.000000p
.measure tran QLT2_K2 FIND V(xqlt2) AT=669.925257p
.measure tran QLT2_K3 FIND V(xqlt2) AT=1142.246683p
.measure tran QLT2_D FIND V(xqlt2) AT=1637.246683p
.measure tran EA2_Z FIND V(xea2) AT=1.500000p
.measure tran EA2_B1 FIND V(xea2) AT=371.925257p
.measure tran EA2_C1 FIND V(xea2) AT=378.925257p
.measure tran EA2_B2 FIND V(xea2) AT=842.246683p
.measure tran EA2_C2 FIND V(xea2) AT=849.246683p
.measure tran EA2_K1 FIND V(xea2) AT=199.000000p
.measure tran EA2_K2 FIND V(xea2) AT=669.925257p
.measure tran EA2_K3 FIND V(xea2) AT=1142.246683p
.measure tran EA2_D FIND V(xea2) AT=1637.246683p
.measure tran EAN2_Z FIND V(xean2) AT=1.500000p
.measure tran EAN2_B1 FIND V(xean2) AT=371.925257p
.measure tran EAN2_C1 FIND V(xean2) AT=378.925257p
.measure tran EAN2_B2 FIND V(xean2) AT=842.246683p
.measure tran EAN2_C2 FIND V(xean2) AT=849.246683p
.measure tran EAN2_K1 FIND V(xean2) AT=199.000000p
.measure tran EAN2_K2 FIND V(xean2) AT=669.925257p
.measure tran EAN2_K3 FIND V(xean2) AT=1142.246683p
.measure tran EAN2_D FIND V(xean2) AT=1637.246683p
.measure tran EB2_Z FIND V(xeb2) AT=1.500000p
.measure tran EB2_B1 FIND V(xeb2) AT=371.925257p
.measure tran EB2_C1 FIND V(xeb2) AT=378.925257p
.measure tran EB2_B2 FIND V(xeb2) AT=842.246683p
.measure tran EB2_C2 FIND V(xeb2) AT=849.246683p
.measure tran EB2_K1 FIND V(xeb2) AT=199.000000p
.measure tran EB2_K2 FIND V(xeb2) AT=669.925257p
.measure tran EB2_K3 FIND V(xeb2) AT=1142.246683p
.measure tran EB2_D FIND V(xeb2) AT=1637.246683p
.measure tran ER2_Z FIND V(xer2) AT=1.500000p
.measure tran ER2_B1 FIND V(xer2) AT=371.925257p
.measure tran ER2_C1 FIND V(xer2) AT=378.925257p
.measure tran ER2_B2 FIND V(xer2) AT=842.246683p
.measure tran ER2_C2 FIND V(xer2) AT=849.246683p
.measure tran ER2_K1 FIND V(xer2) AT=199.000000p
.measure tran ER2_K2 FIND V(xer2) AT=669.925257p
.measure tran ER2_K3 FIND V(xer2) AT=1142.246683p
.measure tran ER2_D FIND V(xer2) AT=1637.246683p
.measure tran ESW2_Z FIND V(xesw2) AT=1.500000p
.measure tran ESW2_B1 FIND V(xesw2) AT=371.925257p
.measure tran ESW2_C1 FIND V(xesw2) AT=378.925257p
.measure tran ESW2_B2 FIND V(xesw2) AT=842.246683p
.measure tran ESW2_C2 FIND V(xesw2) AT=849.246683p
.measure tran ESW2_K1 FIND V(xesw2) AT=199.000000p
.measure tran ESW2_K2 FIND V(xesw2) AT=669.925257p
.measure tran ESW2_K3 FIND V(xesw2) AT=1142.246683p
.measure tran ESW2_D FIND V(xesw2) AT=1637.246683p
.measure tran QG1_Z FIND V(xqg1) AT=1.500000p
.measure tran QG1_B1 FIND V(xqg1) AT=371.925257p
.measure tran QG1_C1 FIND V(xqg1) AT=378.925257p
.measure tran QG1_B2 FIND V(xqg1) AT=842.246683p
.measure tran QG1_C2 FIND V(xqg1) AT=849.246683p
.measure tran QG1_K1 FIND V(xqg1) AT=199.000000p
.measure tran QG1_K2 FIND V(xqg1) AT=669.925257p
.measure tran QG1_K3 FIND V(xqg1) AT=1142.246683p
.measure tran QG1_D FIND V(xqg1) AT=1637.246683p
.measure tran EGTU1_Z FIND V(xegtu1) AT=1.500000p
.measure tran EGTU1_B1 FIND V(xegtu1) AT=371.925257p
.measure tran EGTU1_C1 FIND V(xegtu1) AT=378.925257p
.measure tran EGTU1_B2 FIND V(xegtu1) AT=842.246683p
.measure tran EGTU1_C2 FIND V(xegtu1) AT=849.246683p
.measure tran EGTU1_K1 FIND V(xegtu1) AT=199.000000p
.measure tran EGTU1_K2 FIND V(xegtu1) AT=669.925257p
.measure tran EGTU1_K3 FIND V(xegtu1) AT=1142.246683p
.measure tran EGTU1_D FIND V(xegtu1) AT=1637.246683p
.measure tran QG2_Z FIND V(xqg2) AT=1.500000p
.measure tran QG2_B1 FIND V(xqg2) AT=371.925257p
.measure tran QG2_C1 FIND V(xqg2) AT=378.925257p
.measure tran QG2_B2 FIND V(xqg2) AT=842.246683p
.measure tran QG2_C2 FIND V(xqg2) AT=849.246683p
.measure tran QG2_K1 FIND V(xqg2) AT=199.000000p
.measure tran QG2_K2 FIND V(xqg2) AT=669.925257p
.measure tran QG2_K3 FIND V(xqg2) AT=1142.246683p
.measure tran QG2_D FIND V(xqg2) AT=1637.246683p
.measure tran EGTU2_Z FIND V(xegtu2) AT=1.500000p
.measure tran EGTU2_B1 FIND V(xegtu2) AT=371.925257p
.measure tran EGTU2_C1 FIND V(xegtu2) AT=378.925257p
.measure tran EGTU2_B2 FIND V(xegtu2) AT=842.246683p
.measure tran EGTU2_C2 FIND V(xegtu2) AT=849.246683p
.measure tran EGTU2_K1 FIND V(xegtu2) AT=199.000000p
.measure tran EGTU2_K2 FIND V(xegtu2) AT=669.925257p
.measure tran EGTU2_K3 FIND V(xegtu2) AT=1142.246683p
.measure tran EGTU2_D FIND V(xegtu2) AT=1637.246683p
.measure tran QG3_Z FIND V(xqg3) AT=1.500000p
.measure tran QG3_B1 FIND V(xqg3) AT=371.925257p
.measure tran QG3_C1 FIND V(xqg3) AT=378.925257p
.measure tran QG3_B2 FIND V(xqg3) AT=842.246683p
.measure tran QG3_C2 FIND V(xqg3) AT=849.246683p
.measure tran QG3_K1 FIND V(xqg3) AT=199.000000p
.measure tran QG3_K2 FIND V(xqg3) AT=669.925257p
.measure tran QG3_K3 FIND V(xqg3) AT=1142.246683p
.measure tran QG3_D FIND V(xqg3) AT=1637.246683p
.measure tran EGTU3_Z FIND V(xegtu3) AT=1.500000p
.measure tran EGTU3_B1 FIND V(xegtu3) AT=371.925257p
.measure tran EGTU3_C1 FIND V(xegtu3) AT=378.925257p
.measure tran EGTU3_B2 FIND V(xegtu3) AT=842.246683p
.measure tran EGTU3_C2 FIND V(xegtu3) AT=849.246683p
.measure tran EGTU3_K1 FIND V(xegtu3) AT=199.000000p
.measure tran EGTU3_K2 FIND V(xegtu3) AT=669.925257p
.measure tran EGTU3_K3 FIND V(xegtu3) AT=1142.246683p
.measure tran EGTU3_D FIND V(xegtu3) AT=1637.246683p
.measure tran QDV_Z FIND V(xqdv) AT=1.500000p
.measure tran QDV_B1 FIND V(xqdv) AT=371.925257p
.measure tran QDV_C1 FIND V(xqdv) AT=378.925257p
.measure tran QDV_B2 FIND V(xqdv) AT=842.246683p
.measure tran QDV_C2 FIND V(xqdv) AT=849.246683p
.measure tran QDV_K1 FIND V(xqdv) AT=199.000000p
.measure tran QDV_K2 FIND V(xqdv) AT=669.925257p
.measure tran QDV_K3 FIND V(xqdv) AT=1142.246683p
.measure tran QDV_D FIND V(xqdv) AT=1637.246683p
.measure tran QI1_Z FIND V(xqi1) AT=1.500000p
.measure tran QI1_B1 FIND V(xqi1) AT=371.925257p
.measure tran QI1_C1 FIND V(xqi1) AT=378.925257p
.measure tran QI1_B2 FIND V(xqi1) AT=842.246683p
.measure tran QI1_C2 FIND V(xqi1) AT=849.246683p
.measure tran QI1_K1 FIND V(xqi1) AT=199.000000p
.measure tran QI1_K2 FIND V(xqi1) AT=669.925257p
.measure tran QI1_K3 FIND V(xqi1) AT=1142.246683p
.measure tran QI1_D FIND V(xqi1) AT=1637.246683p
.measure tran EGT_Z FIND V(xegt) AT=1.500000p
.measure tran EGT_B1 FIND V(xegt) AT=371.925257p
.measure tran EGT_C1 FIND V(xegt) AT=378.925257p
.measure tran EGT_B2 FIND V(xegt) AT=842.246683p
.measure tran EGT_C2 FIND V(xegt) AT=849.246683p
.measure tran EGT_K1 FIND V(xegt) AT=199.000000p
.measure tran EGT_K2 FIND V(xegt) AT=669.925257p
.measure tran EGT_K3 FIND V(xegt) AT=1142.246683p
.measure tran EGT_D FIND V(xegt) AT=1637.246683p
.measure tran VR1Z FIND V(rail1) AT=1.500000p
.measure tran VR2Z FIND V(rail2) AT=1.500000p
.measure tran VR3Z FIND V(rail3) AT=1.500000p
.measure tran VR1B1 FIND V(rail1) AT=371.925257p
.measure tran VR2B1 FIND V(rail2) AT=371.925257p
.measure tran VR3B1 FIND V(rail3) AT=371.925257p
.measure tran VR1C1 FIND V(rail1) AT=378.925257p
.measure tran VR2C1 FIND V(rail2) AT=378.925257p
.measure tran VR3C1 FIND V(rail3) AT=378.925257p
.measure tran VR1B2 FIND V(rail1) AT=842.246683p
.measure tran VR2B2 FIND V(rail2) AT=842.246683p
.measure tran VR3B2 FIND V(rail3) AT=842.246683p
.measure tran VR1C2 FIND V(rail1) AT=849.246683p
.measure tran VR2C2 FIND V(rail2) AT=849.246683p
.measure tran VR3C2 FIND V(rail3) AT=849.246683p
.measure tran VR1K1 FIND V(rail1) AT=199.000000p
.measure tran VR2K1 FIND V(rail2) AT=199.000000p
.measure tran VR3K1 FIND V(rail3) AT=199.000000p
.measure tran VR1K2 FIND V(rail1) AT=669.925257p
.measure tran VR2K2 FIND V(rail2) AT=669.925257p
.measure tran VR3K2 FIND V(rail3) AT=669.925257p
.measure tran VR1K3 FIND V(rail1) AT=1142.246683p
.measure tran VR2K3 FIND V(rail2) AT=1142.246683p
.measure tran VR3K3 FIND V(rail3) AT=1142.246683p
.measure tran VR1D FIND V(rail1) AT=1637.246683p
.measure tran VR2D FIND V(rail2) AT=1637.246683p
.measure tran VR3D FIND V(rail3) AT=1637.246683p
.measure tran VR1H FIND V(rail1) AT=197.000000p
.measure tran VR2H FIND V(rail2) AT=197.000000p
.measure tran VR3H FIND V(rail3) AT=197.000000p
.measure tran VR1PK MAX V(rail1) FROM=200p TO=1641.25p
.measure tran VR2PK MAX V(rail2) FROM=200p TO=1641.25p
.measure tran VR3PK MAX V(rail3) FROM=200p TO=1641.25p
.measure tran O1_0S FIND V(o1_0) AT=199.000000p
.measure tran O1_0E FIND V(o1_0) AT=1637.246683p
.measure tran O1_1S FIND V(o1_1) AT=199.000000p
.measure tran O1_1E FIND V(o1_1) AT=1637.246683p
.measure tran O1_2S FIND V(o1_2) AT=199.000000p
.measure tran O1_2E FIND V(o1_2) AT=1637.246683p
.measure tran O1_3S FIND V(o1_3) AT=199.000000p
.measure tran O1_3E FIND V(o1_3) AT=1637.246683p
.measure tran O1_4S FIND V(o1_4) AT=199.000000p
.measure tran O1_4E FIND V(o1_4) AT=1637.246683p
.measure tran O1_5S FIND V(o1_5) AT=199.000000p
.measure tran O1_5E FIND V(o1_5) AT=1637.246683p
.measure tran O1_6S FIND V(o1_6) AT=199.000000p
.measure tran O1_6E FIND V(o1_6) AT=1637.246683p
.measure tran O1_7S FIND V(o1_7) AT=199.000000p
.measure tran O1_7E FIND V(o1_7) AT=1637.246683p
.measure tran O2_0S FIND V(o2_0) AT=669.925257p
.measure tran O2_0E FIND V(o2_0) AT=1637.246683p
.measure tran O2_1S FIND V(o2_1) AT=669.925257p
.measure tran O2_1E FIND V(o2_1) AT=1637.246683p
.measure tran O2_2S FIND V(o2_2) AT=669.925257p
.measure tran O2_2E FIND V(o2_2) AT=1637.246683p
.measure tran O2_3S FIND V(o2_3) AT=669.925257p
.measure tran O2_3E FIND V(o2_3) AT=1637.246683p
.measure tran O2_4S FIND V(o2_4) AT=669.925257p
.measure tran O2_4E FIND V(o2_4) AT=1637.246683p
.measure tran O2_5S FIND V(o2_5) AT=669.925257p
.measure tran O2_5E FIND V(o2_5) AT=1637.246683p
.measure tran O2_6S FIND V(o2_6) AT=669.925257p
.measure tran O2_6E FIND V(o2_6) AT=1637.246683p
.measure tran O2_7S FIND V(o2_7) AT=669.925257p
.measure tran O2_7E FIND V(o2_7) AT=1637.246683p
.measure tran O3_0S FIND V(o3_0) AT=1142.246683p
.measure tran O3_0E FIND V(o3_0) AT=1637.246683p
.measure tran O3_1S FIND V(o3_1) AT=1142.246683p
.measure tran O3_1E FIND V(o3_1) AT=1637.246683p
.measure tran O3_2S FIND V(o3_2) AT=1142.246683p
.measure tran O3_2E FIND V(o3_2) AT=1637.246683p
.measure tran O3_3S FIND V(o3_3) AT=1142.246683p
.measure tran O3_3E FIND V(o3_3) AT=1637.246683p
.measure tran O3_4S FIND V(o3_4) AT=1142.246683p
.measure tran O3_4E FIND V(o3_4) AT=1637.246683p
.measure tran O3_5S FIND V(o3_5) AT=1142.246683p
.measure tran O3_5E FIND V(o3_5) AT=1637.246683p
.measure tran O3_6S FIND V(o3_6) AT=1142.246683p
.measure tran O3_6E FIND V(o3_6) AT=1637.246683p
.measure tran O3_7S FIND V(o3_7) AT=1142.246683p
.measure tran O3_7E FIND V(o3_7) AT=1637.246683p
.measure tran IZ1 FIND I(L1) AT=371.925257p
.measure tran IPK1 MAX I(L1) FROM=200p TO=1641.25p
.measure tran IZ2 FIND I(L2) AT=842.246683p
.measure tran IPK2 MAX I(L2) FROM=200p TO=1641.25p
.print tran V(rail1) V(rail2) V(rail3) I(L1) I(L2) V(o1_0) V(o1_1) V(o1_2) V(o1_3) V(o1_4) V(o1_5) V(o1_6) V(o1_7) V(o2_0) V(o2_1) V(o2_2) V(o2_3) V(o2_4) V(o2_5) V(o2_6) V(o2_7) V(o3_0) V(o3_1) V(o3_2) V(o3_3) V(o3_4) V(o3_5) V(o3_6) V(o3_7) V(xea1) V(xean1) V(xer1) V(xesw1) V(xea2) V(xean2) V(xer2) V(xesw2) V(sw1) V(sw2) V(a1) V(a2)
.end
