* SKEPTIC: is the chain failure a SIZING problem? parallel nMOS (no new geometry)
.hdl "/usr/local/share/xyce/verilog-a/psp103/psp103.va"
.include "/usr/local/src/kestrel/sim/models/sg13g2_psp103_tt.lib"
.include "/usr/local/src/stat-sim/qal/sg13lv_compat.sp"
VG vg 0 0.5
VR r 0 0.7433
XP1 o1 vg r r sg13_lv_pmos w=1.12u l=0.13u
XN1_0 o1 vg 0 0 sg13_lv_nmos w=0.74u l=0.13u
XP2 o2 vg r r sg13_lv_pmos w=1.12u l=0.13u
XN2_0 o2 vg 0 0 sg13_lv_nmos w=0.74u l=0.13u
XN2_1 o2 vg 0 0 sg13_lv_nmos w=0.74u l=0.13u
XP4 o4 vg r r sg13_lv_pmos w=1.12u l=0.13u
XN4_0 o4 vg 0 0 sg13_lv_nmos w=0.74u l=0.13u
XN4_1 o4 vg 0 0 sg13_lv_nmos w=0.74u l=0.13u
XN4_2 o4 vg 0 0 sg13_lv_nmos w=0.74u l=0.13u
XN4_3 o4 vg 0 0 sg13_lv_nmos w=0.74u l=0.13u
XP8 o8 vg r r sg13_lv_pmos w=1.12u l=0.13u
XN8_0 o8 vg 0 0 sg13_lv_nmos w=0.74u l=0.13u
XN8_1 o8 vg 0 0 sg13_lv_nmos w=0.74u l=0.13u
XN8_2 o8 vg 0 0 sg13_lv_nmos w=0.74u l=0.13u
XN8_3 o8 vg 0 0 sg13_lv_nmos w=0.74u l=0.13u
XN8_4 o8 vg 0 0 sg13_lv_nmos w=0.74u l=0.13u
XN8_5 o8 vg 0 0 sg13_lv_nmos w=0.74u l=0.13u
XN8_6 o8 vg 0 0 sg13_lv_nmos w=0.74u l=0.13u
XN8_7 o8 vg 0 0 sg13_lv_nmos w=0.74u l=0.13u
XP16 o16 vg r r sg13_lv_pmos w=1.12u l=0.13u
XN16_0 o16 vg 0 0 sg13_lv_nmos w=0.74u l=0.13u
XN16_1 o16 vg 0 0 sg13_lv_nmos w=0.74u l=0.13u
XN16_2 o16 vg 0 0 sg13_lv_nmos w=0.74u l=0.13u
XN16_3 o16 vg 0 0 sg13_lv_nmos w=0.74u l=0.13u
XN16_4 o16 vg 0 0 sg13_lv_nmos w=0.74u l=0.13u
XN16_5 o16 vg 0 0 sg13_lv_nmos w=0.74u l=0.13u
XN16_6 o16 vg 0 0 sg13_lv_nmos w=0.74u l=0.13u
XN16_7 o16 vg 0 0 sg13_lv_nmos w=0.74u l=0.13u
XN16_8 o16 vg 0 0 sg13_lv_nmos w=0.74u l=0.13u
XN16_9 o16 vg 0 0 sg13_lv_nmos w=0.74u l=0.13u
XN16_10 o16 vg 0 0 sg13_lv_nmos w=0.74u l=0.13u
XN16_11 o16 vg 0 0 sg13_lv_nmos w=0.74u l=0.13u
XN16_12 o16 vg 0 0 sg13_lv_nmos w=0.74u l=0.13u
XN16_13 o16 vg 0 0 sg13_lv_nmos w=0.74u l=0.13u
XN16_14 o16 vg 0 0 sg13_lv_nmos w=0.74u l=0.13u
XN16_15 o16 vg 0 0 sg13_lv_nmos w=0.74u l=0.13u
XP32 o32 vg r r sg13_lv_pmos w=1.12u l=0.13u
XN32_0 o32 vg 0 0 sg13_lv_nmos w=0.74u l=0.13u
XN32_1 o32 vg 0 0 sg13_lv_nmos w=0.74u l=0.13u
XN32_2 o32 vg 0 0 sg13_lv_nmos w=0.74u l=0.13u
XN32_3 o32 vg 0 0 sg13_lv_nmos w=0.74u l=0.13u
XN32_4 o32 vg 0 0 sg13_lv_nmos w=0.74u l=0.13u
XN32_5 o32 vg 0 0 sg13_lv_nmos w=0.74u l=0.13u
XN32_6 o32 vg 0 0 sg13_lv_nmos w=0.74u l=0.13u
XN32_7 o32 vg 0 0 sg13_lv_nmos w=0.74u l=0.13u
XN32_8 o32 vg 0 0 sg13_lv_nmos w=0.74u l=0.13u
XN32_9 o32 vg 0 0 sg13_lv_nmos w=0.74u l=0.13u
XN32_10 o32 vg 0 0 sg13_lv_nmos w=0.74u l=0.13u
XN32_11 o32 vg 0 0 sg13_lv_nmos w=0.74u l=0.13u
XN32_12 o32 vg 0 0 sg13_lv_nmos w=0.74u l=0.13u
XN32_13 o32 vg 0 0 sg13_lv_nmos w=0.74u l=0.13u
XN32_14 o32 vg 0 0 sg13_lv_nmos w=0.74u l=0.13u
XN32_15 o32 vg 0 0 sg13_lv_nmos w=0.74u l=0.13u
XN32_16 o32 vg 0 0 sg13_lv_nmos w=0.74u l=0.13u
XN32_17 o32 vg 0 0 sg13_lv_nmos w=0.74u l=0.13u
XN32_18 o32 vg 0 0 sg13_lv_nmos w=0.74u l=0.13u
XN32_19 o32 vg 0 0 sg13_lv_nmos w=0.74u l=0.13u
XN32_20 o32 vg 0 0 sg13_lv_nmos w=0.74u l=0.13u
XN32_21 o32 vg 0 0 sg13_lv_nmos w=0.74u l=0.13u
XN32_22 o32 vg 0 0 sg13_lv_nmos w=0.74u l=0.13u
XN32_23 o32 vg 0 0 sg13_lv_nmos w=0.74u l=0.13u
XN32_24 o32 vg 0 0 sg13_lv_nmos w=0.74u l=0.13u
XN32_25 o32 vg 0 0 sg13_lv_nmos w=0.74u l=0.13u
XN32_26 o32 vg 0 0 sg13_lv_nmos w=0.74u l=0.13u
XN32_27 o32 vg 0 0 sg13_lv_nmos w=0.74u l=0.13u
XN32_28 o32 vg 0 0 sg13_lv_nmos w=0.74u l=0.13u
XN32_29 o32 vg 0 0 sg13_lv_nmos w=0.74u l=0.13u
XN32_30 o32 vg 0 0 sg13_lv_nmos w=0.74u l=0.13u
XN32_31 o32 vg 0 0 sg13_lv_nmos w=0.74u l=0.13u
.dc VG 0.0 0.8 0.01
.print dc V(o1) V(o2) V(o4) V(o8) V(o16) V(o32)
.end
