* th22 C-element: DATA-NULL-DATA energy anchor (real keeper, PSP103/SG13G2)
.hdl "/usr/local/share/xyce/verilog-a/psp103/psp103.va"
.include "/usr/local/src/kestrel/sim/models/sg13g2_psp103_tt.lib"
.include "/usr/local/src/ldx/asic/cells/th22.sp"
.param VDD=1.2
VDD vdd 0 {VDD}
VSS vss 0 0
* A,B: NULL(0) -> DATA(1) at 1n -> NULL(0) at 3n, period 4n (one op = DATA+NULL)
VA a 0 PULSE(0 {VDD} 1n 0.15n 0.15n 1.7n 4n)
VB b 0 PULSE(0 {VDD} 1n 0.15n 0.15n 1.7n 4n)
X1 a b y vdd vss th22
CL y 0 3f
* energy from supply over the 2nd full op (4n..8n), steady:
.tran 2p 12n uic
.measure tran QVDD INTEG I(VDD) from=4n to=8n
.measure tran EVDD PARAM {VDD*QVDD}
.measure tran YMAX MAX V(y) from=4n to=8n
.measure tran YMIN MIN V(y) from=4n to=8n
.end
