* GENERATED by nulex map_ncl_struct.py --target spice -- do not edit.
* Transistor-level SG13G2 realization of the dual-rail NCL netlist (phys binding).
* The enclosing deck must provide, before the top subckt is instantiated:
*   .hdl "<verilog-a>/psp103/psp103.va"          (PSP103 device)
*   .include "<sg13g2_psp103_tt.lib>"             (SG13G2 PSP103 model card)
*   .include "<ldx>/asic/cells/th22.sp"           (C-element)
*   .include "<ldx>/asic/cells/th_gates.sp"       (th12/th23/th33/th34w2)
*   .include "<nulex>/lib/th_cells_sg13g2.sp"     (th13/th14 collectors)
* Each data bit -> two rail nodes <port>_L/_H (or _L_<i>/_H_<i> for a bus).
* Encoding: DATA1=(L=1,H=0)  DATA0=(L=0,H=1)  NULL=(L=0,H=0).
.subckt sha_slice a_L_0 a_H_0 a_L_1 a_H_1 a_L_2 a_H_2 a_L_3 a_H_3 a_L_4 a_H_4 a_L_5 a_H_5 a_L_6 a_H_6 a_L_7 a_H_7 b_L_0 b_H_0 b_L_1 b_H_1 b_L_2 b_H_2 b_L_3 b_H_3 b_L_4 b_H_4 b_L_5 b_H_5 b_L_6 b_H_6 b_L_7 b_H_7 c_L_0 c_H_0 c_L_1 c_H_1 c_L_2 c_H_2 c_L_3 c_H_3 c_L_4 c_H_4 c_L_5 c_H_5 c_L_6 c_H_6 c_L_7 c_H_7 e_L_0 e_H_0 e_L_1 e_H_1 e_L_2 e_H_2 e_L_3 e_H_3 e_L_4 e_H_4 e_L_5 e_H_5 e_L_6 e_H_6 e_L_7 e_H_7 f_L_0 f_H_0 f_L_1 f_H_1 f_L_2 f_H_2 f_L_3 f_H_3 f_L_4 f_H_4 f_L_5 f_H_5 f_L_6 f_H_6 f_L_7 f_H_7 g_L_0 g_H_0 g_L_1 g_H_1 g_L_2 g_H_2 g_L_3 g_H_3 g_L_4 g_H_4 g_L_5 g_H_5 g_L_6 g_H_6 g_L_7 g_H_7 maj_L_0 maj_H_0 maj_L_1 maj_H_1 maj_L_2 maj_H_2 maj_L_3 maj_H_3 maj_L_4 maj_H_4 maj_L_5 maj_H_5 maj_L_6 maj_H_6 maj_L_7 maj_H_7 ch_L_0 ch_H_0 ch_L_1 ch_H_1 ch_L_2 ch_H_2 ch_L_3 ch_H_3 ch_L_4 ch_H_4 ch_L_5 ch_H_5 ch_L_6 ch_H_6 ch_L_7 ch_H_7 sum_L_0 sum_H_0 sum_L_1 sum_H_1 sum_L_2 sum_H_2 sum_L_3 sum_H_3 sum_L_4 sum_H_4 sum_L_5 sum_H_5 sum_L_6 sum_H_6 sum_L_7 sum_H_7 VDD VSS
X1 a_L_6 c_L_6 n74_L VDD VSS th22
X2 a_L_6 c_H_6 m0_m10 VDD VSS th22
X3 a_H_6 c_L_6 m0_m01 VDD VSS th22
X4 a_H_6 c_H_6 m0_m00 VDD VSS th22
X6 m0_m10 m0_m01 m0_m00 n74_H VDD VSS th13
X7 a_L_7 c_L_7 n75_L VDD VSS th22
X8 a_L_7 c_H_7 m1_m10 VDD VSS th22
X9 a_H_7 c_L_7 m1_m01 VDD VSS th22
X10 a_H_7 c_H_7 m1_m00 VDD VSS th22
X12 m1_m10 m1_m01 m1_m00 n75_H VDD VSS th13
X13 n76_L n77_L m2_m11 VDD VSS th22
X14 n76_L n77_H m2_m10 VDD VSS th22
X15 n76_H n77_L m2_m01 VDD VSS th22
X16 n76_H n77_H m2_m00 VDD VSS th22
X17 m2_m10 m2_m01 n78_L VDD VSS th12
X18 m2_m11 m2_m00 n78_H VDD VSS th12
X19 n79_L n80_L m3_m11 VDD VSS th22
X20 n79_L n80_H m3_m10 VDD VSS th22
X21 n79_H n80_L m3_m01 VDD VSS th22
X22 n79_H n80_H m3_m00 VDD VSS th22
X23 m3_m10 m3_m01 n81_L VDD VSS th12
X24 m3_m11 m3_m00 n81_H VDD VSS th12
X25 n82_L n83_L m4_m11 VDD VSS th22
X26 n82_L n83_H m4_m10 VDD VSS th22
X27 n82_H n83_L m4_m01 VDD VSS th22
X28 n82_H n83_H m4_m00 VDD VSS th22
X29 m4_m10 m4_m01 n84_L VDD VSS th12
X30 m4_m11 m4_m00 n84_H VDD VSS th12
X31 n85_L n86_L m5_m11 VDD VSS th22
X32 n85_L n86_H m5_m10 VDD VSS th22
X33 n85_H n86_L m5_m01 VDD VSS th22
X34 n85_H n86_H m5_m00 VDD VSS th22
X35 m5_m10 m5_m01 n87_L VDD VSS th12
X36 m5_m11 m5_m00 n87_H VDD VSS th12
X37 n88_L n89_L m6_m11 VDD VSS th22
X38 n88_L n89_H m6_m10 VDD VSS th22
X39 n88_H n89_L m6_m01 VDD VSS th22
X40 n88_H n89_H m6_m00 VDD VSS th22
X41 m6_m10 m6_m01 n90_L VDD VSS th12
X42 m6_m11 m6_m00 n90_H VDD VSS th12
X43 n91_L n92_L m7_m11 VDD VSS th22
X44 n91_L n92_H m7_m10 VDD VSS th22
X45 n91_H n92_L m7_m01 VDD VSS th22
X46 n91_H n92_H m7_m00 VDD VSS th22
X47 m7_m10 m7_m01 n93_L VDD VSS th12
X48 m7_m11 m7_m00 n93_H VDD VSS th12
X49 n94_L n74_L m8_m11 VDD VSS th22
X50 n94_L n74_H m8_m10 VDD VSS th22
X51 n94_H n74_L m8_m01 VDD VSS th22
X52 n94_H n74_H m8_m00 VDD VSS th22
X53 m8_m10 m8_m01 n95_L VDD VSS th12
X54 m8_m11 m8_m00 n95_H VDD VSS th12
X55 n96_L n75_L m9_m11 VDD VSS th22
X56 n96_L n75_H m9_m10 VDD VSS th22
X57 n96_H n75_L m9_m01 VDD VSS th22
X58 n96_H n75_H m9_m00 VDD VSS th22
X59 m9_m10 m9_m01 n97_L VDD VSS th12
X60 m9_m11 m9_m00 n97_H VDD VSS th12
X61 b_L_0 c_L_0 n98_L VDD VSS th22
X62 b_L_0 c_H_0 m10_m10 VDD VSS th22
X63 b_H_0 c_L_0 m10_m01 VDD VSS th22
X64 b_H_0 c_H_0 m10_m00 VDD VSS th22
X66 m10_m10 m10_m01 m10_m00 n98_H VDD VSS th13
X67 b_L_1 c_L_1 n99_L VDD VSS th22
X68 b_L_1 c_H_1 m11_m10 VDD VSS th22
X69 b_H_1 c_L_1 m11_m01 VDD VSS th22
X70 b_H_1 c_H_1 m11_m00 VDD VSS th22
X72 m11_m10 m11_m01 m11_m00 n99_H VDD VSS th13
X73 b_L_2 c_L_2 n100_L VDD VSS th22
X74 b_L_2 c_H_2 m12_m10 VDD VSS th22
X75 b_H_2 c_L_2 m12_m01 VDD VSS th22
X76 b_H_2 c_H_2 m12_m00 VDD VSS th22
X78 m12_m10 m12_m01 m12_m00 n100_H VDD VSS th13
X79 b_L_3 c_L_3 n101_L VDD VSS th22
X80 b_L_3 c_H_3 m13_m10 VDD VSS th22
X81 b_H_3 c_L_3 m13_m01 VDD VSS th22
X82 b_H_3 c_H_3 m13_m00 VDD VSS th22
X84 m13_m10 m13_m01 m13_m00 n101_H VDD VSS th13
X85 b_L_4 c_L_4 n102_L VDD VSS th22
X86 b_L_4 c_H_4 m14_m10 VDD VSS th22
X87 b_H_4 c_L_4 m14_m01 VDD VSS th22
X88 b_H_4 c_H_4 m14_m00 VDD VSS th22
X90 m14_m10 m14_m01 m14_m00 n102_H VDD VSS th13
X91 b_L_5 c_L_5 n103_L VDD VSS th22
X92 b_L_5 c_H_5 m15_m10 VDD VSS th22
X93 b_H_5 c_L_5 m15_m01 VDD VSS th22
X94 b_H_5 c_H_5 m15_m00 VDD VSS th22
X96 m15_m10 m15_m01 m15_m00 n103_H VDD VSS th13
X97 b_L_6 c_L_6 n104_L VDD VSS th22
X98 b_L_6 c_H_6 m16_m10 VDD VSS th22
X99 b_H_6 c_L_6 m16_m01 VDD VSS th22
X100 b_H_6 c_H_6 m16_m00 VDD VSS th22
X102 m16_m10 m16_m01 m16_m00 n104_H VDD VSS th13
X103 b_L_7 c_L_7 n105_L VDD VSS th22
X104 b_L_7 c_H_7 m17_m10 VDD VSS th22
X105 b_H_7 c_L_7 m17_m01 VDD VSS th22
X106 b_H_7 c_H_7 m17_m00 VDD VSS th22
X108 m17_m10 m17_m01 m17_m00 n105_H VDD VSS th13
X109 n78_L n98_L m18_m11 VDD VSS th22
X110 n78_L n98_H m18_m10 VDD VSS th22
X111 n78_H n98_L m18_m01 VDD VSS th22
X112 n78_H n98_H m18_m00 VDD VSS th22
X113 m18_m10 m18_m01 maj_L_0 VDD VSS th12
X114 m18_m11 m18_m00 maj_H_0 VDD VSS th12
X115 n81_L n99_L m19_m11 VDD VSS th22
X116 n81_L n99_H m19_m10 VDD VSS th22
X117 n81_H n99_L m19_m01 VDD VSS th22
X118 n81_H n99_H m19_m00 VDD VSS th22
X119 m19_m10 m19_m01 maj_L_1 VDD VSS th12
X120 m19_m11 m19_m00 maj_H_1 VDD VSS th12
X121 n84_L n100_L m20_m11 VDD VSS th22
X122 n84_L n100_H m20_m10 VDD VSS th22
X123 n84_H n100_L m20_m01 VDD VSS th22
X124 n84_H n100_H m20_m00 VDD VSS th22
X125 m20_m10 m20_m01 maj_L_2 VDD VSS th12
X126 m20_m11 m20_m00 maj_H_2 VDD VSS th12
X127 n87_L n101_L m21_m11 VDD VSS th22
X128 n87_L n101_H m21_m10 VDD VSS th22
X129 n87_H n101_L m21_m01 VDD VSS th22
X130 n87_H n101_H m21_m00 VDD VSS th22
X131 m21_m10 m21_m01 maj_L_3 VDD VSS th12
X132 m21_m11 m21_m00 maj_H_3 VDD VSS th12
X133 n90_L n102_L m22_m11 VDD VSS th22
X134 n90_L n102_H m22_m10 VDD VSS th22
X135 n90_H n102_L m22_m01 VDD VSS th22
X136 n90_H n102_H m22_m00 VDD VSS th22
X137 m22_m10 m22_m01 maj_L_4 VDD VSS th12
X138 m22_m11 m22_m00 maj_H_4 VDD VSS th12
X139 n93_L n103_L m23_m11 VDD VSS th22
X140 n93_L n103_H m23_m10 VDD VSS th22
X141 n93_H n103_L m23_m01 VDD VSS th22
X142 n93_H n103_H m23_m00 VDD VSS th22
X143 m23_m10 m23_m01 maj_L_5 VDD VSS th12
X144 m23_m11 m23_m00 maj_H_5 VDD VSS th12
X145 n95_L n104_L m24_m11 VDD VSS th22
X146 n95_L n104_H m24_m10 VDD VSS th22
X147 n95_H n104_L m24_m01 VDD VSS th22
X148 n95_H n104_H m24_m00 VDD VSS th22
X149 m24_m10 m24_m01 maj_L_6 VDD VSS th12
X150 m24_m11 m24_m00 maj_H_6 VDD VSS th12
X151 n97_L n105_L m25_m11 VDD VSS th22
X152 n97_L n105_H m25_m10 VDD VSS th22
X153 n97_H n105_L m25_m01 VDD VSS th22
X154 n97_H n105_H m25_m00 VDD VSS th22
X155 m25_m10 m25_m01 maj_L_7 VDD VSS th12
X156 m25_m11 m25_m00 maj_H_7 VDD VSS th12
X157 e_L_0 f_L_0 n106_L VDD VSS th22
X158 e_L_0 f_H_0 m26_m10 VDD VSS th22
X159 e_H_0 f_L_0 m26_m01 VDD VSS th22
X160 e_H_0 f_H_0 m26_m00 VDD VSS th22
X162 m26_m10 m26_m01 m26_m00 n106_H VDD VSS th13
X163 e_L_1 f_L_1 n107_L VDD VSS th22
X164 e_L_1 f_H_1 m27_m10 VDD VSS th22
X165 e_H_1 f_L_1 m27_m01 VDD VSS th22
X166 e_H_1 f_H_1 m27_m00 VDD VSS th22
X168 m27_m10 m27_m01 m27_m00 n107_H VDD VSS th13
X169 e_L_2 f_L_2 n108_L VDD VSS th22
X170 e_L_2 f_H_2 m28_m10 VDD VSS th22
X171 e_H_2 f_L_2 m28_m01 VDD VSS th22
X172 e_H_2 f_H_2 m28_m00 VDD VSS th22
X174 m28_m10 m28_m01 m28_m00 n108_H VDD VSS th13
X175 e_L_3 f_L_3 n109_L VDD VSS th22
X176 e_L_3 f_H_3 m29_m10 VDD VSS th22
X177 e_H_3 f_L_3 m29_m01 VDD VSS th22
X178 e_H_3 f_H_3 m29_m00 VDD VSS th22
X180 m29_m10 m29_m01 m29_m00 n109_H VDD VSS th13
X181 e_L_4 f_L_4 n110_L VDD VSS th22
X182 e_L_4 f_H_4 m30_m10 VDD VSS th22
X183 e_H_4 f_L_4 m30_m01 VDD VSS th22
X184 e_H_4 f_H_4 m30_m00 VDD VSS th22
X186 m30_m10 m30_m01 m30_m00 n110_H VDD VSS th13
X187 e_L_5 f_L_5 n111_L VDD VSS th22
X188 e_L_5 f_H_5 m31_m10 VDD VSS th22
X189 e_H_5 f_L_5 m31_m01 VDD VSS th22
X190 e_H_5 f_H_5 m31_m00 VDD VSS th22
X192 m31_m10 m31_m01 m31_m00 n111_H VDD VSS th13
X193 e_L_6 f_L_6 n112_L VDD VSS th22
X194 e_L_6 f_H_6 m32_m10 VDD VSS th22
X195 e_H_6 f_L_6 m32_m01 VDD VSS th22
X196 e_H_6 f_H_6 m32_m00 VDD VSS th22
X198 m32_m10 m32_m01 m32_m00 n112_H VDD VSS th13
X199 e_L_7 f_L_7 n113_L VDD VSS th22
X200 e_L_7 f_H_7 m33_m10 VDD VSS th22
X201 e_H_7 f_L_7 m33_m01 VDD VSS th22
X202 e_H_7 f_H_7 m33_m00 VDD VSS th22
X204 m33_m10 m33_m01 m33_m00 n113_H VDD VSS th13
X205 e_H_0 g_L_0 n115_L VDD VSS th22
X206 e_H_0 g_H_0 m34_m10 VDD VSS th22
X207 e_L_0 g_L_0 m34_m01 VDD VSS th22
X208 e_L_0 g_H_0 m34_m00 VDD VSS th22
X210 m34_m10 m34_m01 m34_m00 n115_H VDD VSS th13
X211 e_H_1 g_L_1 n117_L VDD VSS th22
X212 e_H_1 g_H_1 m35_m10 VDD VSS th22
X213 e_L_1 g_L_1 m35_m01 VDD VSS th22
X214 e_L_1 g_H_1 m35_m00 VDD VSS th22
X216 m35_m10 m35_m01 m35_m00 n117_H VDD VSS th13
X217 e_H_2 g_L_2 n119_L VDD VSS th22
X218 e_H_2 g_H_2 m36_m10 VDD VSS th22
X219 e_L_2 g_L_2 m36_m01 VDD VSS th22
X220 e_L_2 g_H_2 m36_m00 VDD VSS th22
X222 m36_m10 m36_m01 m36_m00 n119_H VDD VSS th13
X223 e_H_3 g_L_3 n121_L VDD VSS th22
X224 e_H_3 g_H_3 m37_m10 VDD VSS th22
X225 e_L_3 g_L_3 m37_m01 VDD VSS th22
X226 e_L_3 g_H_3 m37_m00 VDD VSS th22
X228 m37_m10 m37_m01 m37_m00 n121_H VDD VSS th13
X229 e_H_4 g_L_4 n123_L VDD VSS th22
X230 e_H_4 g_H_4 m38_m10 VDD VSS th22
X231 e_L_4 g_L_4 m38_m01 VDD VSS th22
X232 e_L_4 g_H_4 m38_m00 VDD VSS th22
X234 m38_m10 m38_m01 m38_m00 n123_H VDD VSS th13
X235 e_H_5 g_L_5 n125_L VDD VSS th22
X236 e_H_5 g_H_5 m39_m10 VDD VSS th22
X237 e_L_5 g_L_5 m39_m01 VDD VSS th22
X238 e_L_5 g_H_5 m39_m00 VDD VSS th22
X240 m39_m10 m39_m01 m39_m00 n125_H VDD VSS th13
X241 e_H_6 g_L_6 n127_L VDD VSS th22
X242 e_H_6 g_H_6 m40_m10 VDD VSS th22
X243 e_L_6 g_L_6 m40_m01 VDD VSS th22
X244 e_L_6 g_H_6 m40_m00 VDD VSS th22
X246 m40_m10 m40_m01 m40_m00 n127_H VDD VSS th13
X247 e_H_7 g_L_7 n129_L VDD VSS th22
X248 e_H_7 g_H_7 m41_m10 VDD VSS th22
X249 e_L_7 g_L_7 m41_m01 VDD VSS th22
X250 e_L_7 g_H_7 m41_m00 VDD VSS th22
X252 m41_m10 m41_m01 m41_m00 n129_H VDD VSS th13
X253 n106_L n115_L m42_m11 VDD VSS th22
X254 n106_L n115_H m42_m10 VDD VSS th22
X255 n106_H n115_L m42_m01 VDD VSS th22
X256 n106_H n115_H m42_m00 VDD VSS th22
X257 m42_m10 m42_m01 ch_L_0 VDD VSS th12
X258 m42_m11 m42_m00 ch_H_0 VDD VSS th12
X259 n107_L n117_L m43_m11 VDD VSS th22
X260 n107_L n117_H m43_m10 VDD VSS th22
X261 n107_H n117_L m43_m01 VDD VSS th22
X262 n107_H n117_H m43_m00 VDD VSS th22
X263 m43_m10 m43_m01 ch_L_1 VDD VSS th12
X264 m43_m11 m43_m00 ch_H_1 VDD VSS th12
X265 n108_L n119_L m44_m11 VDD VSS th22
X266 n108_L n119_H m44_m10 VDD VSS th22
X267 n108_H n119_L m44_m01 VDD VSS th22
X268 n108_H n119_H m44_m00 VDD VSS th22
X269 m44_m10 m44_m01 ch_L_2 VDD VSS th12
X270 m44_m11 m44_m00 ch_H_2 VDD VSS th12
X271 n109_L n121_L m45_m11 VDD VSS th22
X272 n109_L n121_H m45_m10 VDD VSS th22
X273 n109_H n121_L m45_m01 VDD VSS th22
X274 n109_H n121_H m45_m00 VDD VSS th22
X275 m45_m10 m45_m01 ch_L_3 VDD VSS th12
X276 m45_m11 m45_m00 ch_H_3 VDD VSS th12
X277 n110_L n123_L m46_m11 VDD VSS th22
X278 n110_L n123_H m46_m10 VDD VSS th22
X279 n110_H n123_L m46_m01 VDD VSS th22
X280 n110_H n123_H m46_m00 VDD VSS th22
X281 m46_m10 m46_m01 ch_L_4 VDD VSS th12
X282 m46_m11 m46_m00 ch_H_4 VDD VSS th12
X283 n111_L n125_L m47_m11 VDD VSS th22
X284 n111_L n125_H m47_m10 VDD VSS th22
X285 n111_H n125_L m47_m01 VDD VSS th22
X286 n111_H n125_H m47_m00 VDD VSS th22
X287 m47_m10 m47_m01 ch_L_5 VDD VSS th12
X288 m47_m11 m47_m00 ch_H_5 VDD VSS th12
X289 n112_L n127_L m48_m11 VDD VSS th22
X290 n112_L n127_H m48_m10 VDD VSS th22
X291 n112_H n127_L m48_m01 VDD VSS th22
X292 n112_H n127_H m48_m00 VDD VSS th22
X293 m48_m10 m48_m01 ch_L_6 VDD VSS th12
X294 m48_m11 m48_m00 ch_H_6 VDD VSS th12
X295 n113_L n129_L m49_m11 VDD VSS th22
X296 n113_L n129_H m49_m10 VDD VSS th22
X297 n113_H n129_L m49_m01 VDD VSS th22
X298 n113_H n129_H m49_m00 VDD VSS th22
X299 m49_m10 m49_m01 ch_L_7 VDD VSS th12
X300 m49_m11 m49_m00 ch_H_7 VDD VSS th12
X301 n130_L n76_L m50_m11 VDD VSS th22
X302 n130_L n76_H m50_m10 VDD VSS th22
X303 n130_H n76_L m50_m01 VDD VSS th22
X304 n130_H n76_H m50_m00 VDD VSS th22
X305 m50_m10 m50_m01 sum_L_1 VDD VSS th12
X306 m50_m11 m50_m00 sum_H_1 VDD VSS th12
X307 n131_L n132_L m51_m11 VDD VSS th22
X308 n131_L n132_H m51_m10 VDD VSS th22
X309 n131_H n132_L m51_m01 VDD VSS th22
X310 n131_H n132_H m51_m00 VDD VSS th22
X311 m51_m10 m51_m01 sum_L_2 VDD VSS th12
X312 m51_m11 m51_m00 sum_H_2 VDD VSS th12
X313 n133_L n134_L m52_m11 VDD VSS th22
X314 n133_L n134_H m52_m10 VDD VSS th22
X315 n133_H n134_L m52_m01 VDD VSS th22
X316 n133_H n134_H m52_m00 VDD VSS th22
X317 m52_m10 m52_m01 sum_L_3 VDD VSS th12
X318 m52_m11 m52_m00 sum_H_3 VDD VSS th12
X319 n135_L n136_L m53_m11 VDD VSS th22
X320 n135_L n136_H m53_m10 VDD VSS th22
X321 n135_H n136_L m53_m01 VDD VSS th22
X322 n135_H n136_H m53_m00 VDD VSS th22
X323 m53_m10 m53_m01 sum_L_4 VDD VSS th12
X324 m53_m11 m53_m00 sum_H_4 VDD VSS th12
X325 n137_L n138_L m54_m11 VDD VSS th22
X326 n137_L n138_H m54_m10 VDD VSS th22
X327 n137_H n138_L m54_m01 VDD VSS th22
X328 n137_H n138_H m54_m00 VDD VSS th22
X329 m54_m10 m54_m01 sum_L_5 VDD VSS th12
X330 m54_m11 m54_m00 sum_H_5 VDD VSS th12
X331 n139_L n140_L m55_m11 VDD VSS th22
X332 n139_L n140_H m55_m10 VDD VSS th22
X333 n139_H n140_L m55_m01 VDD VSS th22
X334 n139_H n140_H m55_m00 VDD VSS th22
X335 m55_m10 m55_m01 sum_L_6 VDD VSS th12
X336 m55_m11 m55_m00 sum_H_6 VDD VSS th12
X337 n141_L n142_L m56_m11 VDD VSS th22
X338 n141_L n142_H m56_m10 VDD VSS th22
X339 n141_H n142_L m56_m01 VDD VSS th22
X340 n141_H n142_H m56_m00 VDD VSS th22
X341 m56_m10 m56_m01 sum_L_7 VDD VSS th12
X342 m56_m11 m56_m00 sum_H_7 VDD VSS th12
X343 a_L_0 b_L_0 n76_L VDD VSS th22
X344 a_L_0 b_H_0 m57_m10 VDD VSS th22
X345 a_H_0 b_L_0 m57_m01 VDD VSS th22
X346 a_H_0 b_H_0 m57_m00 VDD VSS th22
X348 m57_m10 m57_m01 m57_m00 n76_H VDD VSS th13
X349 a_L_1 b_L_1 n79_L VDD VSS th22
X350 a_L_1 b_H_1 m58_m10 VDD VSS th22
X351 a_H_1 b_L_1 m58_m01 VDD VSS th22
X352 a_H_1 b_H_1 m58_m00 VDD VSS th22
X354 m58_m10 m58_m01 m58_m00 n79_H VDD VSS th13
X355 a_L_2 b_L_2 n82_L VDD VSS th22
X356 a_L_2 b_H_2 m59_m10 VDD VSS th22
X357 a_H_2 b_L_2 m59_m01 VDD VSS th22
X358 a_H_2 b_H_2 m59_m00 VDD VSS th22
X360 m59_m10 m59_m01 m59_m00 n82_H VDD VSS th13
X361 a_L_3 b_L_3 n85_L VDD VSS th22
X362 a_L_3 b_H_3 m60_m10 VDD VSS th22
X363 a_H_3 b_L_3 m60_m01 VDD VSS th22
X364 a_H_3 b_H_3 m60_m00 VDD VSS th22
X366 m60_m10 m60_m01 m60_m00 n85_H VDD VSS th13
X367 a_L_4 b_L_4 n88_L VDD VSS th22
X368 a_L_4 b_H_4 m61_m10 VDD VSS th22
X369 a_H_4 b_L_4 m61_m01 VDD VSS th22
X370 a_H_4 b_H_4 m61_m00 VDD VSS th22
X372 m61_m10 m61_m01 m61_m00 n88_H VDD VSS th13
X373 a_L_5 b_L_5 n91_L VDD VSS th22
X374 a_L_5 b_H_5 m62_m10 VDD VSS th22
X375 a_H_5 b_L_5 m62_m01 VDD VSS th22
X376 a_H_5 b_H_5 m62_m00 VDD VSS th22
X378 m62_m10 m62_m01 m62_m00 n91_H VDD VSS th13
X379 a_L_6 b_L_6 n94_L VDD VSS th22
X380 a_L_6 b_H_6 m63_m10 VDD VSS th22
X381 a_H_6 b_L_6 m63_m01 VDD VSS th22
X382 a_H_6 b_H_6 m63_m00 VDD VSS th22
X384 m63_m10 m63_m01 m63_m00 n94_H VDD VSS th13
X385 a_L_7 b_L_7 n96_L VDD VSS th22
X386 a_L_7 b_H_7 m64_m10 VDD VSS th22
X387 a_H_7 b_L_7 m64_m01 VDD VSS th22
X388 a_H_7 b_H_7 m64_m00 VDD VSS th22
X390 m64_m10 m64_m01 m64_m00 n96_H VDD VSS th13
X391 a_L_0 b_L_0 m65_m11 VDD VSS th22
X392 a_L_0 b_H_0 m65_m10 VDD VSS th22
X393 a_H_0 b_L_0 m65_m01 VDD VSS th22
X394 a_H_0 b_H_0 m65_m00 VDD VSS th22
X395 m65_m10 m65_m01 sum_L_0 VDD VSS th12
X396 m65_m11 m65_m00 sum_H_0 VDD VSS th12
X397 a_L_1 b_L_1 m66_m11 VDD VSS th22
X398 a_L_1 b_H_1 m66_m10 VDD VSS th22
X399 a_H_1 b_L_1 m66_m01 VDD VSS th22
X400 a_H_1 b_H_1 m66_m00 VDD VSS th22
X401 m66_m10 m66_m01 n130_L VDD VSS th12
X402 m66_m11 m66_m00 n130_H VDD VSS th12
X403 a_L_2 b_L_2 m67_m11 VDD VSS th22
X404 a_L_2 b_H_2 m67_m10 VDD VSS th22
X405 a_H_2 b_L_2 m67_m01 VDD VSS th22
X406 a_H_2 b_H_2 m67_m00 VDD VSS th22
X407 m67_m10 m67_m01 n131_L VDD VSS th12
X408 m67_m11 m67_m00 n131_H VDD VSS th12
X409 a_L_3 b_L_3 m68_m11 VDD VSS th22
X410 a_L_3 b_H_3 m68_m10 VDD VSS th22
X411 a_H_3 b_L_3 m68_m01 VDD VSS th22
X412 a_H_3 b_H_3 m68_m00 VDD VSS th22
X413 m68_m10 m68_m01 n133_L VDD VSS th12
X414 m68_m11 m68_m00 n133_H VDD VSS th12
X415 a_L_4 b_L_4 m69_m11 VDD VSS th22
X416 a_L_4 b_H_4 m69_m10 VDD VSS th22
X417 a_H_4 b_L_4 m69_m01 VDD VSS th22
X418 a_H_4 b_H_4 m69_m00 VDD VSS th22
X419 m69_m10 m69_m01 n135_L VDD VSS th12
X420 m69_m11 m69_m00 n135_H VDD VSS th12
X421 a_L_5 b_L_5 m70_m11 VDD VSS th22
X422 a_L_5 b_H_5 m70_m10 VDD VSS th22
X423 a_H_5 b_L_5 m70_m01 VDD VSS th22
X424 a_H_5 b_H_5 m70_m00 VDD VSS th22
X425 m70_m10 m70_m01 n137_L VDD VSS th12
X426 m70_m11 m70_m00 n137_H VDD VSS th12
X427 a_L_6 b_L_6 m71_m11 VDD VSS th22
X428 a_L_6 b_H_6 m71_m10 VDD VSS th22
X429 a_H_6 b_L_6 m71_m01 VDD VSS th22
X430 a_H_6 b_H_6 m71_m00 VDD VSS th22
X431 m71_m10 m71_m01 n139_L VDD VSS th12
X432 m71_m11 m71_m00 n139_H VDD VSS th12
X433 a_L_7 b_L_7 m72_m11 VDD VSS th22
X434 a_L_7 b_H_7 m72_m10 VDD VSS th22
X435 a_H_7 b_L_7 m72_m01 VDD VSS th22
X436 a_H_7 b_H_7 m72_m00 VDD VSS th22
X437 m72_m10 m72_m01 n141_L VDD VSS th12
X438 m72_m11 m72_m00 n141_H VDD VSS th12
X439 n130_L n76_L n143_L VDD VSS th22
X440 n130_L n76_H m73_m10 VDD VSS th22
X441 n130_H n76_L m73_m01 VDD VSS th22
X442 n130_H n76_H m73_m00 VDD VSS th22
X444 m73_m10 m73_m01 m73_m00 n143_H VDD VSS th13
X445 n133_L n82_L n144_L VDD VSS th22
X446 n133_L n82_H m74_m10 VDD VSS th22
X447 n133_H n82_L m74_m01 VDD VSS th22
X448 n133_H n82_H m74_m00 VDD VSS th22
X450 m74_m10 m74_m01 m74_m00 n144_H VDD VSS th13
X451 n137_L n88_L n145_L VDD VSS th22
X452 n137_L n88_H m75_m10 VDD VSS th22
X453 n137_H n88_L m75_m01 VDD VSS th22
X454 n137_H n88_H m75_m00 VDD VSS th22
X456 m75_m10 m75_m01 m75_m00 n145_H VDD VSS th13
X457 n146_L n132_L n147_L VDD VSS th22
X458 n146_L n132_H m76_m10 VDD VSS th22
X459 n146_H n132_L m76_m01 VDD VSS th22
X460 n146_H n132_H m76_m00 VDD VSS th22
X462 m76_m10 m76_m01 m76_m00 n147_H VDD VSS th13
X463 n133_L n131_L n146_L VDD VSS th22
X464 n133_L n131_H m77_m10 VDD VSS th22
X465 n133_H n131_L m77_m01 VDD VSS th22
X466 n133_H n131_H m77_m00 VDD VSS th22
X468 m77_m10 m77_m01 m77_m00 n146_H VDD VSS th13
X469 n137_L n135_L n148_L VDD VSS th22
X470 n137_L n135_H m78_m10 VDD VSS th22
X471 n137_H n135_L m78_m01 VDD VSS th22
X472 n137_H n135_H m78_m00 VDD VSS th22
X474 m78_m10 m78_m01 m78_m00 n148_H VDD VSS th13
X475 n148_L n136_L n149_L VDD VSS th22
X476 n148_L n136_H m79_m10 VDD VSS th22
X477 n148_H n136_L m79_m01 VDD VSS th22
X478 n148_H n136_H m79_m00 VDD VSS th22
X480 m79_m10 m79_m01 m79_m00 n149_H VDD VSS th13
X481 n131_L n132_L n150_L VDD VSS th22
X482 n131_L n132_H m80_m10 VDD VSS th22
X483 n131_H n132_L m80_m01 VDD VSS th22
X484 n131_H n132_H m80_m00 VDD VSS th22
X486 m80_m10 m80_m01 m80_m00 n150_H VDD VSS th13
X487 n135_L n136_L n151_L VDD VSS th22
X488 n135_L n136_H m81_m10 VDD VSS th22
X489 n135_H n136_L m81_m01 VDD VSS th22
X490 n135_H n136_H m81_m00 VDD VSS th22
X492 m81_m10 m81_m01 m81_m00 n151_H VDD VSS th13
X493 n139_L n140_L n152_L VDD VSS th22
X494 n139_L n140_H m82_m10 VDD VSS th22
X495 n139_H n140_L m82_m01 VDD VSS th22
X496 n139_H n140_H m82_m00 VDD VSS th22
X498 m82_m10 m82_m01 m82_m00 n152_H VDD VSS th13
X499 n79_L n143_L m83_m11 VDD VSS th22
X500 n79_L n143_H m83_m10 VDD VSS th22
X501 n79_H n143_L m83_m01 VDD VSS th22
X502 n79_H n143_H n132_H VDD VSS th22
X503 m83_m11 m83_m10 m83_m01 n132_L VDD VSS th13
X505 n85_L n144_L m84_m11 VDD VSS th22
X506 n85_L n144_H m84_m10 VDD VSS th22
X507 n85_H n144_L m84_m01 VDD VSS th22
X508 n85_H n144_H n153_H VDD VSS th22
X509 m84_m11 m84_m10 m84_m01 n153_L VDD VSS th13
X511 n91_L n145_L m85_m11 VDD VSS th22
X512 n91_L n145_H m85_m10 VDD VSS th22
X513 n91_H n145_L m85_m01 VDD VSS th22
X514 n91_H n145_H n154_H VDD VSS th22
X515 m85_m11 m85_m10 m85_m01 n154_L VDD VSS th13
X517 n153_L n147_L m86_m11 VDD VSS th22
X518 n153_L n147_H m86_m10 VDD VSS th22
X519 n153_H n147_L m86_m01 VDD VSS th22
X520 n153_H n147_H n136_H VDD VSS th22
X521 m86_m11 m86_m10 m86_m01 n136_L VDD VSS th13
X523 n154_L n149_L m87_m11 VDD VSS th22
X524 n154_L n149_H m87_m10 VDD VSS th22
X525 n154_H n149_L m87_m01 VDD VSS th22
X526 n154_H n149_H n140_H VDD VSS th22
X527 m87_m11 m87_m10 m87_m01 n140_L VDD VSS th13
X529 n82_L n150_L m88_m11 VDD VSS th22
X530 n82_L n150_H m88_m10 VDD VSS th22
X531 n82_H n150_L m88_m01 VDD VSS th22
X532 n82_H n150_H n134_H VDD VSS th22
X533 m88_m11 m88_m10 m88_m01 n134_L VDD VSS th13
X535 n88_L n151_L m89_m11 VDD VSS th22
X536 n88_L n151_H m89_m10 VDD VSS th22
X537 n88_H n151_L m89_m01 VDD VSS th22
X538 n88_H n151_H n138_H VDD VSS th22
X539 m89_m11 m89_m10 m89_m01 n138_L VDD VSS th13
X541 n94_L n152_L m90_m11 VDD VSS th22
X542 n94_L n152_H m90_m10 VDD VSS th22
X543 n94_H n152_L m90_m01 VDD VSS th22
X544 n94_H n152_H n142_H VDD VSS th22
X545 m90_m11 m90_m10 m90_m01 n142_L VDD VSS th13
X547 a_L_0 c_L_0 n77_L VDD VSS th22
X548 a_L_0 c_H_0 m91_m10 VDD VSS th22
X549 a_H_0 c_L_0 m91_m01 VDD VSS th22
X550 a_H_0 c_H_0 m91_m00 VDD VSS th22
X552 m91_m10 m91_m01 m91_m00 n77_H VDD VSS th13
X553 a_L_1 c_L_1 n80_L VDD VSS th22
X554 a_L_1 c_H_1 m92_m10 VDD VSS th22
X555 a_H_1 c_L_1 m92_m01 VDD VSS th22
X556 a_H_1 c_H_1 m92_m00 VDD VSS th22
X558 m92_m10 m92_m01 m92_m00 n80_H VDD VSS th13
X559 a_L_2 c_L_2 n83_L VDD VSS th22
X560 a_L_2 c_H_2 m93_m10 VDD VSS th22
X561 a_H_2 c_L_2 m93_m01 VDD VSS th22
X562 a_H_2 c_H_2 m93_m00 VDD VSS th22
X564 m93_m10 m93_m01 m93_m00 n83_H VDD VSS th13
X565 a_L_3 c_L_3 n86_L VDD VSS th22
X566 a_L_3 c_H_3 m94_m10 VDD VSS th22
X567 a_H_3 c_L_3 m94_m01 VDD VSS th22
X568 a_H_3 c_H_3 m94_m00 VDD VSS th22
X570 m94_m10 m94_m01 m94_m00 n86_H VDD VSS th13
X571 a_L_4 c_L_4 n89_L VDD VSS th22
X572 a_L_4 c_H_4 m95_m10 VDD VSS th22
X573 a_H_4 c_L_4 m95_m01 VDD VSS th22
X574 a_H_4 c_H_4 m95_m00 VDD VSS th22
X576 m95_m10 m95_m01 m95_m00 n89_H VDD VSS th13
X577 a_L_5 c_L_5 n92_L VDD VSS th22
X578 a_L_5 c_H_5 m96_m10 VDD VSS th22
X579 a_H_5 c_L_5 m96_m01 VDD VSS th22
X580 a_H_5 c_H_5 m96_m00 VDD VSS th22
X582 m96_m10 m96_m01 m96_m00 n92_H VDD VSS th13
.ends sha_slice
