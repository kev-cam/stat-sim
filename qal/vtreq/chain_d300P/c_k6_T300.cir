.hdl "/usr/local/share/xyce/verilog-a/psp103/psp103.va"
.include "/usr/local/src/kestrel/sim/models/sg13g2_psp103_tt.lib"
.include "/usr/local/src/stat-sim/qal/vtreq/shim_dvt.sp"
.param DVTN=0 DVTP=-0.3
.OPTIONS TIMEINT METHOD=GEAR RELTOL=1e-6 ABSTOL=1e-15 CHGTOL=1e-17
.param LT=15n RS=10
VHI vhi 0 1.5
VRES vres 0 1.2
CRES1 res1 0 35.979f
XRP1_0a rm1_0 o6_0 vres vres sg13_lv_pmos w=0.15u l=0.13u
XRN1_0a rm1_0 o6_0 0 0 sg13_lv_nmos w=1.48u l=0.13u
CRM1_0 rm1_0 0 2f
XRP1_0b rb1_0 rm1_0 vres vres sg13_lv_pmos w=1.12u l=0.13u
XRN1_0b rb1_0 rm1_0 0 0 sg13_lv_nmos w=0.74u l=0.13u
CRB1_0 rb1_0 0 2f
XRP1_1a rm1_1 o6_1 vres vres sg13_lv_pmos w=0.15u l=0.13u
XRN1_1a rm1_1 o6_1 0 0 sg13_lv_nmos w=1.48u l=0.13u
CRM1_1 rm1_1 0 2f
XRP1_1b rb1_1 rm1_1 vres vres sg13_lv_pmos w=1.12u l=0.13u
XRN1_1b rb1_1 rm1_1 0 0 sg13_lv_nmos w=0.74u l=0.13u
CRB1_1 rb1_1 0 2f
XRP1_2a rm1_2 o6_2 vres vres sg13_lv_pmos w=0.15u l=0.13u
XRN1_2a rm1_2 o6_2 0 0 sg13_lv_nmos w=1.48u l=0.13u
CRM1_2 rm1_2 0 2f
XRP1_2b rb1_2 rm1_2 vres vres sg13_lv_pmos w=1.12u l=0.13u
XRN1_2b rb1_2 rm1_2 0 0 sg13_lv_nmos w=0.74u l=0.13u
CRB1_2 rb1_2 0 2f
XRP1_3a rm1_3 o6_3 vres vres sg13_lv_pmos w=0.15u l=0.13u
XRN1_3a rm1_3 o6_3 0 0 sg13_lv_nmos w=1.48u l=0.13u
CRM1_3 rm1_3 0 2f
XRP1_3b rb1_3 rm1_3 vres vres sg13_lv_pmos w=1.12u l=0.13u
XRN1_3b rb1_3 rm1_3 0 0 sg13_lv_nmos w=0.74u l=0.13u
CRB1_3 rb1_3 0 2f
XRP1_4a rm1_4 o6_4 vres vres sg13_lv_pmos w=0.15u l=0.13u
XRN1_4a rm1_4 o6_4 0 0 sg13_lv_nmos w=1.48u l=0.13u
CRM1_4 rm1_4 0 2f
XRP1_4b rb1_4 rm1_4 vres vres sg13_lv_pmos w=1.12u l=0.13u
XRN1_4b rb1_4 rm1_4 0 0 sg13_lv_nmos w=0.74u l=0.13u
CRB1_4 rb1_4 0 2f
XRP1_5a rm1_5 o6_5 vres vres sg13_lv_pmos w=0.15u l=0.13u
XRN1_5a rm1_5 o6_5 0 0 sg13_lv_nmos w=1.48u l=0.13u
CRM1_5 rm1_5 0 2f
XRP1_5b rb1_5 rm1_5 vres vres sg13_lv_pmos w=1.12u l=0.13u
XRN1_5b rb1_5 rm1_5 0 0 sg13_lv_nmos w=0.74u l=0.13u
CRB1_5 rb1_5 0 2f
XRP1_6a rm1_6 o6_6 vres vres sg13_lv_pmos w=0.15u l=0.13u
XRN1_6a rm1_6 o6_6 0 0 sg13_lv_nmos w=1.48u l=0.13u
CRM1_6 rm1_6 0 2f
XRP1_6b rb1_6 rm1_6 vres vres sg13_lv_pmos w=1.12u l=0.13u
XRN1_6b rb1_6 rm1_6 0 0 sg13_lv_nmos w=0.74u l=0.13u
CRB1_6 rb1_6 0 2f
XRP1_7a rm1_7 o6_7 vres vres sg13_lv_pmos w=0.15u l=0.13u
XRN1_7a rm1_7 o6_7 0 0 sg13_lv_nmos w=1.48u l=0.13u
CRM1_7 rm1_7 0 2f
XRP1_7b rb1_7 rm1_7 vres vres sg13_lv_pmos w=1.12u l=0.13u
XRN1_7b rb1_7 rm1_7 0 0 sg13_lv_nmos w=0.74u l=0.13u
CRB1_7 rb1_7 0 2f
VMG1 gn1 0 0
VI1_0 in1_0 0 1.2
VI1_1 in1_1 0 0
VI1_2 in1_2 0 1.2
VI1_3 in1_3 0 0
VI1_4 in1_4 0 1.2
VI1_5 in1_5 0 0
VI1_6 in1_6 0 1.2
VI1_7 in1_7 0 0
XP1_0 o1_0 in1_0 rail1 rail1 sg13_lv_pmos w=1.12u l=0.13u
XN1_0 o1_0 in1_0 gn1 gn1 sg13_lv_nmos w=0.74u l=0.13u
CL1_0 o1_0 gn1 2f
XP1_1 o1_1 in1_1 rail1 rail1 sg13_lv_pmos w=1.12u l=0.13u
XN1_1 o1_1 in1_1 gn1 gn1 sg13_lv_nmos w=0.74u l=0.13u
CL1_1 o1_1 gn1 2f
XP1_2 o1_2 in1_2 rail1 rail1 sg13_lv_pmos w=1.12u l=0.13u
XN1_2 o1_2 in1_2 gn1 gn1 sg13_lv_nmos w=0.74u l=0.13u
CL1_2 o1_2 gn1 2f
XP1_3 o1_3 in1_3 rail1 rail1 sg13_lv_pmos w=1.12u l=0.13u
XN1_3 o1_3 in1_3 gn1 gn1 sg13_lv_nmos w=0.74u l=0.13u
CL1_3 o1_3 gn1 2f
XP1_4 o1_4 in1_4 rail1 rail1 sg13_lv_pmos w=1.12u l=0.13u
XN1_4 o1_4 in1_4 gn1 gn1 sg13_lv_nmos w=0.74u l=0.13u
CL1_4 o1_4 gn1 2f
XP1_5 o1_5 in1_5 rail1 rail1 sg13_lv_pmos w=1.12u l=0.13u
XN1_5 o1_5 in1_5 gn1 gn1 sg13_lv_nmos w=0.74u l=0.13u
CL1_5 o1_5 gn1 2f
XP1_6 o1_6 in1_6 rail1 rail1 sg13_lv_pmos w=1.12u l=0.13u
XN1_6 o1_6 in1_6 gn1 gn1 sg13_lv_nmos w=0.74u l=0.13u
CL1_6 o1_6 gn1 2f
XP1_7 o1_7 in1_7 rail1 rail1 sg13_lv_pmos w=1.12u l=0.13u
XN1_7 o1_7 in1_7 gn1 gn1 sg13_lv_nmos w=0.74u l=0.13u
CL1_7 o1_7 gn1 2f
VMG2 gn2 0 0
XP2_0 o2_0 o1_0 rail2 rail2 sg13_lv_pmos w=1.12u l=0.13u
XN2_0 o2_0 o1_0 gn2 gn2 sg13_lv_nmos w=0.74u l=0.13u
CL2_0 o2_0 gn2 2f
XP2_1 o2_1 o1_1 rail2 rail2 sg13_lv_pmos w=1.12u l=0.13u
XN2_1 o2_1 o1_1 gn2 gn2 sg13_lv_nmos w=0.74u l=0.13u
CL2_1 o2_1 gn2 2f
XP2_2 o2_2 o1_2 rail2 rail2 sg13_lv_pmos w=1.12u l=0.13u
XN2_2 o2_2 o1_2 gn2 gn2 sg13_lv_nmos w=0.74u l=0.13u
CL2_2 o2_2 gn2 2f
XP2_3 o2_3 o1_3 rail2 rail2 sg13_lv_pmos w=1.12u l=0.13u
XN2_3 o2_3 o1_3 gn2 gn2 sg13_lv_nmos w=0.74u l=0.13u
CL2_3 o2_3 gn2 2f
XP2_4 o2_4 o1_4 rail2 rail2 sg13_lv_pmos w=1.12u l=0.13u
XN2_4 o2_4 o1_4 gn2 gn2 sg13_lv_nmos w=0.74u l=0.13u
CL2_4 o2_4 gn2 2f
XP2_5 o2_5 o1_5 rail2 rail2 sg13_lv_pmos w=1.12u l=0.13u
XN2_5 o2_5 o1_5 gn2 gn2 sg13_lv_nmos w=0.74u l=0.13u
CL2_5 o2_5 gn2 2f
XP2_6 o2_6 o1_6 rail2 rail2 sg13_lv_pmos w=1.12u l=0.13u
XN2_6 o2_6 o1_6 gn2 gn2 sg13_lv_nmos w=0.74u l=0.13u
CL2_6 o2_6 gn2 2f
XP2_7 o2_7 o1_7 rail2 rail2 sg13_lv_pmos w=1.12u l=0.13u
XN2_7 o2_7 o1_7 gn2 gn2 sg13_lv_nmos w=0.74u l=0.13u
CL2_7 o2_7 gn2 2f
VMG3 gn3 0 0
XP3_0 o3_0 o2_0 rail3 rail3 sg13_lv_pmos w=1.12u l=0.13u
XN3_0 o3_0 o2_0 gn3 gn3 sg13_lv_nmos w=0.74u l=0.13u
CL3_0 o3_0 gn3 2f
XP3_1 o3_1 o2_1 rail3 rail3 sg13_lv_pmos w=1.12u l=0.13u
XN3_1 o3_1 o2_1 gn3 gn3 sg13_lv_nmos w=0.74u l=0.13u
CL3_1 o3_1 gn3 2f
XP3_2 o3_2 o2_2 rail3 rail3 sg13_lv_pmos w=1.12u l=0.13u
XN3_2 o3_2 o2_2 gn3 gn3 sg13_lv_nmos w=0.74u l=0.13u
CL3_2 o3_2 gn3 2f
XP3_3 o3_3 o2_3 rail3 rail3 sg13_lv_pmos w=1.12u l=0.13u
XN3_3 o3_3 o2_3 gn3 gn3 sg13_lv_nmos w=0.74u l=0.13u
CL3_3 o3_3 gn3 2f
XP3_4 o3_4 o2_4 rail3 rail3 sg13_lv_pmos w=1.12u l=0.13u
XN3_4 o3_4 o2_4 gn3 gn3 sg13_lv_nmos w=0.74u l=0.13u
CL3_4 o3_4 gn3 2f
XP3_5 o3_5 o2_5 rail3 rail3 sg13_lv_pmos w=1.12u l=0.13u
XN3_5 o3_5 o2_5 gn3 gn3 sg13_lv_nmos w=0.74u l=0.13u
CL3_5 o3_5 gn3 2f
XP3_6 o3_6 o2_6 rail3 rail3 sg13_lv_pmos w=1.12u l=0.13u
XN3_6 o3_6 o2_6 gn3 gn3 sg13_lv_nmos w=0.74u l=0.13u
CL3_6 o3_6 gn3 2f
XP3_7 o3_7 o2_7 rail3 rail3 sg13_lv_pmos w=1.12u l=0.13u
XN3_7 o3_7 o2_7 gn3 gn3 sg13_lv_nmos w=0.74u l=0.13u
CL3_7 o3_7 gn3 2f
VMG4 gn4 0 0
XP4_0 o4_0 o3_0 rail4 rail4 sg13_lv_pmos w=1.12u l=0.13u
XN4_0 o4_0 o3_0 gn4 gn4 sg13_lv_nmos w=0.74u l=0.13u
CL4_0 o4_0 gn4 2f
XP4_1 o4_1 o3_1 rail4 rail4 sg13_lv_pmos w=1.12u l=0.13u
XN4_1 o4_1 o3_1 gn4 gn4 sg13_lv_nmos w=0.74u l=0.13u
CL4_1 o4_1 gn4 2f
XP4_2 o4_2 o3_2 rail4 rail4 sg13_lv_pmos w=1.12u l=0.13u
XN4_2 o4_2 o3_2 gn4 gn4 sg13_lv_nmos w=0.74u l=0.13u
CL4_2 o4_2 gn4 2f
XP4_3 o4_3 o3_3 rail4 rail4 sg13_lv_pmos w=1.12u l=0.13u
XN4_3 o4_3 o3_3 gn4 gn4 sg13_lv_nmos w=0.74u l=0.13u
CL4_3 o4_3 gn4 2f
XP4_4 o4_4 o3_4 rail4 rail4 sg13_lv_pmos w=1.12u l=0.13u
XN4_4 o4_4 o3_4 gn4 gn4 sg13_lv_nmos w=0.74u l=0.13u
CL4_4 o4_4 gn4 2f
XP4_5 o4_5 o3_5 rail4 rail4 sg13_lv_pmos w=1.12u l=0.13u
XN4_5 o4_5 o3_5 gn4 gn4 sg13_lv_nmos w=0.74u l=0.13u
CL4_5 o4_5 gn4 2f
XP4_6 o4_6 o3_6 rail4 rail4 sg13_lv_pmos w=1.12u l=0.13u
XN4_6 o4_6 o3_6 gn4 gn4 sg13_lv_nmos w=0.74u l=0.13u
CL4_6 o4_6 gn4 2f
XP4_7 o4_7 o3_7 rail4 rail4 sg13_lv_pmos w=1.12u l=0.13u
XN4_7 o4_7 o3_7 gn4 gn4 sg13_lv_nmos w=0.74u l=0.13u
CL4_7 o4_7 gn4 2f
VMG5 gn5 0 0
XP5_0 o5_0 o4_0 rail5 rail5 sg13_lv_pmos w=1.12u l=0.13u
XN5_0 o5_0 o4_0 gn5 gn5 sg13_lv_nmos w=0.74u l=0.13u
CL5_0 o5_0 gn5 2f
XP5_1 o5_1 o4_1 rail5 rail5 sg13_lv_pmos w=1.12u l=0.13u
XN5_1 o5_1 o4_1 gn5 gn5 sg13_lv_nmos w=0.74u l=0.13u
CL5_1 o5_1 gn5 2f
XP5_2 o5_2 o4_2 rail5 rail5 sg13_lv_pmos w=1.12u l=0.13u
XN5_2 o5_2 o4_2 gn5 gn5 sg13_lv_nmos w=0.74u l=0.13u
CL5_2 o5_2 gn5 2f
XP5_3 o5_3 o4_3 rail5 rail5 sg13_lv_pmos w=1.12u l=0.13u
XN5_3 o5_3 o4_3 gn5 gn5 sg13_lv_nmos w=0.74u l=0.13u
CL5_3 o5_3 gn5 2f
XP5_4 o5_4 o4_4 rail5 rail5 sg13_lv_pmos w=1.12u l=0.13u
XN5_4 o5_4 o4_4 gn5 gn5 sg13_lv_nmos w=0.74u l=0.13u
CL5_4 o5_4 gn5 2f
XP5_5 o5_5 o4_5 rail5 rail5 sg13_lv_pmos w=1.12u l=0.13u
XN5_5 o5_5 o4_5 gn5 gn5 sg13_lv_nmos w=0.74u l=0.13u
CL5_5 o5_5 gn5 2f
XP5_6 o5_6 o4_6 rail5 rail5 sg13_lv_pmos w=1.12u l=0.13u
XN5_6 o5_6 o4_6 gn5 gn5 sg13_lv_nmos w=0.74u l=0.13u
CL5_6 o5_6 gn5 2f
XP5_7 o5_7 o4_7 rail5 rail5 sg13_lv_pmos w=1.12u l=0.13u
XN5_7 o5_7 o4_7 gn5 gn5 sg13_lv_nmos w=0.74u l=0.13u
CL5_7 o5_7 gn5 2f
VMG6 gn6 0 0
XP6_0 o6_0 o5_0 rail6 rail6 sg13_lv_pmos w=1.12u l=0.13u
XN6_0 o6_0 o5_0 gn6 gn6 sg13_lv_nmos w=0.74u l=0.13u
CL6_0 o6_0 gn6 2f
XP6_1 o6_1 o5_1 rail6 rail6 sg13_lv_pmos w=1.12u l=0.13u
XN6_1 o6_1 o5_1 gn6 gn6 sg13_lv_nmos w=0.74u l=0.13u
CL6_1 o6_1 gn6 2f
XP6_2 o6_2 o5_2 rail6 rail6 sg13_lv_pmos w=1.12u l=0.13u
XN6_2 o6_2 o5_2 gn6 gn6 sg13_lv_nmos w=0.74u l=0.13u
CL6_2 o6_2 gn6 2f
XP6_3 o6_3 o5_3 rail6 rail6 sg13_lv_pmos w=1.12u l=0.13u
XN6_3 o6_3 o5_3 gn6 gn6 sg13_lv_nmos w=0.74u l=0.13u
CL6_3 o6_3 gn6 2f
XP6_4 o6_4 o5_4 rail6 rail6 sg13_lv_pmos w=1.12u l=0.13u
XN6_4 o6_4 o5_4 gn6 gn6 sg13_lv_nmos w=0.74u l=0.13u
CL6_4 o6_4 gn6 2f
XP6_5 o6_5 o5_5 rail6 rail6 sg13_lv_pmos w=1.12u l=0.13u
XN6_5 o6_5 o5_5 gn6 gn6 sg13_lv_nmos w=0.74u l=0.13u
CL6_5 o6_5 gn6 2f
XP6_6 o6_6 o5_6 rail6 rail6 sg13_lv_pmos w=1.12u l=0.13u
XN6_6 o6_6 o5_6 gn6 gn6 sg13_lv_nmos w=0.74u l=0.13u
CL6_6 o6_6 gn6 2f
XP6_7 o6_7 o5_7 rail6 rail6 sg13_lv_pmos w=1.12u l=0.13u
XN6_7 o6_7 o5_7 gn6 gn6 sg13_lv_nmos w=0.74u l=0.13u
CL6_7 o6_7 gn6 2f
L1 res1 mid1 {LT}
R1 mid1 sw1 {RS}
XSWN1 sw1 gt1 rail1 0 sg13_lv_nmos w=10u l=0.13u
XSWP1 sw1 gtp1 rail1 vhi sg13_lv_pmos w=20u l=0.13u
XPK1 sw1 pk1 0 0 sg13_lv_nmos w=2u l=0.13u
L2 a2 mid2 {LT}
R2 mid2 sw2 {RS}
XSWN2 sw2 gt2 rail2 0 sg13_lv_nmos w=10u l=0.13u
XSWP2 sw2 gtp2 rail2 vhi sg13_lv_pmos w=20u l=0.13u
XPK2 sw2 pk2 0 0 sg13_lv_nmos w=2u l=0.13u
XSWSN2 a2 gt2 rail1 0 sg13_lv_nmos w=10u l=0.13u
XSWSP2 a2 gtp2 rail1 vhi sg13_lv_pmos w=20u l=0.13u
L3 a3 mid3 {LT}
R3 mid3 sw3 {RS}
XSWN3 sw3 gt3 rail3 0 sg13_lv_nmos w=10u l=0.13u
XSWP3 sw3 gtp3 rail3 vhi sg13_lv_pmos w=20u l=0.13u
XPK3 sw3 pk3 0 0 sg13_lv_nmos w=2u l=0.13u
XSWSN3 a3 gt3 rail2 0 sg13_lv_nmos w=10u l=0.13u
XSWSP3 a3 gtp3 rail2 vhi sg13_lv_pmos w=20u l=0.13u
L4 a4 mid4 {LT}
R4 mid4 sw4 {RS}
XSWN4 sw4 gt4 rail4 0 sg13_lv_nmos w=10u l=0.13u
XSWP4 sw4 gtp4 rail4 vhi sg13_lv_pmos w=20u l=0.13u
XPK4 sw4 pk4 0 0 sg13_lv_nmos w=2u l=0.13u
XSWSN4 a4 gt4 rail3 0 sg13_lv_nmos w=10u l=0.13u
XSWSP4 a4 gtp4 rail3 vhi sg13_lv_pmos w=20u l=0.13u
L5 a5 mid5 {LT}
R5 mid5 sw5 {RS}
XSWN5 sw5 gt5 rail5 0 sg13_lv_nmos w=10u l=0.13u
XSWP5 sw5 gtp5 rail5 vhi sg13_lv_pmos w=20u l=0.13u
XPK5 sw5 pk5 0 0 sg13_lv_nmos w=2u l=0.13u
XSWSN5 a5 gt5 rail4 0 sg13_lv_nmos w=10u l=0.13u
XSWSP5 a5 gtp5 rail4 vhi sg13_lv_pmos w=20u l=0.13u
L6 a6 mid6 {LT}
R6 mid6 sw6 {RS}
XSWN6 sw6 gt6 rail6 0 sg13_lv_nmos w=10u l=0.13u
XSWP6 sw6 gtp6 rail6 vhi sg13_lv_pmos w=20u l=0.13u
XPK6 sw6 pk6 0 0 sg13_lv_nmos w=2u l=0.13u
XSWSN6 a6 gt6 rail5 0 sg13_lv_nmos w=10u l=0.13u
XSWSP6 a6 gtp6 rail5 vhi sg13_lv_pmos w=20u l=0.13u
VGT1 gt1 0 PWL(0 0 198p 0 200p 1.5 267.908p 1.5 269.908p 0)
VGTP1 gtp1 0 PWL(0 1.5 198p 1.5 200p 0 267.908p 0 269.908p 1.5)
VPK1 pk1 0 PWL(0 0 269.908p 0 271.908p 1.5)
VGT2 gt2 0 PWL(0 0 498p 0 500p 1.5 609.636p 1.5 611.636p 0)
VGTP2 gtp2 0 PWL(0 1.5 498p 1.5 500p 0 609.636p 0 611.636p 1.5)
VPK2 pk2 0 PWL(0 1.5 500p 1.5 502p 0 611.636p 0 613.636p 1.5)
VGT3 gt3 0 PWL(0 0 798p 0 800p 1.5 904.631p 1.5 906.631p 0)
VGTP3 gtp3 0 PWL(0 1.5 798p 1.5 800p 0 904.631p 0 906.631p 1.5)
VPK3 pk3 0 PWL(0 1.5 800p 1.5 802p 0 906.631p 0 908.631p 1.5)
VGT4 gt4 0 PWL(0 0 1098p 0 1100p 1.5 1202.12p 1.5 1204.12p 0)
VGTP4 gtp4 0 PWL(0 1.5 1098p 1.5 1100p 0 1202.12p 0 1204.12p 1.5)
VPK4 pk4 0 PWL(0 1.5 1100p 1.5 1102p 0 1204.12p 0 1206.12p 1.5)
VGT5 gt5 0 PWL(0 0 1398p 0 1400p 1.5 1501.86p 1.5 1503.86p 0)
VGTP5 gtp5 0 PWL(0 1.5 1398p 1.5 1400p 0 1501.86p 0 1503.86p 1.5)
VPK5 pk5 0 PWL(0 1.5 1400p 1.5 1402p 0 1503.86p 0 1505.86p 1.5)
VGT6 gt6 0 PWL(0 0 1698p 0 1700p 1.5 1794.53p 1.5 1796.53p 0)
VGTP6 gtp6 0 PWL(0 1.5 1698p 1.5 1700p 0 1794.53p 0 1796.53p 1.5)
VPK6 pk6 0 PWL(0 1.5 1700p 1.5 1702p 0 1796.53p 0 1798.53p 1.5)
CXqlt1 xqlt1 0 1
BXqlt1 0 xqlt1 I={ I(L1) }
RXqlt1 xqlt1 0 0.01
CXea1 xea1 0 1
BXea1 0 xea1 I={ V(res1)*I(L1) }
RXea1 xea1 0 0.01
CXean1 xean1 0 1
BXean1 0 xean1 I={ V(res1)*I(L1) }
RXean1 xean1 0 0.01
CXeb1 xeb1 0 1
BXeb1 0 xeb1 I={ V(rail1)*I(L1) }
RXeb1 xeb1 0 0.01
CXer1 xer1 0 1
BXer1 0 xer1 I={ I(L1)*I(L1)*10 }
RXer1 xer1 0 0.01
CXesw1 xesw1 0 1
BXesw1 0 xesw1 I={ V(sw1)*I(L1) }
RXesw1 xesw1 0 0.01
CXqlt2 xqlt2 0 1
BXqlt2 0 xqlt2 I={ I(L2) }
RXqlt2 xqlt2 0 0.01
CXea2 xea2 0 1
BXea2 0 xea2 I={ V(rail1)*I(L2) }
RXea2 xea2 0 0.01
CXean2 xean2 0 1
BXean2 0 xean2 I={ V(a2)*I(L2) }
RXean2 xean2 0 0.01
CXeb2 xeb2 0 1
BXeb2 0 xeb2 I={ V(rail2)*I(L2) }
RXeb2 xeb2 0 0.01
CXer2 xer2 0 1
BXer2 0 xer2 I={ I(L2)*I(L2)*10 }
RXer2 xer2 0 0.01
CXesw2 xesw2 0 1
BXesw2 0 xesw2 I={ V(sw2)*I(L2) }
RXesw2 xesw2 0 0.01
CXqlt3 xqlt3 0 1
BXqlt3 0 xqlt3 I={ I(L3) }
RXqlt3 xqlt3 0 0.01
CXea3 xea3 0 1
BXea3 0 xea3 I={ V(rail2)*I(L3) }
RXea3 xea3 0 0.01
CXean3 xean3 0 1
BXean3 0 xean3 I={ V(a3)*I(L3) }
RXean3 xean3 0 0.01
CXeb3 xeb3 0 1
BXeb3 0 xeb3 I={ V(rail3)*I(L3) }
RXeb3 xeb3 0 0.01
CXer3 xer3 0 1
BXer3 0 xer3 I={ I(L3)*I(L3)*10 }
RXer3 xer3 0 0.01
CXesw3 xesw3 0 1
BXesw3 0 xesw3 I={ V(sw3)*I(L3) }
RXesw3 xesw3 0 0.01
CXqlt4 xqlt4 0 1
BXqlt4 0 xqlt4 I={ I(L4) }
RXqlt4 xqlt4 0 0.01
CXea4 xea4 0 1
BXea4 0 xea4 I={ V(rail3)*I(L4) }
RXea4 xea4 0 0.01
CXean4 xean4 0 1
BXean4 0 xean4 I={ V(a4)*I(L4) }
RXean4 xean4 0 0.01
CXeb4 xeb4 0 1
BXeb4 0 xeb4 I={ V(rail4)*I(L4) }
RXeb4 xeb4 0 0.01
CXer4 xer4 0 1
BXer4 0 xer4 I={ I(L4)*I(L4)*10 }
RXer4 xer4 0 0.01
CXesw4 xesw4 0 1
BXesw4 0 xesw4 I={ V(sw4)*I(L4) }
RXesw4 xesw4 0 0.01
CXqlt5 xqlt5 0 1
BXqlt5 0 xqlt5 I={ I(L5) }
RXqlt5 xqlt5 0 0.01
CXea5 xea5 0 1
BXea5 0 xea5 I={ V(rail4)*I(L5) }
RXea5 xea5 0 0.01
CXean5 xean5 0 1
BXean5 0 xean5 I={ V(a5)*I(L5) }
RXean5 xean5 0 0.01
CXeb5 xeb5 0 1
BXeb5 0 xeb5 I={ V(rail5)*I(L5) }
RXeb5 xeb5 0 0.01
CXer5 xer5 0 1
BXer5 0 xer5 I={ I(L5)*I(L5)*10 }
RXer5 xer5 0 0.01
CXesw5 xesw5 0 1
BXesw5 0 xesw5 I={ V(sw5)*I(L5) }
RXesw5 xesw5 0 0.01
CXqlt6 xqlt6 0 1
BXqlt6 0 xqlt6 I={ I(L6) }
RXqlt6 xqlt6 0 0.01
CXea6 xea6 0 1
BXea6 0 xea6 I={ V(rail5)*I(L6) }
RXea6 xea6 0 0.01
CXean6 xean6 0 1
BXean6 0 xean6 I={ V(a6)*I(L6) }
RXean6 xean6 0 0.01
CXeb6 xeb6 0 1
BXeb6 0 xeb6 I={ V(rail6)*I(L6) }
RXeb6 xeb6 0 0.01
CXer6 xer6 0 1
BXer6 0 xer6 I={ I(L6)*I(L6)*10 }
RXer6 xer6 0 0.01
CXesw6 xesw6 0 1
BXesw6 0 xesw6 I={ V(sw6)*I(L6) }
RXesw6 xesw6 0 0.01
CXqg1 xqg1 0 1
BXqg1 0 xqg1 I={ I(VMG1) }
RXqg1 xqg1 0 0.01
CXqg2 xqg2 0 1
BXqg2 0 xqg2 I={ I(VMG2) }
RXqg2 xqg2 0 0.01
CXqg3 xqg3 0 1
BXqg3 0 xqg3 I={ I(VMG3) }
RXqg3 xqg3 0 0.01
CXqg4 xqg4 0 1
BXqg4 0 xqg4 I={ I(VMG4) }
RXqg4 xqg4 0 0.01
CXqg5 xqg5 0 1
BXqg5 0 xqg5 I={ I(VMG5) }
RXqg5 xqg5 0 0.01
CXqg6 xqg6 0 1
BXqg6 0 xqg6 I={ I(VMG6) }
RXqg6 xqg6 0 0.01
CXqres xqres 0 1
BXqres 0 xqres I={ -I(VRES) }
RXqres xqres 0 0.01
CXqhi xqhi 0 1
BXqhi 0 xqhi I={ -I(VHI) }
RXqhi xqhi 0 0.01
CXqi1 xqi1 0 1
BXqi1 0 xqi1 I={ -(I(VI1_0)+I(VI1_1)+I(VI1_2)+I(VI1_3)+I(VI1_4)+I(VI1_5)+I(VI1_6)+I(VI1_7)) }
RXqi1 xqi1 0 0.01
CXegt xegt 0 1
BXegt 0 xegt I={ -V(gt1)*I(VGT1)-V(gtp1)*I(VGTP1)-V(pk1)*I(VPK1)-V(gt2)*I(VGT2)-V(gtp2)*I(VGTP2)-V(pk2)*I(VPK2)-V(gt3)*I(VGT3)-V(gtp3)*I(VGTP3)-V(pk3)*I(VPK3)-V(gt4)*I(VGT4)-V(gtp4)*I(VGTP4)-V(pk4)*I(VPK4)-V(gt5)*I(VGT5)-V(gtp5)*I(VGTP5)-V(pk5)*I(VPK5)-V(gt6)*I(VGT6)-V(gtp6)*I(VGTP6)-V(pk6)*I(VPK6) }
RXegt xegt 0 0.01
.ic V(res1)=1.2 V(rail1)=0 V(rail2)=0 V(rail3)=0 V(rail4)=0 V(rail5)=0 V(rail6)=0 V(a2)=0 V(a3)=0 V(a4)=0 V(a5)=0 V(a6)=0
.tran 0.1p 2500p 0 0.0884183p
.measure tran QLT1_Z FIND V(xqlt1) AT=1.500000p
.measure tran QLT1_B1 FIND V(xqlt1) AT=268.908060p
.measure tran QLT1_B2 FIND V(xqlt1) AT=610.635546p
.measure tran QLT1_B3 FIND V(xqlt1) AT=905.631066p
.measure tran QLT1_B4 FIND V(xqlt1) AT=1203.124186p
.measure tran QLT1_B5 FIND V(xqlt1) AT=1502.855261p
.measure tran QLT1_B6 FIND V(xqlt1) AT=1795.533996p
.measure tran QLT1_K1 FIND V(xqlt1) AT=499.000000p
.measure tran QLT1_K2 FIND V(xqlt1) AT=799.000000p
.measure tran QLT1_K3 FIND V(xqlt1) AT=1099.000000p
.measure tran QLT1_K4 FIND V(xqlt1) AT=1399.000000p
.measure tran QLT1_K5 FIND V(xqlt1) AT=1699.000000p
.measure tran QLT1_K6 FIND V(xqlt1) AT=2001.000000p
.measure tran QLT1_D FIND V(xqlt1) AT=2496.000000p
.measure tran EA1_Z FIND V(xea1) AT=1.500000p
.measure tran EA1_B1 FIND V(xea1) AT=268.908060p
.measure tran EA1_B2 FIND V(xea1) AT=610.635546p
.measure tran EA1_B3 FIND V(xea1) AT=905.631066p
.measure tran EA1_B4 FIND V(xea1) AT=1203.124186p
.measure tran EA1_B5 FIND V(xea1) AT=1502.855261p
.measure tran EA1_B6 FIND V(xea1) AT=1795.533996p
.measure tran EA1_K1 FIND V(xea1) AT=499.000000p
.measure tran EA1_K2 FIND V(xea1) AT=799.000000p
.measure tran EA1_K3 FIND V(xea1) AT=1099.000000p
.measure tran EA1_K4 FIND V(xea1) AT=1399.000000p
.measure tran EA1_K5 FIND V(xea1) AT=1699.000000p
.measure tran EA1_K6 FIND V(xea1) AT=2001.000000p
.measure tran EA1_D FIND V(xea1) AT=2496.000000p
.measure tran EAN1_Z FIND V(xean1) AT=1.500000p
.measure tran EAN1_B1 FIND V(xean1) AT=268.908060p
.measure tran EAN1_B2 FIND V(xean1) AT=610.635546p
.measure tran EAN1_B3 FIND V(xean1) AT=905.631066p
.measure tran EAN1_B4 FIND V(xean1) AT=1203.124186p
.measure tran EAN1_B5 FIND V(xean1) AT=1502.855261p
.measure tran EAN1_B6 FIND V(xean1) AT=1795.533996p
.measure tran EAN1_K1 FIND V(xean1) AT=499.000000p
.measure tran EAN1_K2 FIND V(xean1) AT=799.000000p
.measure tran EAN1_K3 FIND V(xean1) AT=1099.000000p
.measure tran EAN1_K4 FIND V(xean1) AT=1399.000000p
.measure tran EAN1_K5 FIND V(xean1) AT=1699.000000p
.measure tran EAN1_K6 FIND V(xean1) AT=2001.000000p
.measure tran EAN1_D FIND V(xean1) AT=2496.000000p
.measure tran EB1_Z FIND V(xeb1) AT=1.500000p
.measure tran EB1_B1 FIND V(xeb1) AT=268.908060p
.measure tran EB1_B2 FIND V(xeb1) AT=610.635546p
.measure tran EB1_B3 FIND V(xeb1) AT=905.631066p
.measure tran EB1_B4 FIND V(xeb1) AT=1203.124186p
.measure tran EB1_B5 FIND V(xeb1) AT=1502.855261p
.measure tran EB1_B6 FIND V(xeb1) AT=1795.533996p
.measure tran EB1_K1 FIND V(xeb1) AT=499.000000p
.measure tran EB1_K2 FIND V(xeb1) AT=799.000000p
.measure tran EB1_K3 FIND V(xeb1) AT=1099.000000p
.measure tran EB1_K4 FIND V(xeb1) AT=1399.000000p
.measure tran EB1_K5 FIND V(xeb1) AT=1699.000000p
.measure tran EB1_K6 FIND V(xeb1) AT=2001.000000p
.measure tran EB1_D FIND V(xeb1) AT=2496.000000p
.measure tran ER1_Z FIND V(xer1) AT=1.500000p
.measure tran ER1_B1 FIND V(xer1) AT=268.908060p
.measure tran ER1_B2 FIND V(xer1) AT=610.635546p
.measure tran ER1_B3 FIND V(xer1) AT=905.631066p
.measure tran ER1_B4 FIND V(xer1) AT=1203.124186p
.measure tran ER1_B5 FIND V(xer1) AT=1502.855261p
.measure tran ER1_B6 FIND V(xer1) AT=1795.533996p
.measure tran ER1_K1 FIND V(xer1) AT=499.000000p
.measure tran ER1_K2 FIND V(xer1) AT=799.000000p
.measure tran ER1_K3 FIND V(xer1) AT=1099.000000p
.measure tran ER1_K4 FIND V(xer1) AT=1399.000000p
.measure tran ER1_K5 FIND V(xer1) AT=1699.000000p
.measure tran ER1_K6 FIND V(xer1) AT=2001.000000p
.measure tran ER1_D FIND V(xer1) AT=2496.000000p
.measure tran ESW1_Z FIND V(xesw1) AT=1.500000p
.measure tran ESW1_B1 FIND V(xesw1) AT=268.908060p
.measure tran ESW1_B2 FIND V(xesw1) AT=610.635546p
.measure tran ESW1_B3 FIND V(xesw1) AT=905.631066p
.measure tran ESW1_B4 FIND V(xesw1) AT=1203.124186p
.measure tran ESW1_B5 FIND V(xesw1) AT=1502.855261p
.measure tran ESW1_B6 FIND V(xesw1) AT=1795.533996p
.measure tran ESW1_K1 FIND V(xesw1) AT=499.000000p
.measure tran ESW1_K2 FIND V(xesw1) AT=799.000000p
.measure tran ESW1_K3 FIND V(xesw1) AT=1099.000000p
.measure tran ESW1_K4 FIND V(xesw1) AT=1399.000000p
.measure tran ESW1_K5 FIND V(xesw1) AT=1699.000000p
.measure tran ESW1_K6 FIND V(xesw1) AT=2001.000000p
.measure tran ESW1_D FIND V(xesw1) AT=2496.000000p
.measure tran QLT2_Z FIND V(xqlt2) AT=1.500000p
.measure tran QLT2_B1 FIND V(xqlt2) AT=268.908060p
.measure tran QLT2_B2 FIND V(xqlt2) AT=610.635546p
.measure tran QLT2_B3 FIND V(xqlt2) AT=905.631066p
.measure tran QLT2_B4 FIND V(xqlt2) AT=1203.124186p
.measure tran QLT2_B5 FIND V(xqlt2) AT=1502.855261p
.measure tran QLT2_B6 FIND V(xqlt2) AT=1795.533996p
.measure tran QLT2_K1 FIND V(xqlt2) AT=499.000000p
.measure tran QLT2_K2 FIND V(xqlt2) AT=799.000000p
.measure tran QLT2_K3 FIND V(xqlt2) AT=1099.000000p
.measure tran QLT2_K4 FIND V(xqlt2) AT=1399.000000p
.measure tran QLT2_K5 FIND V(xqlt2) AT=1699.000000p
.measure tran QLT2_K6 FIND V(xqlt2) AT=2001.000000p
.measure tran QLT2_D FIND V(xqlt2) AT=2496.000000p
.measure tran EA2_Z FIND V(xea2) AT=1.500000p
.measure tran EA2_B1 FIND V(xea2) AT=268.908060p
.measure tran EA2_B2 FIND V(xea2) AT=610.635546p
.measure tran EA2_B3 FIND V(xea2) AT=905.631066p
.measure tran EA2_B4 FIND V(xea2) AT=1203.124186p
.measure tran EA2_B5 FIND V(xea2) AT=1502.855261p
.measure tran EA2_B6 FIND V(xea2) AT=1795.533996p
.measure tran EA2_K1 FIND V(xea2) AT=499.000000p
.measure tran EA2_K2 FIND V(xea2) AT=799.000000p
.measure tran EA2_K3 FIND V(xea2) AT=1099.000000p
.measure tran EA2_K4 FIND V(xea2) AT=1399.000000p
.measure tran EA2_K5 FIND V(xea2) AT=1699.000000p
.measure tran EA2_K6 FIND V(xea2) AT=2001.000000p
.measure tran EA2_D FIND V(xea2) AT=2496.000000p
.measure tran EAN2_Z FIND V(xean2) AT=1.500000p
.measure tran EAN2_B1 FIND V(xean2) AT=268.908060p
.measure tran EAN2_B2 FIND V(xean2) AT=610.635546p
.measure tran EAN2_B3 FIND V(xean2) AT=905.631066p
.measure tran EAN2_B4 FIND V(xean2) AT=1203.124186p
.measure tran EAN2_B5 FIND V(xean2) AT=1502.855261p
.measure tran EAN2_B6 FIND V(xean2) AT=1795.533996p
.measure tran EAN2_K1 FIND V(xean2) AT=499.000000p
.measure tran EAN2_K2 FIND V(xean2) AT=799.000000p
.measure tran EAN2_K3 FIND V(xean2) AT=1099.000000p
.measure tran EAN2_K4 FIND V(xean2) AT=1399.000000p
.measure tran EAN2_K5 FIND V(xean2) AT=1699.000000p
.measure tran EAN2_K6 FIND V(xean2) AT=2001.000000p
.measure tran EAN2_D FIND V(xean2) AT=2496.000000p
.measure tran EB2_Z FIND V(xeb2) AT=1.500000p
.measure tran EB2_B1 FIND V(xeb2) AT=268.908060p
.measure tran EB2_B2 FIND V(xeb2) AT=610.635546p
.measure tran EB2_B3 FIND V(xeb2) AT=905.631066p
.measure tran EB2_B4 FIND V(xeb2) AT=1203.124186p
.measure tran EB2_B5 FIND V(xeb2) AT=1502.855261p
.measure tran EB2_B6 FIND V(xeb2) AT=1795.533996p
.measure tran EB2_K1 FIND V(xeb2) AT=499.000000p
.measure tran EB2_K2 FIND V(xeb2) AT=799.000000p
.measure tran EB2_K3 FIND V(xeb2) AT=1099.000000p
.measure tran EB2_K4 FIND V(xeb2) AT=1399.000000p
.measure tran EB2_K5 FIND V(xeb2) AT=1699.000000p
.measure tran EB2_K6 FIND V(xeb2) AT=2001.000000p
.measure tran EB2_D FIND V(xeb2) AT=2496.000000p
.measure tran ER2_Z FIND V(xer2) AT=1.500000p
.measure tran ER2_B1 FIND V(xer2) AT=268.908060p
.measure tran ER2_B2 FIND V(xer2) AT=610.635546p
.measure tran ER2_B3 FIND V(xer2) AT=905.631066p
.measure tran ER2_B4 FIND V(xer2) AT=1203.124186p
.measure tran ER2_B5 FIND V(xer2) AT=1502.855261p
.measure tran ER2_B6 FIND V(xer2) AT=1795.533996p
.measure tran ER2_K1 FIND V(xer2) AT=499.000000p
.measure tran ER2_K2 FIND V(xer2) AT=799.000000p
.measure tran ER2_K3 FIND V(xer2) AT=1099.000000p
.measure tran ER2_K4 FIND V(xer2) AT=1399.000000p
.measure tran ER2_K5 FIND V(xer2) AT=1699.000000p
.measure tran ER2_K6 FIND V(xer2) AT=2001.000000p
.measure tran ER2_D FIND V(xer2) AT=2496.000000p
.measure tran ESW2_Z FIND V(xesw2) AT=1.500000p
.measure tran ESW2_B1 FIND V(xesw2) AT=268.908060p
.measure tran ESW2_B2 FIND V(xesw2) AT=610.635546p
.measure tran ESW2_B3 FIND V(xesw2) AT=905.631066p
.measure tran ESW2_B4 FIND V(xesw2) AT=1203.124186p
.measure tran ESW2_B5 FIND V(xesw2) AT=1502.855261p
.measure tran ESW2_B6 FIND V(xesw2) AT=1795.533996p
.measure tran ESW2_K1 FIND V(xesw2) AT=499.000000p
.measure tran ESW2_K2 FIND V(xesw2) AT=799.000000p
.measure tran ESW2_K3 FIND V(xesw2) AT=1099.000000p
.measure tran ESW2_K4 FIND V(xesw2) AT=1399.000000p
.measure tran ESW2_K5 FIND V(xesw2) AT=1699.000000p
.measure tran ESW2_K6 FIND V(xesw2) AT=2001.000000p
.measure tran ESW2_D FIND V(xesw2) AT=2496.000000p
.measure tran QLT3_Z FIND V(xqlt3) AT=1.500000p
.measure tran QLT3_B1 FIND V(xqlt3) AT=268.908060p
.measure tran QLT3_B2 FIND V(xqlt3) AT=610.635546p
.measure tran QLT3_B3 FIND V(xqlt3) AT=905.631066p
.measure tran QLT3_B4 FIND V(xqlt3) AT=1203.124186p
.measure tran QLT3_B5 FIND V(xqlt3) AT=1502.855261p
.measure tran QLT3_B6 FIND V(xqlt3) AT=1795.533996p
.measure tran QLT3_K1 FIND V(xqlt3) AT=499.000000p
.measure tran QLT3_K2 FIND V(xqlt3) AT=799.000000p
.measure tran QLT3_K3 FIND V(xqlt3) AT=1099.000000p
.measure tran QLT3_K4 FIND V(xqlt3) AT=1399.000000p
.measure tran QLT3_K5 FIND V(xqlt3) AT=1699.000000p
.measure tran QLT3_K6 FIND V(xqlt3) AT=2001.000000p
.measure tran QLT3_D FIND V(xqlt3) AT=2496.000000p
.measure tran EA3_Z FIND V(xea3) AT=1.500000p
.measure tran EA3_B1 FIND V(xea3) AT=268.908060p
.measure tran EA3_B2 FIND V(xea3) AT=610.635546p
.measure tran EA3_B3 FIND V(xea3) AT=905.631066p
.measure tran EA3_B4 FIND V(xea3) AT=1203.124186p
.measure tran EA3_B5 FIND V(xea3) AT=1502.855261p
.measure tran EA3_B6 FIND V(xea3) AT=1795.533996p
.measure tran EA3_K1 FIND V(xea3) AT=499.000000p
.measure tran EA3_K2 FIND V(xea3) AT=799.000000p
.measure tran EA3_K3 FIND V(xea3) AT=1099.000000p
.measure tran EA3_K4 FIND V(xea3) AT=1399.000000p
.measure tran EA3_K5 FIND V(xea3) AT=1699.000000p
.measure tran EA3_K6 FIND V(xea3) AT=2001.000000p
.measure tran EA3_D FIND V(xea3) AT=2496.000000p
.measure tran EAN3_Z FIND V(xean3) AT=1.500000p
.measure tran EAN3_B1 FIND V(xean3) AT=268.908060p
.measure tran EAN3_B2 FIND V(xean3) AT=610.635546p
.measure tran EAN3_B3 FIND V(xean3) AT=905.631066p
.measure tran EAN3_B4 FIND V(xean3) AT=1203.124186p
.measure tran EAN3_B5 FIND V(xean3) AT=1502.855261p
.measure tran EAN3_B6 FIND V(xean3) AT=1795.533996p
.measure tran EAN3_K1 FIND V(xean3) AT=499.000000p
.measure tran EAN3_K2 FIND V(xean3) AT=799.000000p
.measure tran EAN3_K3 FIND V(xean3) AT=1099.000000p
.measure tran EAN3_K4 FIND V(xean3) AT=1399.000000p
.measure tran EAN3_K5 FIND V(xean3) AT=1699.000000p
.measure tran EAN3_K6 FIND V(xean3) AT=2001.000000p
.measure tran EAN3_D FIND V(xean3) AT=2496.000000p
.measure tran EB3_Z FIND V(xeb3) AT=1.500000p
.measure tran EB3_B1 FIND V(xeb3) AT=268.908060p
.measure tran EB3_B2 FIND V(xeb3) AT=610.635546p
.measure tran EB3_B3 FIND V(xeb3) AT=905.631066p
.measure tran EB3_B4 FIND V(xeb3) AT=1203.124186p
.measure tran EB3_B5 FIND V(xeb3) AT=1502.855261p
.measure tran EB3_B6 FIND V(xeb3) AT=1795.533996p
.measure tran EB3_K1 FIND V(xeb3) AT=499.000000p
.measure tran EB3_K2 FIND V(xeb3) AT=799.000000p
.measure tran EB3_K3 FIND V(xeb3) AT=1099.000000p
.measure tran EB3_K4 FIND V(xeb3) AT=1399.000000p
.measure tran EB3_K5 FIND V(xeb3) AT=1699.000000p
.measure tran EB3_K6 FIND V(xeb3) AT=2001.000000p
.measure tran EB3_D FIND V(xeb3) AT=2496.000000p
.measure tran ER3_Z FIND V(xer3) AT=1.500000p
.measure tran ER3_B1 FIND V(xer3) AT=268.908060p
.measure tran ER3_B2 FIND V(xer3) AT=610.635546p
.measure tran ER3_B3 FIND V(xer3) AT=905.631066p
.measure tran ER3_B4 FIND V(xer3) AT=1203.124186p
.measure tran ER3_B5 FIND V(xer3) AT=1502.855261p
.measure tran ER3_B6 FIND V(xer3) AT=1795.533996p
.measure tran ER3_K1 FIND V(xer3) AT=499.000000p
.measure tran ER3_K2 FIND V(xer3) AT=799.000000p
.measure tran ER3_K3 FIND V(xer3) AT=1099.000000p
.measure tran ER3_K4 FIND V(xer3) AT=1399.000000p
.measure tran ER3_K5 FIND V(xer3) AT=1699.000000p
.measure tran ER3_K6 FIND V(xer3) AT=2001.000000p
.measure tran ER3_D FIND V(xer3) AT=2496.000000p
.measure tran ESW3_Z FIND V(xesw3) AT=1.500000p
.measure tran ESW3_B1 FIND V(xesw3) AT=268.908060p
.measure tran ESW3_B2 FIND V(xesw3) AT=610.635546p
.measure tran ESW3_B3 FIND V(xesw3) AT=905.631066p
.measure tran ESW3_B4 FIND V(xesw3) AT=1203.124186p
.measure tran ESW3_B5 FIND V(xesw3) AT=1502.855261p
.measure tran ESW3_B6 FIND V(xesw3) AT=1795.533996p
.measure tran ESW3_K1 FIND V(xesw3) AT=499.000000p
.measure tran ESW3_K2 FIND V(xesw3) AT=799.000000p
.measure tran ESW3_K3 FIND V(xesw3) AT=1099.000000p
.measure tran ESW3_K4 FIND V(xesw3) AT=1399.000000p
.measure tran ESW3_K5 FIND V(xesw3) AT=1699.000000p
.measure tran ESW3_K6 FIND V(xesw3) AT=2001.000000p
.measure tran ESW3_D FIND V(xesw3) AT=2496.000000p
.measure tran QLT4_Z FIND V(xqlt4) AT=1.500000p
.measure tran QLT4_B1 FIND V(xqlt4) AT=268.908060p
.measure tran QLT4_B2 FIND V(xqlt4) AT=610.635546p
.measure tran QLT4_B3 FIND V(xqlt4) AT=905.631066p
.measure tran QLT4_B4 FIND V(xqlt4) AT=1203.124186p
.measure tran QLT4_B5 FIND V(xqlt4) AT=1502.855261p
.measure tran QLT4_B6 FIND V(xqlt4) AT=1795.533996p
.measure tran QLT4_K1 FIND V(xqlt4) AT=499.000000p
.measure tran QLT4_K2 FIND V(xqlt4) AT=799.000000p
.measure tran QLT4_K3 FIND V(xqlt4) AT=1099.000000p
.measure tran QLT4_K4 FIND V(xqlt4) AT=1399.000000p
.measure tran QLT4_K5 FIND V(xqlt4) AT=1699.000000p
.measure tran QLT4_K6 FIND V(xqlt4) AT=2001.000000p
.measure tran QLT4_D FIND V(xqlt4) AT=2496.000000p
.measure tran EA4_Z FIND V(xea4) AT=1.500000p
.measure tran EA4_B1 FIND V(xea4) AT=268.908060p
.measure tran EA4_B2 FIND V(xea4) AT=610.635546p
.measure tran EA4_B3 FIND V(xea4) AT=905.631066p
.measure tran EA4_B4 FIND V(xea4) AT=1203.124186p
.measure tran EA4_B5 FIND V(xea4) AT=1502.855261p
.measure tran EA4_B6 FIND V(xea4) AT=1795.533996p
.measure tran EA4_K1 FIND V(xea4) AT=499.000000p
.measure tran EA4_K2 FIND V(xea4) AT=799.000000p
.measure tran EA4_K3 FIND V(xea4) AT=1099.000000p
.measure tran EA4_K4 FIND V(xea4) AT=1399.000000p
.measure tran EA4_K5 FIND V(xea4) AT=1699.000000p
.measure tran EA4_K6 FIND V(xea4) AT=2001.000000p
.measure tran EA4_D FIND V(xea4) AT=2496.000000p
.measure tran EAN4_Z FIND V(xean4) AT=1.500000p
.measure tran EAN4_B1 FIND V(xean4) AT=268.908060p
.measure tran EAN4_B2 FIND V(xean4) AT=610.635546p
.measure tran EAN4_B3 FIND V(xean4) AT=905.631066p
.measure tran EAN4_B4 FIND V(xean4) AT=1203.124186p
.measure tran EAN4_B5 FIND V(xean4) AT=1502.855261p
.measure tran EAN4_B6 FIND V(xean4) AT=1795.533996p
.measure tran EAN4_K1 FIND V(xean4) AT=499.000000p
.measure tran EAN4_K2 FIND V(xean4) AT=799.000000p
.measure tran EAN4_K3 FIND V(xean4) AT=1099.000000p
.measure tran EAN4_K4 FIND V(xean4) AT=1399.000000p
.measure tran EAN4_K5 FIND V(xean4) AT=1699.000000p
.measure tran EAN4_K6 FIND V(xean4) AT=2001.000000p
.measure tran EAN4_D FIND V(xean4) AT=2496.000000p
.measure tran EB4_Z FIND V(xeb4) AT=1.500000p
.measure tran EB4_B1 FIND V(xeb4) AT=268.908060p
.measure tran EB4_B2 FIND V(xeb4) AT=610.635546p
.measure tran EB4_B3 FIND V(xeb4) AT=905.631066p
.measure tran EB4_B4 FIND V(xeb4) AT=1203.124186p
.measure tran EB4_B5 FIND V(xeb4) AT=1502.855261p
.measure tran EB4_B6 FIND V(xeb4) AT=1795.533996p
.measure tran EB4_K1 FIND V(xeb4) AT=499.000000p
.measure tran EB4_K2 FIND V(xeb4) AT=799.000000p
.measure tran EB4_K3 FIND V(xeb4) AT=1099.000000p
.measure tran EB4_K4 FIND V(xeb4) AT=1399.000000p
.measure tran EB4_K5 FIND V(xeb4) AT=1699.000000p
.measure tran EB4_K6 FIND V(xeb4) AT=2001.000000p
.measure tran EB4_D FIND V(xeb4) AT=2496.000000p
.measure tran ER4_Z FIND V(xer4) AT=1.500000p
.measure tran ER4_B1 FIND V(xer4) AT=268.908060p
.measure tran ER4_B2 FIND V(xer4) AT=610.635546p
.measure tran ER4_B3 FIND V(xer4) AT=905.631066p
.measure tran ER4_B4 FIND V(xer4) AT=1203.124186p
.measure tran ER4_B5 FIND V(xer4) AT=1502.855261p
.measure tran ER4_B6 FIND V(xer4) AT=1795.533996p
.measure tran ER4_K1 FIND V(xer4) AT=499.000000p
.measure tran ER4_K2 FIND V(xer4) AT=799.000000p
.measure tran ER4_K3 FIND V(xer4) AT=1099.000000p
.measure tran ER4_K4 FIND V(xer4) AT=1399.000000p
.measure tran ER4_K5 FIND V(xer4) AT=1699.000000p
.measure tran ER4_K6 FIND V(xer4) AT=2001.000000p
.measure tran ER4_D FIND V(xer4) AT=2496.000000p
.measure tran ESW4_Z FIND V(xesw4) AT=1.500000p
.measure tran ESW4_B1 FIND V(xesw4) AT=268.908060p
.measure tran ESW4_B2 FIND V(xesw4) AT=610.635546p
.measure tran ESW4_B3 FIND V(xesw4) AT=905.631066p
.measure tran ESW4_B4 FIND V(xesw4) AT=1203.124186p
.measure tran ESW4_B5 FIND V(xesw4) AT=1502.855261p
.measure tran ESW4_B6 FIND V(xesw4) AT=1795.533996p
.measure tran ESW4_K1 FIND V(xesw4) AT=499.000000p
.measure tran ESW4_K2 FIND V(xesw4) AT=799.000000p
.measure tran ESW4_K3 FIND V(xesw4) AT=1099.000000p
.measure tran ESW4_K4 FIND V(xesw4) AT=1399.000000p
.measure tran ESW4_K5 FIND V(xesw4) AT=1699.000000p
.measure tran ESW4_K6 FIND V(xesw4) AT=2001.000000p
.measure tran ESW4_D FIND V(xesw4) AT=2496.000000p
.measure tran QLT5_Z FIND V(xqlt5) AT=1.500000p
.measure tran QLT5_B1 FIND V(xqlt5) AT=268.908060p
.measure tran QLT5_B2 FIND V(xqlt5) AT=610.635546p
.measure tran QLT5_B3 FIND V(xqlt5) AT=905.631066p
.measure tran QLT5_B4 FIND V(xqlt5) AT=1203.124186p
.measure tran QLT5_B5 FIND V(xqlt5) AT=1502.855261p
.measure tran QLT5_B6 FIND V(xqlt5) AT=1795.533996p
.measure tran QLT5_K1 FIND V(xqlt5) AT=499.000000p
.measure tran QLT5_K2 FIND V(xqlt5) AT=799.000000p
.measure tran QLT5_K3 FIND V(xqlt5) AT=1099.000000p
.measure tran QLT5_K4 FIND V(xqlt5) AT=1399.000000p
.measure tran QLT5_K5 FIND V(xqlt5) AT=1699.000000p
.measure tran QLT5_K6 FIND V(xqlt5) AT=2001.000000p
.measure tran QLT5_D FIND V(xqlt5) AT=2496.000000p
.measure tran EA5_Z FIND V(xea5) AT=1.500000p
.measure tran EA5_B1 FIND V(xea5) AT=268.908060p
.measure tran EA5_B2 FIND V(xea5) AT=610.635546p
.measure tran EA5_B3 FIND V(xea5) AT=905.631066p
.measure tran EA5_B4 FIND V(xea5) AT=1203.124186p
.measure tran EA5_B5 FIND V(xea5) AT=1502.855261p
.measure tran EA5_B6 FIND V(xea5) AT=1795.533996p
.measure tran EA5_K1 FIND V(xea5) AT=499.000000p
.measure tran EA5_K2 FIND V(xea5) AT=799.000000p
.measure tran EA5_K3 FIND V(xea5) AT=1099.000000p
.measure tran EA5_K4 FIND V(xea5) AT=1399.000000p
.measure tran EA5_K5 FIND V(xea5) AT=1699.000000p
.measure tran EA5_K6 FIND V(xea5) AT=2001.000000p
.measure tran EA5_D FIND V(xea5) AT=2496.000000p
.measure tran EAN5_Z FIND V(xean5) AT=1.500000p
.measure tran EAN5_B1 FIND V(xean5) AT=268.908060p
.measure tran EAN5_B2 FIND V(xean5) AT=610.635546p
.measure tran EAN5_B3 FIND V(xean5) AT=905.631066p
.measure tran EAN5_B4 FIND V(xean5) AT=1203.124186p
.measure tran EAN5_B5 FIND V(xean5) AT=1502.855261p
.measure tran EAN5_B6 FIND V(xean5) AT=1795.533996p
.measure tran EAN5_K1 FIND V(xean5) AT=499.000000p
.measure tran EAN5_K2 FIND V(xean5) AT=799.000000p
.measure tran EAN5_K3 FIND V(xean5) AT=1099.000000p
.measure tran EAN5_K4 FIND V(xean5) AT=1399.000000p
.measure tran EAN5_K5 FIND V(xean5) AT=1699.000000p
.measure tran EAN5_K6 FIND V(xean5) AT=2001.000000p
.measure tran EAN5_D FIND V(xean5) AT=2496.000000p
.measure tran EB5_Z FIND V(xeb5) AT=1.500000p
.measure tran EB5_B1 FIND V(xeb5) AT=268.908060p
.measure tran EB5_B2 FIND V(xeb5) AT=610.635546p
.measure tran EB5_B3 FIND V(xeb5) AT=905.631066p
.measure tran EB5_B4 FIND V(xeb5) AT=1203.124186p
.measure tran EB5_B5 FIND V(xeb5) AT=1502.855261p
.measure tran EB5_B6 FIND V(xeb5) AT=1795.533996p
.measure tran EB5_K1 FIND V(xeb5) AT=499.000000p
.measure tran EB5_K2 FIND V(xeb5) AT=799.000000p
.measure tran EB5_K3 FIND V(xeb5) AT=1099.000000p
.measure tran EB5_K4 FIND V(xeb5) AT=1399.000000p
.measure tran EB5_K5 FIND V(xeb5) AT=1699.000000p
.measure tran EB5_K6 FIND V(xeb5) AT=2001.000000p
.measure tran EB5_D FIND V(xeb5) AT=2496.000000p
.measure tran ER5_Z FIND V(xer5) AT=1.500000p
.measure tran ER5_B1 FIND V(xer5) AT=268.908060p
.measure tran ER5_B2 FIND V(xer5) AT=610.635546p
.measure tran ER5_B3 FIND V(xer5) AT=905.631066p
.measure tran ER5_B4 FIND V(xer5) AT=1203.124186p
.measure tran ER5_B5 FIND V(xer5) AT=1502.855261p
.measure tran ER5_B6 FIND V(xer5) AT=1795.533996p
.measure tran ER5_K1 FIND V(xer5) AT=499.000000p
.measure tran ER5_K2 FIND V(xer5) AT=799.000000p
.measure tran ER5_K3 FIND V(xer5) AT=1099.000000p
.measure tran ER5_K4 FIND V(xer5) AT=1399.000000p
.measure tran ER5_K5 FIND V(xer5) AT=1699.000000p
.measure tran ER5_K6 FIND V(xer5) AT=2001.000000p
.measure tran ER5_D FIND V(xer5) AT=2496.000000p
.measure tran ESW5_Z FIND V(xesw5) AT=1.500000p
.measure tran ESW5_B1 FIND V(xesw5) AT=268.908060p
.measure tran ESW5_B2 FIND V(xesw5) AT=610.635546p
.measure tran ESW5_B3 FIND V(xesw5) AT=905.631066p
.measure tran ESW5_B4 FIND V(xesw5) AT=1203.124186p
.measure tran ESW5_B5 FIND V(xesw5) AT=1502.855261p
.measure tran ESW5_B6 FIND V(xesw5) AT=1795.533996p
.measure tran ESW5_K1 FIND V(xesw5) AT=499.000000p
.measure tran ESW5_K2 FIND V(xesw5) AT=799.000000p
.measure tran ESW5_K3 FIND V(xesw5) AT=1099.000000p
.measure tran ESW5_K4 FIND V(xesw5) AT=1399.000000p
.measure tran ESW5_K5 FIND V(xesw5) AT=1699.000000p
.measure tran ESW5_K6 FIND V(xesw5) AT=2001.000000p
.measure tran ESW5_D FIND V(xesw5) AT=2496.000000p
.measure tran QLT6_Z FIND V(xqlt6) AT=1.500000p
.measure tran QLT6_B1 FIND V(xqlt6) AT=268.908060p
.measure tran QLT6_B2 FIND V(xqlt6) AT=610.635546p
.measure tran QLT6_B3 FIND V(xqlt6) AT=905.631066p
.measure tran QLT6_B4 FIND V(xqlt6) AT=1203.124186p
.measure tran QLT6_B5 FIND V(xqlt6) AT=1502.855261p
.measure tran QLT6_B6 FIND V(xqlt6) AT=1795.533996p
.measure tran QLT6_K1 FIND V(xqlt6) AT=499.000000p
.measure tran QLT6_K2 FIND V(xqlt6) AT=799.000000p
.measure tran QLT6_K3 FIND V(xqlt6) AT=1099.000000p
.measure tran QLT6_K4 FIND V(xqlt6) AT=1399.000000p
.measure tran QLT6_K5 FIND V(xqlt6) AT=1699.000000p
.measure tran QLT6_K6 FIND V(xqlt6) AT=2001.000000p
.measure tran QLT6_D FIND V(xqlt6) AT=2496.000000p
.measure tran EA6_Z FIND V(xea6) AT=1.500000p
.measure tran EA6_B1 FIND V(xea6) AT=268.908060p
.measure tran EA6_B2 FIND V(xea6) AT=610.635546p
.measure tran EA6_B3 FIND V(xea6) AT=905.631066p
.measure tran EA6_B4 FIND V(xea6) AT=1203.124186p
.measure tran EA6_B5 FIND V(xea6) AT=1502.855261p
.measure tran EA6_B6 FIND V(xea6) AT=1795.533996p
.measure tran EA6_K1 FIND V(xea6) AT=499.000000p
.measure tran EA6_K2 FIND V(xea6) AT=799.000000p
.measure tran EA6_K3 FIND V(xea6) AT=1099.000000p
.measure tran EA6_K4 FIND V(xea6) AT=1399.000000p
.measure tran EA6_K5 FIND V(xea6) AT=1699.000000p
.measure tran EA6_K6 FIND V(xea6) AT=2001.000000p
.measure tran EA6_D FIND V(xea6) AT=2496.000000p
.measure tran EAN6_Z FIND V(xean6) AT=1.500000p
.measure tran EAN6_B1 FIND V(xean6) AT=268.908060p
.measure tran EAN6_B2 FIND V(xean6) AT=610.635546p
.measure tran EAN6_B3 FIND V(xean6) AT=905.631066p
.measure tran EAN6_B4 FIND V(xean6) AT=1203.124186p
.measure tran EAN6_B5 FIND V(xean6) AT=1502.855261p
.measure tran EAN6_B6 FIND V(xean6) AT=1795.533996p
.measure tran EAN6_K1 FIND V(xean6) AT=499.000000p
.measure tran EAN6_K2 FIND V(xean6) AT=799.000000p
.measure tran EAN6_K3 FIND V(xean6) AT=1099.000000p
.measure tran EAN6_K4 FIND V(xean6) AT=1399.000000p
.measure tran EAN6_K5 FIND V(xean6) AT=1699.000000p
.measure tran EAN6_K6 FIND V(xean6) AT=2001.000000p
.measure tran EAN6_D FIND V(xean6) AT=2496.000000p
.measure tran EB6_Z FIND V(xeb6) AT=1.500000p
.measure tran EB6_B1 FIND V(xeb6) AT=268.908060p
.measure tran EB6_B2 FIND V(xeb6) AT=610.635546p
.measure tran EB6_B3 FIND V(xeb6) AT=905.631066p
.measure tran EB6_B4 FIND V(xeb6) AT=1203.124186p
.measure tran EB6_B5 FIND V(xeb6) AT=1502.855261p
.measure tran EB6_B6 FIND V(xeb6) AT=1795.533996p
.measure tran EB6_K1 FIND V(xeb6) AT=499.000000p
.measure tran EB6_K2 FIND V(xeb6) AT=799.000000p
.measure tran EB6_K3 FIND V(xeb6) AT=1099.000000p
.measure tran EB6_K4 FIND V(xeb6) AT=1399.000000p
.measure tran EB6_K5 FIND V(xeb6) AT=1699.000000p
.measure tran EB6_K6 FIND V(xeb6) AT=2001.000000p
.measure tran EB6_D FIND V(xeb6) AT=2496.000000p
.measure tran ER6_Z FIND V(xer6) AT=1.500000p
.measure tran ER6_B1 FIND V(xer6) AT=268.908060p
.measure tran ER6_B2 FIND V(xer6) AT=610.635546p
.measure tran ER6_B3 FIND V(xer6) AT=905.631066p
.measure tran ER6_B4 FIND V(xer6) AT=1203.124186p
.measure tran ER6_B5 FIND V(xer6) AT=1502.855261p
.measure tran ER6_B6 FIND V(xer6) AT=1795.533996p
.measure tran ER6_K1 FIND V(xer6) AT=499.000000p
.measure tran ER6_K2 FIND V(xer6) AT=799.000000p
.measure tran ER6_K3 FIND V(xer6) AT=1099.000000p
.measure tran ER6_K4 FIND V(xer6) AT=1399.000000p
.measure tran ER6_K5 FIND V(xer6) AT=1699.000000p
.measure tran ER6_K6 FIND V(xer6) AT=2001.000000p
.measure tran ER6_D FIND V(xer6) AT=2496.000000p
.measure tran ESW6_Z FIND V(xesw6) AT=1.500000p
.measure tran ESW6_B1 FIND V(xesw6) AT=268.908060p
.measure tran ESW6_B2 FIND V(xesw6) AT=610.635546p
.measure tran ESW6_B3 FIND V(xesw6) AT=905.631066p
.measure tran ESW6_B4 FIND V(xesw6) AT=1203.124186p
.measure tran ESW6_B5 FIND V(xesw6) AT=1502.855261p
.measure tran ESW6_B6 FIND V(xesw6) AT=1795.533996p
.measure tran ESW6_K1 FIND V(xesw6) AT=499.000000p
.measure tran ESW6_K2 FIND V(xesw6) AT=799.000000p
.measure tran ESW6_K3 FIND V(xesw6) AT=1099.000000p
.measure tran ESW6_K4 FIND V(xesw6) AT=1399.000000p
.measure tran ESW6_K5 FIND V(xesw6) AT=1699.000000p
.measure tran ESW6_K6 FIND V(xesw6) AT=2001.000000p
.measure tran ESW6_D FIND V(xesw6) AT=2496.000000p
.measure tran QG1_Z FIND V(xqg1) AT=1.500000p
.measure tran QG1_B1 FIND V(xqg1) AT=268.908060p
.measure tran QG1_B2 FIND V(xqg1) AT=610.635546p
.measure tran QG1_B3 FIND V(xqg1) AT=905.631066p
.measure tran QG1_B4 FIND V(xqg1) AT=1203.124186p
.measure tran QG1_B5 FIND V(xqg1) AT=1502.855261p
.measure tran QG1_B6 FIND V(xqg1) AT=1795.533996p
.measure tran QG1_K1 FIND V(xqg1) AT=499.000000p
.measure tran QG1_K2 FIND V(xqg1) AT=799.000000p
.measure tran QG1_K3 FIND V(xqg1) AT=1099.000000p
.measure tran QG1_K4 FIND V(xqg1) AT=1399.000000p
.measure tran QG1_K5 FIND V(xqg1) AT=1699.000000p
.measure tran QG1_K6 FIND V(xqg1) AT=2001.000000p
.measure tran QG1_D FIND V(xqg1) AT=2496.000000p
.measure tran QG2_Z FIND V(xqg2) AT=1.500000p
.measure tran QG2_B1 FIND V(xqg2) AT=268.908060p
.measure tran QG2_B2 FIND V(xqg2) AT=610.635546p
.measure tran QG2_B3 FIND V(xqg2) AT=905.631066p
.measure tran QG2_B4 FIND V(xqg2) AT=1203.124186p
.measure tran QG2_B5 FIND V(xqg2) AT=1502.855261p
.measure tran QG2_B6 FIND V(xqg2) AT=1795.533996p
.measure tran QG2_K1 FIND V(xqg2) AT=499.000000p
.measure tran QG2_K2 FIND V(xqg2) AT=799.000000p
.measure tran QG2_K3 FIND V(xqg2) AT=1099.000000p
.measure tran QG2_K4 FIND V(xqg2) AT=1399.000000p
.measure tran QG2_K5 FIND V(xqg2) AT=1699.000000p
.measure tran QG2_K6 FIND V(xqg2) AT=2001.000000p
.measure tran QG2_D FIND V(xqg2) AT=2496.000000p
.measure tran QG3_Z FIND V(xqg3) AT=1.500000p
.measure tran QG3_B1 FIND V(xqg3) AT=268.908060p
.measure tran QG3_B2 FIND V(xqg3) AT=610.635546p
.measure tran QG3_B3 FIND V(xqg3) AT=905.631066p
.measure tran QG3_B4 FIND V(xqg3) AT=1203.124186p
.measure tran QG3_B5 FIND V(xqg3) AT=1502.855261p
.measure tran QG3_B6 FIND V(xqg3) AT=1795.533996p
.measure tran QG3_K1 FIND V(xqg3) AT=499.000000p
.measure tran QG3_K2 FIND V(xqg3) AT=799.000000p
.measure tran QG3_K3 FIND V(xqg3) AT=1099.000000p
.measure tran QG3_K4 FIND V(xqg3) AT=1399.000000p
.measure tran QG3_K5 FIND V(xqg3) AT=1699.000000p
.measure tran QG3_K6 FIND V(xqg3) AT=2001.000000p
.measure tran QG3_D FIND V(xqg3) AT=2496.000000p
.measure tran QG4_Z FIND V(xqg4) AT=1.500000p
.measure tran QG4_B1 FIND V(xqg4) AT=268.908060p
.measure tran QG4_B2 FIND V(xqg4) AT=610.635546p
.measure tran QG4_B3 FIND V(xqg4) AT=905.631066p
.measure tran QG4_B4 FIND V(xqg4) AT=1203.124186p
.measure tran QG4_B5 FIND V(xqg4) AT=1502.855261p
.measure tran QG4_B6 FIND V(xqg4) AT=1795.533996p
.measure tran QG4_K1 FIND V(xqg4) AT=499.000000p
.measure tran QG4_K2 FIND V(xqg4) AT=799.000000p
.measure tran QG4_K3 FIND V(xqg4) AT=1099.000000p
.measure tran QG4_K4 FIND V(xqg4) AT=1399.000000p
.measure tran QG4_K5 FIND V(xqg4) AT=1699.000000p
.measure tran QG4_K6 FIND V(xqg4) AT=2001.000000p
.measure tran QG4_D FIND V(xqg4) AT=2496.000000p
.measure tran QG5_Z FIND V(xqg5) AT=1.500000p
.measure tran QG5_B1 FIND V(xqg5) AT=268.908060p
.measure tran QG5_B2 FIND V(xqg5) AT=610.635546p
.measure tran QG5_B3 FIND V(xqg5) AT=905.631066p
.measure tran QG5_B4 FIND V(xqg5) AT=1203.124186p
.measure tran QG5_B5 FIND V(xqg5) AT=1502.855261p
.measure tran QG5_B6 FIND V(xqg5) AT=1795.533996p
.measure tran QG5_K1 FIND V(xqg5) AT=499.000000p
.measure tran QG5_K2 FIND V(xqg5) AT=799.000000p
.measure tran QG5_K3 FIND V(xqg5) AT=1099.000000p
.measure tran QG5_K4 FIND V(xqg5) AT=1399.000000p
.measure tran QG5_K5 FIND V(xqg5) AT=1699.000000p
.measure tran QG5_K6 FIND V(xqg5) AT=2001.000000p
.measure tran QG5_D FIND V(xqg5) AT=2496.000000p
.measure tran QG6_Z FIND V(xqg6) AT=1.500000p
.measure tran QG6_B1 FIND V(xqg6) AT=268.908060p
.measure tran QG6_B2 FIND V(xqg6) AT=610.635546p
.measure tran QG6_B3 FIND V(xqg6) AT=905.631066p
.measure tran QG6_B4 FIND V(xqg6) AT=1203.124186p
.measure tran QG6_B5 FIND V(xqg6) AT=1502.855261p
.measure tran QG6_B6 FIND V(xqg6) AT=1795.533996p
.measure tran QG6_K1 FIND V(xqg6) AT=499.000000p
.measure tran QG6_K2 FIND V(xqg6) AT=799.000000p
.measure tran QG6_K3 FIND V(xqg6) AT=1099.000000p
.measure tran QG6_K4 FIND V(xqg6) AT=1399.000000p
.measure tran QG6_K5 FIND V(xqg6) AT=1699.000000p
.measure tran QG6_K6 FIND V(xqg6) AT=2001.000000p
.measure tran QG6_D FIND V(xqg6) AT=2496.000000p
.measure tran QRES_Z FIND V(xqres) AT=1.500000p
.measure tran QRES_B1 FIND V(xqres) AT=268.908060p
.measure tran QRES_B2 FIND V(xqres) AT=610.635546p
.measure tran QRES_B3 FIND V(xqres) AT=905.631066p
.measure tran QRES_B4 FIND V(xqres) AT=1203.124186p
.measure tran QRES_B5 FIND V(xqres) AT=1502.855261p
.measure tran QRES_B6 FIND V(xqres) AT=1795.533996p
.measure tran QRES_K1 FIND V(xqres) AT=499.000000p
.measure tran QRES_K2 FIND V(xqres) AT=799.000000p
.measure tran QRES_K3 FIND V(xqres) AT=1099.000000p
.measure tran QRES_K4 FIND V(xqres) AT=1399.000000p
.measure tran QRES_K5 FIND V(xqres) AT=1699.000000p
.measure tran QRES_K6 FIND V(xqres) AT=2001.000000p
.measure tran QRES_D FIND V(xqres) AT=2496.000000p
.measure tran QHI_Z FIND V(xqhi) AT=1.500000p
.measure tran QHI_B1 FIND V(xqhi) AT=268.908060p
.measure tran QHI_B2 FIND V(xqhi) AT=610.635546p
.measure tran QHI_B3 FIND V(xqhi) AT=905.631066p
.measure tran QHI_B4 FIND V(xqhi) AT=1203.124186p
.measure tran QHI_B5 FIND V(xqhi) AT=1502.855261p
.measure tran QHI_B6 FIND V(xqhi) AT=1795.533996p
.measure tran QHI_K1 FIND V(xqhi) AT=499.000000p
.measure tran QHI_K2 FIND V(xqhi) AT=799.000000p
.measure tran QHI_K3 FIND V(xqhi) AT=1099.000000p
.measure tran QHI_K4 FIND V(xqhi) AT=1399.000000p
.measure tran QHI_K5 FIND V(xqhi) AT=1699.000000p
.measure tran QHI_K6 FIND V(xqhi) AT=2001.000000p
.measure tran QHI_D FIND V(xqhi) AT=2496.000000p
.measure tran QI1_Z FIND V(xqi1) AT=1.500000p
.measure tran QI1_B1 FIND V(xqi1) AT=268.908060p
.measure tran QI1_B2 FIND V(xqi1) AT=610.635546p
.measure tran QI1_B3 FIND V(xqi1) AT=905.631066p
.measure tran QI1_B4 FIND V(xqi1) AT=1203.124186p
.measure tran QI1_B5 FIND V(xqi1) AT=1502.855261p
.measure tran QI1_B6 FIND V(xqi1) AT=1795.533996p
.measure tran QI1_K1 FIND V(xqi1) AT=499.000000p
.measure tran QI1_K2 FIND V(xqi1) AT=799.000000p
.measure tran QI1_K3 FIND V(xqi1) AT=1099.000000p
.measure tran QI1_K4 FIND V(xqi1) AT=1399.000000p
.measure tran QI1_K5 FIND V(xqi1) AT=1699.000000p
.measure tran QI1_K6 FIND V(xqi1) AT=2001.000000p
.measure tran QI1_D FIND V(xqi1) AT=2496.000000p
.measure tran EGT_Z FIND V(xegt) AT=1.500000p
.measure tran EGT_B1 FIND V(xegt) AT=268.908060p
.measure tran EGT_B2 FIND V(xegt) AT=610.635546p
.measure tran EGT_B3 FIND V(xegt) AT=905.631066p
.measure tran EGT_B4 FIND V(xegt) AT=1203.124186p
.measure tran EGT_B5 FIND V(xegt) AT=1502.855261p
.measure tran EGT_B6 FIND V(xegt) AT=1795.533996p
.measure tran EGT_K1 FIND V(xegt) AT=499.000000p
.measure tran EGT_K2 FIND V(xegt) AT=799.000000p
.measure tran EGT_K3 FIND V(xegt) AT=1099.000000p
.measure tran EGT_K4 FIND V(xegt) AT=1399.000000p
.measure tran EGT_K5 FIND V(xegt) AT=1699.000000p
.measure tran EGT_K6 FIND V(xegt) AT=2001.000000p
.measure tran EGT_D FIND V(xegt) AT=2496.000000p
.measure tran VR1Z FIND V(rail1) AT=1.500000p
.measure tran VR2Z FIND V(rail2) AT=1.500000p
.measure tran VR3Z FIND V(rail3) AT=1.500000p
.measure tran VR4Z FIND V(rail4) AT=1.500000p
.measure tran VR5Z FIND V(rail5) AT=1.500000p
.measure tran VR6Z FIND V(rail6) AT=1.500000p
.measure tran VS1Z FIND V(res1) AT=1.500000p
.measure tran VR1B1 FIND V(rail1) AT=268.908060p
.measure tran VR2B1 FIND V(rail2) AT=268.908060p
.measure tran VR3B1 FIND V(rail3) AT=268.908060p
.measure tran VR4B1 FIND V(rail4) AT=268.908060p
.measure tran VR5B1 FIND V(rail5) AT=268.908060p
.measure tran VR6B1 FIND V(rail6) AT=268.908060p
.measure tran VS1B1 FIND V(res1) AT=268.908060p
.measure tran VR1B2 FIND V(rail1) AT=610.635546p
.measure tran VR2B2 FIND V(rail2) AT=610.635546p
.measure tran VR3B2 FIND V(rail3) AT=610.635546p
.measure tran VR4B2 FIND V(rail4) AT=610.635546p
.measure tran VR5B2 FIND V(rail5) AT=610.635546p
.measure tran VR6B2 FIND V(rail6) AT=610.635546p
.measure tran VS1B2 FIND V(res1) AT=610.635546p
.measure tran VR1B3 FIND V(rail1) AT=905.631066p
.measure tran VR2B3 FIND V(rail2) AT=905.631066p
.measure tran VR3B3 FIND V(rail3) AT=905.631066p
.measure tran VR4B3 FIND V(rail4) AT=905.631066p
.measure tran VR5B3 FIND V(rail5) AT=905.631066p
.measure tran VR6B3 FIND V(rail6) AT=905.631066p
.measure tran VS1B3 FIND V(res1) AT=905.631066p
.measure tran VR1B4 FIND V(rail1) AT=1203.124186p
.measure tran VR2B4 FIND V(rail2) AT=1203.124186p
.measure tran VR3B4 FIND V(rail3) AT=1203.124186p
.measure tran VR4B4 FIND V(rail4) AT=1203.124186p
.measure tran VR5B4 FIND V(rail5) AT=1203.124186p
.measure tran VR6B4 FIND V(rail6) AT=1203.124186p
.measure tran VS1B4 FIND V(res1) AT=1203.124186p
.measure tran VR1B5 FIND V(rail1) AT=1502.855261p
.measure tran VR2B5 FIND V(rail2) AT=1502.855261p
.measure tran VR3B5 FIND V(rail3) AT=1502.855261p
.measure tran VR4B5 FIND V(rail4) AT=1502.855261p
.measure tran VR5B5 FIND V(rail5) AT=1502.855261p
.measure tran VR6B5 FIND V(rail6) AT=1502.855261p
.measure tran VS1B5 FIND V(res1) AT=1502.855261p
.measure tran VR1B6 FIND V(rail1) AT=1795.533996p
.measure tran VR2B6 FIND V(rail2) AT=1795.533996p
.measure tran VR3B6 FIND V(rail3) AT=1795.533996p
.measure tran VR4B6 FIND V(rail4) AT=1795.533996p
.measure tran VR5B6 FIND V(rail5) AT=1795.533996p
.measure tran VR6B6 FIND V(rail6) AT=1795.533996p
.measure tran VS1B6 FIND V(res1) AT=1795.533996p
.measure tran VR1K1 FIND V(rail1) AT=499.000000p
.measure tran VR2K1 FIND V(rail2) AT=499.000000p
.measure tran VR3K1 FIND V(rail3) AT=499.000000p
.measure tran VR4K1 FIND V(rail4) AT=499.000000p
.measure tran VR5K1 FIND V(rail5) AT=499.000000p
.measure tran VR6K1 FIND V(rail6) AT=499.000000p
.measure tran VS1K1 FIND V(res1) AT=499.000000p
.measure tran VR1K2 FIND V(rail1) AT=799.000000p
.measure tran VR2K2 FIND V(rail2) AT=799.000000p
.measure tran VR3K2 FIND V(rail3) AT=799.000000p
.measure tran VR4K2 FIND V(rail4) AT=799.000000p
.measure tran VR5K2 FIND V(rail5) AT=799.000000p
.measure tran VR6K2 FIND V(rail6) AT=799.000000p
.measure tran VS1K2 FIND V(res1) AT=799.000000p
.measure tran VR1K3 FIND V(rail1) AT=1099.000000p
.measure tran VR2K3 FIND V(rail2) AT=1099.000000p
.measure tran VR3K3 FIND V(rail3) AT=1099.000000p
.measure tran VR4K3 FIND V(rail4) AT=1099.000000p
.measure tran VR5K3 FIND V(rail5) AT=1099.000000p
.measure tran VR6K3 FIND V(rail6) AT=1099.000000p
.measure tran VS1K3 FIND V(res1) AT=1099.000000p
.measure tran VR1K4 FIND V(rail1) AT=1399.000000p
.measure tran VR2K4 FIND V(rail2) AT=1399.000000p
.measure tran VR3K4 FIND V(rail3) AT=1399.000000p
.measure tran VR4K4 FIND V(rail4) AT=1399.000000p
.measure tran VR5K4 FIND V(rail5) AT=1399.000000p
.measure tran VR6K4 FIND V(rail6) AT=1399.000000p
.measure tran VS1K4 FIND V(res1) AT=1399.000000p
.measure tran VR1K5 FIND V(rail1) AT=1699.000000p
.measure tran VR2K5 FIND V(rail2) AT=1699.000000p
.measure tran VR3K5 FIND V(rail3) AT=1699.000000p
.measure tran VR4K5 FIND V(rail4) AT=1699.000000p
.measure tran VR5K5 FIND V(rail5) AT=1699.000000p
.measure tran VR6K5 FIND V(rail6) AT=1699.000000p
.measure tran VS1K5 FIND V(res1) AT=1699.000000p
.measure tran VR1K6 FIND V(rail1) AT=2001.000000p
.measure tran VR2K6 FIND V(rail2) AT=2001.000000p
.measure tran VR3K6 FIND V(rail3) AT=2001.000000p
.measure tran VR4K6 FIND V(rail4) AT=2001.000000p
.measure tran VR5K6 FIND V(rail5) AT=2001.000000p
.measure tran VR6K6 FIND V(rail6) AT=2001.000000p
.measure tran VS1K6 FIND V(res1) AT=2001.000000p
.measure tran VR1D FIND V(rail1) AT=2496.000000p
.measure tran VR2D FIND V(rail2) AT=2496.000000p
.measure tran VR3D FIND V(rail3) AT=2496.000000p
.measure tran VR4D FIND V(rail4) AT=2496.000000p
.measure tran VR5D FIND V(rail5) AT=2496.000000p
.measure tran VR6D FIND V(rail6) AT=2496.000000p
.measure tran VS1D FIND V(res1) AT=2496.000000p
.measure tran VR1PK MAX V(rail1) FROM=200p TO=2500p
.measure tran O1_0S FIND V(o1_0) AT=499.000000p
.measure tran O1_0E FIND V(o1_0) AT=2496.000000p
.measure tran G1_0B FIND V(in1_0) AT=499.000000p
.measure tran G1_0C FIND V(in1_0) AT=199.000000p
.measure tran G1_0X MIN V(in1_0) FROM=200p TO=498p
.measure tran O1_1S FIND V(o1_1) AT=499.000000p
.measure tran O1_1E FIND V(o1_1) AT=2496.000000p
.measure tran G1_1B FIND V(in1_1) AT=499.000000p
.measure tran G1_1C FIND V(in1_1) AT=199.000000p
.measure tran G1_1X MAX V(in1_1) FROM=200p TO=498p
.measure tran O1_2S FIND V(o1_2) AT=499.000000p
.measure tran O1_2E FIND V(o1_2) AT=2496.000000p
.measure tran G1_2B FIND V(in1_2) AT=499.000000p
.measure tran G1_2C FIND V(in1_2) AT=199.000000p
.measure tran G1_2X MIN V(in1_2) FROM=200p TO=498p
.measure tran O1_3S FIND V(o1_3) AT=499.000000p
.measure tran O1_3E FIND V(o1_3) AT=2496.000000p
.measure tran G1_3B FIND V(in1_3) AT=499.000000p
.measure tran G1_3C FIND V(in1_3) AT=199.000000p
.measure tran G1_3X MAX V(in1_3) FROM=200p TO=498p
.measure tran O1_4S FIND V(o1_4) AT=499.000000p
.measure tran O1_4E FIND V(o1_4) AT=2496.000000p
.measure tran G1_4B FIND V(in1_4) AT=499.000000p
.measure tran G1_4C FIND V(in1_4) AT=199.000000p
.measure tran G1_4X MIN V(in1_4) FROM=200p TO=498p
.measure tran O1_5S FIND V(o1_5) AT=499.000000p
.measure tran O1_5E FIND V(o1_5) AT=2496.000000p
.measure tran G1_5B FIND V(in1_5) AT=499.000000p
.measure tran G1_5C FIND V(in1_5) AT=199.000000p
.measure tran G1_5X MAX V(in1_5) FROM=200p TO=498p
.measure tran O1_6S FIND V(o1_6) AT=499.000000p
.measure tran O1_6E FIND V(o1_6) AT=2496.000000p
.measure tran G1_6B FIND V(in1_6) AT=499.000000p
.measure tran G1_6C FIND V(in1_6) AT=199.000000p
.measure tran G1_6X MIN V(in1_6) FROM=200p TO=498p
.measure tran O1_7S FIND V(o1_7) AT=499.000000p
.measure tran O1_7E FIND V(o1_7) AT=2496.000000p
.measure tran G1_7B FIND V(in1_7) AT=499.000000p
.measure tran G1_7C FIND V(in1_7) AT=199.000000p
.measure tran G1_7X MAX V(in1_7) FROM=200p TO=498p
.measure tran IZ1 FIND I(L1) AT=268.908060p
.measure tran IPK1 MAX I(L1) FROM=200p TO=2500p
.measure tran VR2PK MAX V(rail2) FROM=200p TO=2500p
.measure tran O2_0S FIND V(o2_0) AT=799.000000p
.measure tran O2_0E FIND V(o2_0) AT=2496.000000p
.measure tran G2_0B FIND V(o1_0) AT=799.000000p
.measure tran G2_0C FIND V(o1_0) AT=499.000000p
.measure tran G2_0X MAX V(o1_0) FROM=500p TO=798p
.measure tran O2_1S FIND V(o2_1) AT=799.000000p
.measure tran O2_1E FIND V(o2_1) AT=2496.000000p
.measure tran G2_1B FIND V(o1_1) AT=799.000000p
.measure tran G2_1C FIND V(o1_1) AT=499.000000p
.measure tran G2_1X MIN V(o1_1) FROM=500p TO=798p
.measure tran O2_2S FIND V(o2_2) AT=799.000000p
.measure tran O2_2E FIND V(o2_2) AT=2496.000000p
.measure tran G2_2B FIND V(o1_2) AT=799.000000p
.measure tran G2_2C FIND V(o1_2) AT=499.000000p
.measure tran G2_2X MAX V(o1_2) FROM=500p TO=798p
.measure tran O2_3S FIND V(o2_3) AT=799.000000p
.measure tran O2_3E FIND V(o2_3) AT=2496.000000p
.measure tran G2_3B FIND V(o1_3) AT=799.000000p
.measure tran G2_3C FIND V(o1_3) AT=499.000000p
.measure tran G2_3X MIN V(o1_3) FROM=500p TO=798p
.measure tran O2_4S FIND V(o2_4) AT=799.000000p
.measure tran O2_4E FIND V(o2_4) AT=2496.000000p
.measure tran G2_4B FIND V(o1_4) AT=799.000000p
.measure tran G2_4C FIND V(o1_4) AT=499.000000p
.measure tran G2_4X MAX V(o1_4) FROM=500p TO=798p
.measure tran O2_5S FIND V(o2_5) AT=799.000000p
.measure tran O2_5E FIND V(o2_5) AT=2496.000000p
.measure tran G2_5B FIND V(o1_5) AT=799.000000p
.measure tran G2_5C FIND V(o1_5) AT=499.000000p
.measure tran G2_5X MIN V(o1_5) FROM=500p TO=798p
.measure tran O2_6S FIND V(o2_6) AT=799.000000p
.measure tran O2_6E FIND V(o2_6) AT=2496.000000p
.measure tran G2_6B FIND V(o1_6) AT=799.000000p
.measure tran G2_6C FIND V(o1_6) AT=499.000000p
.measure tran G2_6X MAX V(o1_6) FROM=500p TO=798p
.measure tran O2_7S FIND V(o2_7) AT=799.000000p
.measure tran O2_7E FIND V(o2_7) AT=2496.000000p
.measure tran G2_7B FIND V(o1_7) AT=799.000000p
.measure tran G2_7C FIND V(o1_7) AT=499.000000p
.measure tran G2_7X MIN V(o1_7) FROM=500p TO=798p
.measure tran IZ2 FIND I(L2) AT=610.635546p
.measure tran IPK2 MAX I(L2) FROM=200p TO=2500p
.measure tran VR3PK MAX V(rail3) FROM=200p TO=2500p
.measure tran O3_0S FIND V(o3_0) AT=1099.000000p
.measure tran O3_0E FIND V(o3_0) AT=2496.000000p
.measure tran G3_0B FIND V(o2_0) AT=1099.000000p
.measure tran G3_0C FIND V(o2_0) AT=799.000000p
.measure tran G3_0X MIN V(o2_0) FROM=800p TO=1098p
.measure tran O3_1S FIND V(o3_1) AT=1099.000000p
.measure tran O3_1E FIND V(o3_1) AT=2496.000000p
.measure tran G3_1B FIND V(o2_1) AT=1099.000000p
.measure tran G3_1C FIND V(o2_1) AT=799.000000p
.measure tran G3_1X MAX V(o2_1) FROM=800p TO=1098p
.measure tran O3_2S FIND V(o3_2) AT=1099.000000p
.measure tran O3_2E FIND V(o3_2) AT=2496.000000p
.measure tran G3_2B FIND V(o2_2) AT=1099.000000p
.measure tran G3_2C FIND V(o2_2) AT=799.000000p
.measure tran G3_2X MIN V(o2_2) FROM=800p TO=1098p
.measure tran O3_3S FIND V(o3_3) AT=1099.000000p
.measure tran O3_3E FIND V(o3_3) AT=2496.000000p
.measure tran G3_3B FIND V(o2_3) AT=1099.000000p
.measure tran G3_3C FIND V(o2_3) AT=799.000000p
.measure tran G3_3X MAX V(o2_3) FROM=800p TO=1098p
.measure tran O3_4S FIND V(o3_4) AT=1099.000000p
.measure tran O3_4E FIND V(o3_4) AT=2496.000000p
.measure tran G3_4B FIND V(o2_4) AT=1099.000000p
.measure tran G3_4C FIND V(o2_4) AT=799.000000p
.measure tran G3_4X MIN V(o2_4) FROM=800p TO=1098p
.measure tran O3_5S FIND V(o3_5) AT=1099.000000p
.measure tran O3_5E FIND V(o3_5) AT=2496.000000p
.measure tran G3_5B FIND V(o2_5) AT=1099.000000p
.measure tran G3_5C FIND V(o2_5) AT=799.000000p
.measure tran G3_5X MAX V(o2_5) FROM=800p TO=1098p
.measure tran O3_6S FIND V(o3_6) AT=1099.000000p
.measure tran O3_6E FIND V(o3_6) AT=2496.000000p
.measure tran G3_6B FIND V(o2_6) AT=1099.000000p
.measure tran G3_6C FIND V(o2_6) AT=799.000000p
.measure tran G3_6X MIN V(o2_6) FROM=800p TO=1098p
.measure tran O3_7S FIND V(o3_7) AT=1099.000000p
.measure tran O3_7E FIND V(o3_7) AT=2496.000000p
.measure tran G3_7B FIND V(o2_7) AT=1099.000000p
.measure tran G3_7C FIND V(o2_7) AT=799.000000p
.measure tran G3_7X MAX V(o2_7) FROM=800p TO=1098p
.measure tran IZ3 FIND I(L3) AT=905.631066p
.measure tran IPK3 MAX I(L3) FROM=200p TO=2500p
.measure tran VR4PK MAX V(rail4) FROM=200p TO=2500p
.measure tran O4_0S FIND V(o4_0) AT=1399.000000p
.measure tran O4_0E FIND V(o4_0) AT=2496.000000p
.measure tran G4_0B FIND V(o3_0) AT=1399.000000p
.measure tran G4_0C FIND V(o3_0) AT=1099.000000p
.measure tran G4_0X MAX V(o3_0) FROM=1100p TO=1398p
.measure tran O4_1S FIND V(o4_1) AT=1399.000000p
.measure tran O4_1E FIND V(o4_1) AT=2496.000000p
.measure tran G4_1B FIND V(o3_1) AT=1399.000000p
.measure tran G4_1C FIND V(o3_1) AT=1099.000000p
.measure tran G4_1X MIN V(o3_1) FROM=1100p TO=1398p
.measure tran O4_2S FIND V(o4_2) AT=1399.000000p
.measure tran O4_2E FIND V(o4_2) AT=2496.000000p
.measure tran G4_2B FIND V(o3_2) AT=1399.000000p
.measure tran G4_2C FIND V(o3_2) AT=1099.000000p
.measure tran G4_2X MAX V(o3_2) FROM=1100p TO=1398p
.measure tran O4_3S FIND V(o4_3) AT=1399.000000p
.measure tran O4_3E FIND V(o4_3) AT=2496.000000p
.measure tran G4_3B FIND V(o3_3) AT=1399.000000p
.measure tran G4_3C FIND V(o3_3) AT=1099.000000p
.measure tran G4_3X MIN V(o3_3) FROM=1100p TO=1398p
.measure tran O4_4S FIND V(o4_4) AT=1399.000000p
.measure tran O4_4E FIND V(o4_4) AT=2496.000000p
.measure tran G4_4B FIND V(o3_4) AT=1399.000000p
.measure tran G4_4C FIND V(o3_4) AT=1099.000000p
.measure tran G4_4X MAX V(o3_4) FROM=1100p TO=1398p
.measure tran O4_5S FIND V(o4_5) AT=1399.000000p
.measure tran O4_5E FIND V(o4_5) AT=2496.000000p
.measure tran G4_5B FIND V(o3_5) AT=1399.000000p
.measure tran G4_5C FIND V(o3_5) AT=1099.000000p
.measure tran G4_5X MIN V(o3_5) FROM=1100p TO=1398p
.measure tran O4_6S FIND V(o4_6) AT=1399.000000p
.measure tran O4_6E FIND V(o4_6) AT=2496.000000p
.measure tran G4_6B FIND V(o3_6) AT=1399.000000p
.measure tran G4_6C FIND V(o3_6) AT=1099.000000p
.measure tran G4_6X MAX V(o3_6) FROM=1100p TO=1398p
.measure tran O4_7S FIND V(o4_7) AT=1399.000000p
.measure tran O4_7E FIND V(o4_7) AT=2496.000000p
.measure tran G4_7B FIND V(o3_7) AT=1399.000000p
.measure tran G4_7C FIND V(o3_7) AT=1099.000000p
.measure tran G4_7X MIN V(o3_7) FROM=1100p TO=1398p
.measure tran IZ4 FIND I(L4) AT=1203.124186p
.measure tran IPK4 MAX I(L4) FROM=200p TO=2500p
.measure tran VR5PK MAX V(rail5) FROM=200p TO=2500p
.measure tran O5_0S FIND V(o5_0) AT=1699.000000p
.measure tran O5_0E FIND V(o5_0) AT=2496.000000p
.measure tran G5_0B FIND V(o4_0) AT=1699.000000p
.measure tran G5_0C FIND V(o4_0) AT=1399.000000p
.measure tran G5_0X MIN V(o4_0) FROM=1400p TO=1698p
.measure tran O5_1S FIND V(o5_1) AT=1699.000000p
.measure tran O5_1E FIND V(o5_1) AT=2496.000000p
.measure tran G5_1B FIND V(o4_1) AT=1699.000000p
.measure tran G5_1C FIND V(o4_1) AT=1399.000000p
.measure tran G5_1X MAX V(o4_1) FROM=1400p TO=1698p
.measure tran O5_2S FIND V(o5_2) AT=1699.000000p
.measure tran O5_2E FIND V(o5_2) AT=2496.000000p
.measure tran G5_2B FIND V(o4_2) AT=1699.000000p
.measure tran G5_2C FIND V(o4_2) AT=1399.000000p
.measure tran G5_2X MIN V(o4_2) FROM=1400p TO=1698p
.measure tran O5_3S FIND V(o5_3) AT=1699.000000p
.measure tran O5_3E FIND V(o5_3) AT=2496.000000p
.measure tran G5_3B FIND V(o4_3) AT=1699.000000p
.measure tran G5_3C FIND V(o4_3) AT=1399.000000p
.measure tran G5_3X MAX V(o4_3) FROM=1400p TO=1698p
.measure tran O5_4S FIND V(o5_4) AT=1699.000000p
.measure tran O5_4E FIND V(o5_4) AT=2496.000000p
.measure tran G5_4B FIND V(o4_4) AT=1699.000000p
.measure tran G5_4C FIND V(o4_4) AT=1399.000000p
.measure tran G5_4X MIN V(o4_4) FROM=1400p TO=1698p
.measure tran O5_5S FIND V(o5_5) AT=1699.000000p
.measure tran O5_5E FIND V(o5_5) AT=2496.000000p
.measure tran G5_5B FIND V(o4_5) AT=1699.000000p
.measure tran G5_5C FIND V(o4_5) AT=1399.000000p
.measure tran G5_5X MAX V(o4_5) FROM=1400p TO=1698p
.measure tran O5_6S FIND V(o5_6) AT=1699.000000p
.measure tran O5_6E FIND V(o5_6) AT=2496.000000p
.measure tran G5_6B FIND V(o4_6) AT=1699.000000p
.measure tran G5_6C FIND V(o4_6) AT=1399.000000p
.measure tran G5_6X MIN V(o4_6) FROM=1400p TO=1698p
.measure tran O5_7S FIND V(o5_7) AT=1699.000000p
.measure tran O5_7E FIND V(o5_7) AT=2496.000000p
.measure tran G5_7B FIND V(o4_7) AT=1699.000000p
.measure tran G5_7C FIND V(o4_7) AT=1399.000000p
.measure tran G5_7X MAX V(o4_7) FROM=1400p TO=1698p
.measure tran IZ5 FIND I(L5) AT=1502.855261p
.measure tran IPK5 MAX I(L5) FROM=200p TO=2500p
.measure tran VR6PK MAX V(rail6) FROM=200p TO=2500p
.measure tran O6_0S FIND V(o6_0) AT=2001.000000p
.measure tran O6_0E FIND V(o6_0) AT=2496.000000p
.measure tran G6_0B FIND V(o5_0) AT=2001.000000p
.measure tran G6_0C FIND V(o5_0) AT=1699.000000p
.measure tran G6_0X MAX V(o5_0) FROM=1700p TO=2000p
.measure tran O6_1S FIND V(o6_1) AT=2001.000000p
.measure tran O6_1E FIND V(o6_1) AT=2496.000000p
.measure tran G6_1B FIND V(o5_1) AT=2001.000000p
.measure tran G6_1C FIND V(o5_1) AT=1699.000000p
.measure tran G6_1X MIN V(o5_1) FROM=1700p TO=2000p
.measure tran O6_2S FIND V(o6_2) AT=2001.000000p
.measure tran O6_2E FIND V(o6_2) AT=2496.000000p
.measure tran G6_2B FIND V(o5_2) AT=2001.000000p
.measure tran G6_2C FIND V(o5_2) AT=1699.000000p
.measure tran G6_2X MAX V(o5_2) FROM=1700p TO=2000p
.measure tran O6_3S FIND V(o6_3) AT=2001.000000p
.measure tran O6_3E FIND V(o6_3) AT=2496.000000p
.measure tran G6_3B FIND V(o5_3) AT=2001.000000p
.measure tran G6_3C FIND V(o5_3) AT=1699.000000p
.measure tran G6_3X MIN V(o5_3) FROM=1700p TO=2000p
.measure tran O6_4S FIND V(o6_4) AT=2001.000000p
.measure tran O6_4E FIND V(o6_4) AT=2496.000000p
.measure tran G6_4B FIND V(o5_4) AT=2001.000000p
.measure tran G6_4C FIND V(o5_4) AT=1699.000000p
.measure tran G6_4X MAX V(o5_4) FROM=1700p TO=2000p
.measure tran O6_5S FIND V(o6_5) AT=2001.000000p
.measure tran O6_5E FIND V(o6_5) AT=2496.000000p
.measure tran G6_5B FIND V(o5_5) AT=2001.000000p
.measure tran G6_5C FIND V(o5_5) AT=1699.000000p
.measure tran G6_5X MIN V(o5_5) FROM=1700p TO=2000p
.measure tran O6_6S FIND V(o6_6) AT=2001.000000p
.measure tran O6_6E FIND V(o6_6) AT=2496.000000p
.measure tran G6_6B FIND V(o5_6) AT=2001.000000p
.measure tran G6_6C FIND V(o5_6) AT=1699.000000p
.measure tran G6_6X MAX V(o5_6) FROM=1700p TO=2000p
.measure tran O6_7S FIND V(o6_7) AT=2001.000000p
.measure tran O6_7E FIND V(o6_7) AT=2496.000000p
.measure tran G6_7B FIND V(o5_7) AT=2001.000000p
.measure tran G6_7C FIND V(o5_7) AT=1699.000000p
.measure tran G6_7X MIN V(o5_7) FROM=1700p TO=2000p
.measure tran IZ6 FIND I(L6) AT=1795.533996p
.measure tran IPK6 MAX I(L6) FROM=200p TO=2500p
.print tran V(rail1) V(rail2) V(rail3) V(rail4) V(rail5) V(rail6) V(res1) I(L1) I(L2) I(L3) I(L4) I(L5) I(L6) V(o1_0) V(o1_1) V(o2_0) V(o2_1) V(o3_0) V(o3_1) V(o4_0) V(o4_1) V(o5_0) V(o5_1) V(o6_0) V(o6_1) V(rm1_0) V(rb1_0) V(rm1_1) V(rb1_1)
.end
