.hdl "/usr/local/share/xyce/verilog-a/psp103/psp103.va"
.include "/usr/local/src/kestrel/sim/models/sg13g2_psp103_tt.lib"
.include "/usr/local/src/stat-sim/qal/sg13lv_compat.sp"
.OPTIONS TIMEINT METHOD=GEAR RELTOL=1e-6 ABSTOL=1e-15 CHGTOL=1e-17
.param LT=15n RS=10
VHI vhi 0 1.5
VRES vres 0 1.2
CRES1 res1 0 35.979f
XRP1_0a rm1_0 o2_0 vres vres sg13_lv_pmos w=1.12u l=0.13u
XRN1_0a rm1_0 o2_0 0 0 sg13_lv_nmos w=0.74u l=0.13u
CRM1_0 rm1_0 0 2f
XRP1_0b rb1_0 rm1_0 vres vres sg13_lv_pmos w=1.12u l=0.13u
XRN1_0b rb1_0 rm1_0 0 0 sg13_lv_nmos w=0.74u l=0.13u
CRB1_0 rb1_0 0 2f
XRP1_1a rm1_1 o2_1 vres vres sg13_lv_pmos w=1.12u l=0.13u
XRN1_1a rm1_1 o2_1 0 0 sg13_lv_nmos w=0.74u l=0.13u
CRM1_1 rm1_1 0 2f
XRP1_1b rb1_1 rm1_1 vres vres sg13_lv_pmos w=1.12u l=0.13u
XRN1_1b rb1_1 rm1_1 0 0 sg13_lv_nmos w=0.74u l=0.13u
CRB1_1 rb1_1 0 2f
XRP1_2a rm1_2 o2_2 vres vres sg13_lv_pmos w=1.12u l=0.13u
XRN1_2a rm1_2 o2_2 0 0 sg13_lv_nmos w=0.74u l=0.13u
CRM1_2 rm1_2 0 2f
XRP1_2b rb1_2 rm1_2 vres vres sg13_lv_pmos w=1.12u l=0.13u
XRN1_2b rb1_2 rm1_2 0 0 sg13_lv_nmos w=0.74u l=0.13u
CRB1_2 rb1_2 0 2f
XRP1_3a rm1_3 o2_3 vres vres sg13_lv_pmos w=1.12u l=0.13u
XRN1_3a rm1_3 o2_3 0 0 sg13_lv_nmos w=0.74u l=0.13u
CRM1_3 rm1_3 0 2f
XRP1_3b rb1_3 rm1_3 vres vres sg13_lv_pmos w=1.12u l=0.13u
XRN1_3b rb1_3 rm1_3 0 0 sg13_lv_nmos w=0.74u l=0.13u
CRB1_3 rb1_3 0 2f
XRP1_4a rm1_4 o2_4 vres vres sg13_lv_pmos w=1.12u l=0.13u
XRN1_4a rm1_4 o2_4 0 0 sg13_lv_nmos w=0.74u l=0.13u
CRM1_4 rm1_4 0 2f
XRP1_4b rb1_4 rm1_4 vres vres sg13_lv_pmos w=1.12u l=0.13u
XRN1_4b rb1_4 rm1_4 0 0 sg13_lv_nmos w=0.74u l=0.13u
CRB1_4 rb1_4 0 2f
XRP1_5a rm1_5 o2_5 vres vres sg13_lv_pmos w=1.12u l=0.13u
XRN1_5a rm1_5 o2_5 0 0 sg13_lv_nmos w=0.74u l=0.13u
CRM1_5 rm1_5 0 2f
XRP1_5b rb1_5 rm1_5 vres vres sg13_lv_pmos w=1.12u l=0.13u
XRN1_5b rb1_5 rm1_5 0 0 sg13_lv_nmos w=0.74u l=0.13u
CRB1_5 rb1_5 0 2f
XRP1_6a rm1_6 o2_6 vres vres sg13_lv_pmos w=1.12u l=0.13u
XRN1_6a rm1_6 o2_6 0 0 sg13_lv_nmos w=0.74u l=0.13u
CRM1_6 rm1_6 0 2f
XRP1_6b rb1_6 rm1_6 vres vres sg13_lv_pmos w=1.12u l=0.13u
XRN1_6b rb1_6 rm1_6 0 0 sg13_lv_nmos w=0.74u l=0.13u
CRB1_6 rb1_6 0 2f
XRP1_7a rm1_7 o2_7 vres vres sg13_lv_pmos w=1.12u l=0.13u
XRN1_7a rm1_7 o2_7 0 0 sg13_lv_nmos w=0.74u l=0.13u
CRM1_7 rm1_7 0 2f
XRP1_7b rb1_7 rm1_7 vres vres sg13_lv_pmos w=1.12u l=0.13u
XRN1_7b rb1_7 rm1_7 0 0 sg13_lv_nmos w=0.74u l=0.13u
CRB1_7 rb1_7 0 2f
VMG1 gn1 0 0
VI1_0 in1_0 0 1.2
VI1_1 in1_1 0 0
VI1_2 in1_2 0 1.2
VI1_3 in1_3 0 0
VI1_4 in1_4 0 1.2
VI1_5 in1_5 0 0
VI1_6 in1_6 0 1.2
VI1_7 in1_7 0 0
XP1_0 o1_0 in1_0 rail1 rail1 sg13_lv_pmos w=1.12u l=0.13u
XN1_0 o1_0 in1_0 gn1 gn1 sg13_lv_nmos w=0.74u l=0.13u
CL1_0 o1_0 gn1 2f
XP1_1 o1_1 in1_1 rail1 rail1 sg13_lv_pmos w=1.12u l=0.13u
XN1_1 o1_1 in1_1 gn1 gn1 sg13_lv_nmos w=0.74u l=0.13u
CL1_1 o1_1 gn1 2f
XP1_2 o1_2 in1_2 rail1 rail1 sg13_lv_pmos w=1.12u l=0.13u
XN1_2 o1_2 in1_2 gn1 gn1 sg13_lv_nmos w=0.74u l=0.13u
CL1_2 o1_2 gn1 2f
XP1_3 o1_3 in1_3 rail1 rail1 sg13_lv_pmos w=1.12u l=0.13u
XN1_3 o1_3 in1_3 gn1 gn1 sg13_lv_nmos w=0.74u l=0.13u
CL1_3 o1_3 gn1 2f
XP1_4 o1_4 in1_4 rail1 rail1 sg13_lv_pmos w=1.12u l=0.13u
XN1_4 o1_4 in1_4 gn1 gn1 sg13_lv_nmos w=0.74u l=0.13u
CL1_4 o1_4 gn1 2f
XP1_5 o1_5 in1_5 rail1 rail1 sg13_lv_pmos w=1.12u l=0.13u
XN1_5 o1_5 in1_5 gn1 gn1 sg13_lv_nmos w=0.74u l=0.13u
CL1_5 o1_5 gn1 2f
XP1_6 o1_6 in1_6 rail1 rail1 sg13_lv_pmos w=1.12u l=0.13u
XN1_6 o1_6 in1_6 gn1 gn1 sg13_lv_nmos w=0.74u l=0.13u
CL1_6 o1_6 gn1 2f
XP1_7 o1_7 in1_7 rail1 rail1 sg13_lv_pmos w=1.12u l=0.13u
XN1_7 o1_7 in1_7 gn1 gn1 sg13_lv_nmos w=0.74u l=0.13u
CL1_7 o1_7 gn1 2f
VMG2 gn2 0 0
XP2_0 o2_0 o1_0 rail2 rail2 sg13_lv_pmos w=1.12u l=0.13u
XN2_0 o2_0 o1_0 gn2 gn2 sg13_lv_nmos w=0.74u l=0.13u
CL2_0 o2_0 gn2 2f
XP2_1 o2_1 o1_1 rail2 rail2 sg13_lv_pmos w=1.12u l=0.13u
XN2_1 o2_1 o1_1 gn2 gn2 sg13_lv_nmos w=0.74u l=0.13u
CL2_1 o2_1 gn2 2f
XP2_2 o2_2 o1_2 rail2 rail2 sg13_lv_pmos w=1.12u l=0.13u
XN2_2 o2_2 o1_2 gn2 gn2 sg13_lv_nmos w=0.74u l=0.13u
CL2_2 o2_2 gn2 2f
XP2_3 o2_3 o1_3 rail2 rail2 sg13_lv_pmos w=1.12u l=0.13u
XN2_3 o2_3 o1_3 gn2 gn2 sg13_lv_nmos w=0.74u l=0.13u
CL2_3 o2_3 gn2 2f
XP2_4 o2_4 o1_4 rail2 rail2 sg13_lv_pmos w=1.12u l=0.13u
XN2_4 o2_4 o1_4 gn2 gn2 sg13_lv_nmos w=0.74u l=0.13u
CL2_4 o2_4 gn2 2f
XP2_5 o2_5 o1_5 rail2 rail2 sg13_lv_pmos w=1.12u l=0.13u
XN2_5 o2_5 o1_5 gn2 gn2 sg13_lv_nmos w=0.74u l=0.13u
CL2_5 o2_5 gn2 2f
XP2_6 o2_6 o1_6 rail2 rail2 sg13_lv_pmos w=1.12u l=0.13u
XN2_6 o2_6 o1_6 gn2 gn2 sg13_lv_nmos w=0.74u l=0.13u
CL2_6 o2_6 gn2 2f
XP2_7 o2_7 o1_7 rail2 rail2 sg13_lv_pmos w=1.12u l=0.13u
XN2_7 o2_7 o1_7 gn2 gn2 sg13_lv_nmos w=0.74u l=0.13u
CL2_7 o2_7 gn2 2f
L1 res1 mid1 {LT}
R1 mid1 sw1 {RS}
XSWN1 sw1 gt1 rail1 0 sg13_lv_nmos w=10u l=0.13u
XSWP1 sw1 gtp1 rail1 vhi sg13_lv_pmos w=20u l=0.13u
XPK1 sw1 pk1 0 0 sg13_lv_nmos w=2u l=0.13u
L2 a2 mid2 {LT}
R2 mid2 sw2 {RS}
XSWN2 sw2 gt2 rail2 0 sg13_lv_nmos w=10u l=0.13u
XSWP2 sw2 gtp2 rail2 vhi sg13_lv_pmos w=20u l=0.13u
XPK2 sw2 pk2 0 0 sg13_lv_nmos w=2u l=0.13u
XSWSN2 a2 gt2 rail1 0 sg13_lv_nmos w=10u l=0.13u
XSWSP2 a2 gtp2 rail1 vhi sg13_lv_pmos w=20u l=0.13u
VGT1 gt1 0 PWL(0 0 198p 0 200p 1.5 266.695p 1.5 268.695p 0)
VGTP1 gtp1 0 PWL(0 1.5 198p 1.5 200p 0 266.695p 0 268.695p 1.5)
VPK1 pk1 0 PWL(0 0 268.695p 0 270.695p 1.5)
VGT2 gt2 0 PWL(0 0 498p 0 500p 1.5 597.212p 1.5 599.212p 0)
VGTP2 gtp2 0 PWL(0 1.5 498p 1.5 500p 0 597.212p 0 599.212p 1.5)
VPK2 pk2 0 PWL(0 1.5 500p 1.5 502p 0 599.212p 0 601.212p 1.5)
CXqlt1 xqlt1 0 1
BXqlt1 0 xqlt1 I={ I(L1) }
RXqlt1 xqlt1 0 0.01
CXea1 xea1 0 1
BXea1 0 xea1 I={ V(res1)*I(L1) }
RXea1 xea1 0 0.01
CXean1 xean1 0 1
BXean1 0 xean1 I={ V(res1)*I(L1) }
RXean1 xean1 0 0.01
CXeb1 xeb1 0 1
BXeb1 0 xeb1 I={ V(rail1)*I(L1) }
RXeb1 xeb1 0 0.01
CXer1 xer1 0 1
BXer1 0 xer1 I={ I(L1)*I(L1)*10 }
RXer1 xer1 0 0.01
CXesw1 xesw1 0 1
BXesw1 0 xesw1 I={ V(sw1)*I(L1) }
RXesw1 xesw1 0 0.01
CXqlt2 xqlt2 0 1
BXqlt2 0 xqlt2 I={ I(L2) }
RXqlt2 xqlt2 0 0.01
CXea2 xea2 0 1
BXea2 0 xea2 I={ V(rail1)*I(L2) }
RXea2 xea2 0 0.01
CXean2 xean2 0 1
BXean2 0 xean2 I={ V(a2)*I(L2) }
RXean2 xean2 0 0.01
CXeb2 xeb2 0 1
BXeb2 0 xeb2 I={ V(rail2)*I(L2) }
RXeb2 xeb2 0 0.01
CXer2 xer2 0 1
BXer2 0 xer2 I={ I(L2)*I(L2)*10 }
RXer2 xer2 0 0.01
CXesw2 xesw2 0 1
BXesw2 0 xesw2 I={ V(sw2)*I(L2) }
RXesw2 xesw2 0 0.01
CXqg1 xqg1 0 1
BXqg1 0 xqg1 I={ I(VMG1) }
RXqg1 xqg1 0 0.01
CXqg2 xqg2 0 1
BXqg2 0 xqg2 I={ I(VMG2) }
RXqg2 xqg2 0 0.01
CXqres xqres 0 1
BXqres 0 xqres I={ -I(VRES) }
RXqres xqres 0 0.01
CXqhi xqhi 0 1
BXqhi 0 xqhi I={ -I(VHI) }
RXqhi xqhi 0 0.01
CXqi1 xqi1 0 1
BXqi1 0 xqi1 I={ -(I(VI1_0)+I(VI1_1)+I(VI1_2)+I(VI1_3)+I(VI1_4)+I(VI1_5)+I(VI1_6)+I(VI1_7)) }
RXqi1 xqi1 0 0.01
CXegt xegt 0 1
BXegt 0 xegt I={ -V(gt1)*I(VGT1)-V(gtp1)*I(VGTP1)-V(pk1)*I(VPK1)-V(gt2)*I(VGT2)-V(gtp2)*I(VGTP2)-V(pk2)*I(VPK2) }
RXegt xegt 0 0.01
.ic V(res1)=1.2 V(rail1)=0 V(rail2)=0 V(a2)=0
.tran 0.1p 1300p 0 0.0884183p
.measure tran QLT1_Z FIND V(xqlt1) AT=1.500000p
.measure tran QLT1_B1 FIND V(xqlt1) AT=267.695109p
.measure tran QLT1_B2 FIND V(xqlt1) AT=598.211541p
.measure tran QLT1_K1 FIND V(xqlt1) AT=499.000000p
.measure tran QLT1_K2 FIND V(xqlt1) AT=801.000000p
.measure tran QLT1_D FIND V(xqlt1) AT=1296.000000p
.measure tran EA1_Z FIND V(xea1) AT=1.500000p
.measure tran EA1_B1 FIND V(xea1) AT=267.695109p
.measure tran EA1_B2 FIND V(xea1) AT=598.211541p
.measure tran EA1_K1 FIND V(xea1) AT=499.000000p
.measure tran EA1_K2 FIND V(xea1) AT=801.000000p
.measure tran EA1_D FIND V(xea1) AT=1296.000000p
.measure tran EAN1_Z FIND V(xean1) AT=1.500000p
.measure tran EAN1_B1 FIND V(xean1) AT=267.695109p
.measure tran EAN1_B2 FIND V(xean1) AT=598.211541p
.measure tran EAN1_K1 FIND V(xean1) AT=499.000000p
.measure tran EAN1_K2 FIND V(xean1) AT=801.000000p
.measure tran EAN1_D FIND V(xean1) AT=1296.000000p
.measure tran EB1_Z FIND V(xeb1) AT=1.500000p
.measure tran EB1_B1 FIND V(xeb1) AT=267.695109p
.measure tran EB1_B2 FIND V(xeb1) AT=598.211541p
.measure tran EB1_K1 FIND V(xeb1) AT=499.000000p
.measure tran EB1_K2 FIND V(xeb1) AT=801.000000p
.measure tran EB1_D FIND V(xeb1) AT=1296.000000p
.measure tran ER1_Z FIND V(xer1) AT=1.500000p
.measure tran ER1_B1 FIND V(xer1) AT=267.695109p
.measure tran ER1_B2 FIND V(xer1) AT=598.211541p
.measure tran ER1_K1 FIND V(xer1) AT=499.000000p
.measure tran ER1_K2 FIND V(xer1) AT=801.000000p
.measure tran ER1_D FIND V(xer1) AT=1296.000000p
.measure tran ESW1_Z FIND V(xesw1) AT=1.500000p
.measure tran ESW1_B1 FIND V(xesw1) AT=267.695109p
.measure tran ESW1_B2 FIND V(xesw1) AT=598.211541p
.measure tran ESW1_K1 FIND V(xesw1) AT=499.000000p
.measure tran ESW1_K2 FIND V(xesw1) AT=801.000000p
.measure tran ESW1_D FIND V(xesw1) AT=1296.000000p
.measure tran QLT2_Z FIND V(xqlt2) AT=1.500000p
.measure tran QLT2_B1 FIND V(xqlt2) AT=267.695109p
.measure tran QLT2_B2 FIND V(xqlt2) AT=598.211541p
.measure tran QLT2_K1 FIND V(xqlt2) AT=499.000000p
.measure tran QLT2_K2 FIND V(xqlt2) AT=801.000000p
.measure tran QLT2_D FIND V(xqlt2) AT=1296.000000p
.measure tran EA2_Z FIND V(xea2) AT=1.500000p
.measure tran EA2_B1 FIND V(xea2) AT=267.695109p
.measure tran EA2_B2 FIND V(xea2) AT=598.211541p
.measure tran EA2_K1 FIND V(xea2) AT=499.000000p
.measure tran EA2_K2 FIND V(xea2) AT=801.000000p
.measure tran EA2_D FIND V(xea2) AT=1296.000000p
.measure tran EAN2_Z FIND V(xean2) AT=1.500000p
.measure tran EAN2_B1 FIND V(xean2) AT=267.695109p
.measure tran EAN2_B2 FIND V(xean2) AT=598.211541p
.measure tran EAN2_K1 FIND V(xean2) AT=499.000000p
.measure tran EAN2_K2 FIND V(xean2) AT=801.000000p
.measure tran EAN2_D FIND V(xean2) AT=1296.000000p
.measure tran EB2_Z FIND V(xeb2) AT=1.500000p
.measure tran EB2_B1 FIND V(xeb2) AT=267.695109p
.measure tran EB2_B2 FIND V(xeb2) AT=598.211541p
.measure tran EB2_K1 FIND V(xeb2) AT=499.000000p
.measure tran EB2_K2 FIND V(xeb2) AT=801.000000p
.measure tran EB2_D FIND V(xeb2) AT=1296.000000p
.measure tran ER2_Z FIND V(xer2) AT=1.500000p
.measure tran ER2_B1 FIND V(xer2) AT=267.695109p
.measure tran ER2_B2 FIND V(xer2) AT=598.211541p
.measure tran ER2_K1 FIND V(xer2) AT=499.000000p
.measure tran ER2_K2 FIND V(xer2) AT=801.000000p
.measure tran ER2_D FIND V(xer2) AT=1296.000000p
.measure tran ESW2_Z FIND V(xesw2) AT=1.500000p
.measure tran ESW2_B1 FIND V(xesw2) AT=267.695109p
.measure tran ESW2_B2 FIND V(xesw2) AT=598.211541p
.measure tran ESW2_K1 FIND V(xesw2) AT=499.000000p
.measure tran ESW2_K2 FIND V(xesw2) AT=801.000000p
.measure tran ESW2_D FIND V(xesw2) AT=1296.000000p
.measure tran QG1_Z FIND V(xqg1) AT=1.500000p
.measure tran QG1_B1 FIND V(xqg1) AT=267.695109p
.measure tran QG1_B2 FIND V(xqg1) AT=598.211541p
.measure tran QG1_K1 FIND V(xqg1) AT=499.000000p
.measure tran QG1_K2 FIND V(xqg1) AT=801.000000p
.measure tran QG1_D FIND V(xqg1) AT=1296.000000p
.measure tran QG2_Z FIND V(xqg2) AT=1.500000p
.measure tran QG2_B1 FIND V(xqg2) AT=267.695109p
.measure tran QG2_B2 FIND V(xqg2) AT=598.211541p
.measure tran QG2_K1 FIND V(xqg2) AT=499.000000p
.measure tran QG2_K2 FIND V(xqg2) AT=801.000000p
.measure tran QG2_D FIND V(xqg2) AT=1296.000000p
.measure tran QRES_Z FIND V(xqres) AT=1.500000p
.measure tran QRES_B1 FIND V(xqres) AT=267.695109p
.measure tran QRES_B2 FIND V(xqres) AT=598.211541p
.measure tran QRES_K1 FIND V(xqres) AT=499.000000p
.measure tran QRES_K2 FIND V(xqres) AT=801.000000p
.measure tran QRES_D FIND V(xqres) AT=1296.000000p
.measure tran QHI_Z FIND V(xqhi) AT=1.500000p
.measure tran QHI_B1 FIND V(xqhi) AT=267.695109p
.measure tran QHI_B2 FIND V(xqhi) AT=598.211541p
.measure tran QHI_K1 FIND V(xqhi) AT=499.000000p
.measure tran QHI_K2 FIND V(xqhi) AT=801.000000p
.measure tran QHI_D FIND V(xqhi) AT=1296.000000p
.measure tran QI1_Z FIND V(xqi1) AT=1.500000p
.measure tran QI1_B1 FIND V(xqi1) AT=267.695109p
.measure tran QI1_B2 FIND V(xqi1) AT=598.211541p
.measure tran QI1_K1 FIND V(xqi1) AT=499.000000p
.measure tran QI1_K2 FIND V(xqi1) AT=801.000000p
.measure tran QI1_D FIND V(xqi1) AT=1296.000000p
.measure tran EGT_Z FIND V(xegt) AT=1.500000p
.measure tran EGT_B1 FIND V(xegt) AT=267.695109p
.measure tran EGT_B2 FIND V(xegt) AT=598.211541p
.measure tran EGT_K1 FIND V(xegt) AT=499.000000p
.measure tran EGT_K2 FIND V(xegt) AT=801.000000p
.measure tran EGT_D FIND V(xegt) AT=1296.000000p
.measure tran VR1Z FIND V(rail1) AT=1.500000p
.measure tran VR2Z FIND V(rail2) AT=1.500000p
.measure tran VS1Z FIND V(res1) AT=1.500000p
.measure tran VR1B1 FIND V(rail1) AT=267.695109p
.measure tran VR2B1 FIND V(rail2) AT=267.695109p
.measure tran VS1B1 FIND V(res1) AT=267.695109p
.measure tran VR1B2 FIND V(rail1) AT=598.211541p
.measure tran VR2B2 FIND V(rail2) AT=598.211541p
.measure tran VS1B2 FIND V(res1) AT=598.211541p
.measure tran VR1K1 FIND V(rail1) AT=499.000000p
.measure tran VR2K1 FIND V(rail2) AT=499.000000p
.measure tran VS1K1 FIND V(res1) AT=499.000000p
.measure tran VR1K2 FIND V(rail1) AT=801.000000p
.measure tran VR2K2 FIND V(rail2) AT=801.000000p
.measure tran VS1K2 FIND V(res1) AT=801.000000p
.measure tran VR1D FIND V(rail1) AT=1296.000000p
.measure tran VR2D FIND V(rail2) AT=1296.000000p
.measure tran VS1D FIND V(res1) AT=1296.000000p
.measure tran VR1PK MAX V(rail1) FROM=200p TO=1300p
.measure tran O1_0S FIND V(o1_0) AT=499.000000p
.measure tran O1_0E FIND V(o1_0) AT=1296.000000p
.measure tran G1_0B FIND V(in1_0) AT=499.000000p
.measure tran G1_0C FIND V(in1_0) AT=199.000000p
.measure tran G1_0X MIN V(in1_0) FROM=200p TO=498p
.measure tran O1_1S FIND V(o1_1) AT=499.000000p
.measure tran O1_1E FIND V(o1_1) AT=1296.000000p
.measure tran G1_1B FIND V(in1_1) AT=499.000000p
.measure tran G1_1C FIND V(in1_1) AT=199.000000p
.measure tran G1_1X MAX V(in1_1) FROM=200p TO=498p
.measure tran O1_2S FIND V(o1_2) AT=499.000000p
.measure tran O1_2E FIND V(o1_2) AT=1296.000000p
.measure tran G1_2B FIND V(in1_2) AT=499.000000p
.measure tran G1_2C FIND V(in1_2) AT=199.000000p
.measure tran G1_2X MIN V(in1_2) FROM=200p TO=498p
.measure tran O1_3S FIND V(o1_3) AT=499.000000p
.measure tran O1_3E FIND V(o1_3) AT=1296.000000p
.measure tran G1_3B FIND V(in1_3) AT=499.000000p
.measure tran G1_3C FIND V(in1_3) AT=199.000000p
.measure tran G1_3X MAX V(in1_3) FROM=200p TO=498p
.measure tran O1_4S FIND V(o1_4) AT=499.000000p
.measure tran O1_4E FIND V(o1_4) AT=1296.000000p
.measure tran G1_4B FIND V(in1_4) AT=499.000000p
.measure tran G1_4C FIND V(in1_4) AT=199.000000p
.measure tran G1_4X MIN V(in1_4) FROM=200p TO=498p
.measure tran O1_5S FIND V(o1_5) AT=499.000000p
.measure tran O1_5E FIND V(o1_5) AT=1296.000000p
.measure tran G1_5B FIND V(in1_5) AT=499.000000p
.measure tran G1_5C FIND V(in1_5) AT=199.000000p
.measure tran G1_5X MAX V(in1_5) FROM=200p TO=498p
.measure tran O1_6S FIND V(o1_6) AT=499.000000p
.measure tran O1_6E FIND V(o1_6) AT=1296.000000p
.measure tran G1_6B FIND V(in1_6) AT=499.000000p
.measure tran G1_6C FIND V(in1_6) AT=199.000000p
.measure tran G1_6X MIN V(in1_6) FROM=200p TO=498p
.measure tran O1_7S FIND V(o1_7) AT=499.000000p
.measure tran O1_7E FIND V(o1_7) AT=1296.000000p
.measure tran G1_7B FIND V(in1_7) AT=499.000000p
.measure tran G1_7C FIND V(in1_7) AT=199.000000p
.measure tran G1_7X MAX V(in1_7) FROM=200p TO=498p
.measure tran IZ1 FIND I(L1) AT=267.695109p
.measure tran IPK1 MAX I(L1) FROM=200p TO=1300p
.measure tran VR2PK MAX V(rail2) FROM=200p TO=1300p
.measure tran O2_0S FIND V(o2_0) AT=801.000000p
.measure tran O2_0E FIND V(o2_0) AT=1296.000000p
.measure tran G2_0B FIND V(o1_0) AT=801.000000p
.measure tran G2_0C FIND V(o1_0) AT=499.000000p
.measure tran G2_0X MAX V(o1_0) FROM=500p TO=800p
.measure tran O2_1S FIND V(o2_1) AT=801.000000p
.measure tran O2_1E FIND V(o2_1) AT=1296.000000p
.measure tran G2_1B FIND V(o1_1) AT=801.000000p
.measure tran G2_1C FIND V(o1_1) AT=499.000000p
.measure tran G2_1X MIN V(o1_1) FROM=500p TO=800p
.measure tran O2_2S FIND V(o2_2) AT=801.000000p
.measure tran O2_2E FIND V(o2_2) AT=1296.000000p
.measure tran G2_2B FIND V(o1_2) AT=801.000000p
.measure tran G2_2C FIND V(o1_2) AT=499.000000p
.measure tran G2_2X MAX V(o1_2) FROM=500p TO=800p
.measure tran O2_3S FIND V(o2_3) AT=801.000000p
.measure tran O2_3E FIND V(o2_3) AT=1296.000000p
.measure tran G2_3B FIND V(o1_3) AT=801.000000p
.measure tran G2_3C FIND V(o1_3) AT=499.000000p
.measure tran G2_3X MIN V(o1_3) FROM=500p TO=800p
.measure tran O2_4S FIND V(o2_4) AT=801.000000p
.measure tran O2_4E FIND V(o2_4) AT=1296.000000p
.measure tran G2_4B FIND V(o1_4) AT=801.000000p
.measure tran G2_4C FIND V(o1_4) AT=499.000000p
.measure tran G2_4X MAX V(o1_4) FROM=500p TO=800p
.measure tran O2_5S FIND V(o2_5) AT=801.000000p
.measure tran O2_5E FIND V(o2_5) AT=1296.000000p
.measure tran G2_5B FIND V(o1_5) AT=801.000000p
.measure tran G2_5C FIND V(o1_5) AT=499.000000p
.measure tran G2_5X MIN V(o1_5) FROM=500p TO=800p
.measure tran O2_6S FIND V(o2_6) AT=801.000000p
.measure tran O2_6E FIND V(o2_6) AT=1296.000000p
.measure tran G2_6B FIND V(o1_6) AT=801.000000p
.measure tran G2_6C FIND V(o1_6) AT=499.000000p
.measure tran G2_6X MAX V(o1_6) FROM=500p TO=800p
.measure tran O2_7S FIND V(o2_7) AT=801.000000p
.measure tran O2_7E FIND V(o2_7) AT=1296.000000p
.measure tran G2_7B FIND V(o1_7) AT=801.000000p
.measure tran G2_7C FIND V(o1_7) AT=499.000000p
.measure tran G2_7X MIN V(o1_7) FROM=500p TO=800p
.measure tran IZ2 FIND I(L2) AT=598.211541p
.measure tran IPK2 MAX I(L2) FROM=200p TO=1300p
.print tran V(rail1) V(rail2) V(res1) I(L1) I(L2) V(o1_0) V(o1_1) V(o1_2) V(o1_3) V(o1_4) V(o1_5) V(o1_6) V(o1_7) V(o2_0) V(o2_1) V(o2_2) V(o2_3) V(o2_4) V(o2_5) V(o2_6) V(o2_7) V(rm1_0) V(rb1_0) V(rm1_1) V(rb1_1)
.end
