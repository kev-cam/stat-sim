.hdl "/usr/local/share/xyce/verilog-a/psp103/psp103.va"
.include "/usr/local/src/kestrel/sim/models/sg13g2_psp103_tt.lib"
.include "/usr/local/src/stat-sim/qal/sg13lv_compat.sp"
.OPTIONS TIMEINT METHOD=GEAR RELTOL=1e-6 ABSTOL=1e-15 CHGTOL=1e-17
.param LT=15n RS=10
VHI vhi 0 1.5
VRES vres 0 1.2
CRES1 res1 0 35.979f
XRP1_0a rm1_0 o3_0 vres vres sg13_lv_pmos w=1.12u l=0.13u
XRN1_0a rm1_0 o3_0 0 0 sg13_lv_nmos w=0.74u l=0.13u
CRM1_0 rm1_0 0 2f
XRP1_0b rb1_0 rm1_0 vres vres sg13_lv_pmos w=1.12u l=0.13u
XRN1_0b rb1_0 rm1_0 0 0 sg13_lv_nmos w=0.74u l=0.13u
CRB1_0 rb1_0 0 2f
XRP1_1a rm1_1 o3_1 vres vres sg13_lv_pmos w=1.12u l=0.13u
XRN1_1a rm1_1 o3_1 0 0 sg13_lv_nmos w=0.74u l=0.13u
CRM1_1 rm1_1 0 2f
XRP1_1b rb1_1 rm1_1 vres vres sg13_lv_pmos w=1.12u l=0.13u
XRN1_1b rb1_1 rm1_1 0 0 sg13_lv_nmos w=0.74u l=0.13u
CRB1_1 rb1_1 0 2f
XRP1_2a rm1_2 o3_2 vres vres sg13_lv_pmos w=1.12u l=0.13u
XRN1_2a rm1_2 o3_2 0 0 sg13_lv_nmos w=0.74u l=0.13u
CRM1_2 rm1_2 0 2f
XRP1_2b rb1_2 rm1_2 vres vres sg13_lv_pmos w=1.12u l=0.13u
XRN1_2b rb1_2 rm1_2 0 0 sg13_lv_nmos w=0.74u l=0.13u
CRB1_2 rb1_2 0 2f
XRP1_3a rm1_3 o3_3 vres vres sg13_lv_pmos w=1.12u l=0.13u
XRN1_3a rm1_3 o3_3 0 0 sg13_lv_nmos w=0.74u l=0.13u
CRM1_3 rm1_3 0 2f
XRP1_3b rb1_3 rm1_3 vres vres sg13_lv_pmos w=1.12u l=0.13u
XRN1_3b rb1_3 rm1_3 0 0 sg13_lv_nmos w=0.74u l=0.13u
CRB1_3 rb1_3 0 2f
XRP1_4a rm1_4 o3_4 vres vres sg13_lv_pmos w=1.12u l=0.13u
XRN1_4a rm1_4 o3_4 0 0 sg13_lv_nmos w=0.74u l=0.13u
CRM1_4 rm1_4 0 2f
XRP1_4b rb1_4 rm1_4 vres vres sg13_lv_pmos w=1.12u l=0.13u
XRN1_4b rb1_4 rm1_4 0 0 sg13_lv_nmos w=0.74u l=0.13u
CRB1_4 rb1_4 0 2f
XRP1_5a rm1_5 o3_5 vres vres sg13_lv_pmos w=1.12u l=0.13u
XRN1_5a rm1_5 o3_5 0 0 sg13_lv_nmos w=0.74u l=0.13u
CRM1_5 rm1_5 0 2f
XRP1_5b rb1_5 rm1_5 vres vres sg13_lv_pmos w=1.12u l=0.13u
XRN1_5b rb1_5 rm1_5 0 0 sg13_lv_nmos w=0.74u l=0.13u
CRB1_5 rb1_5 0 2f
XRP1_6a rm1_6 o3_6 vres vres sg13_lv_pmos w=1.12u l=0.13u
XRN1_6a rm1_6 o3_6 0 0 sg13_lv_nmos w=0.74u l=0.13u
CRM1_6 rm1_6 0 2f
XRP1_6b rb1_6 rm1_6 vres vres sg13_lv_pmos w=1.12u l=0.13u
XRN1_6b rb1_6 rm1_6 0 0 sg13_lv_nmos w=0.74u l=0.13u
CRB1_6 rb1_6 0 2f
XRP1_7a rm1_7 o3_7 vres vres sg13_lv_pmos w=1.12u l=0.13u
XRN1_7a rm1_7 o3_7 0 0 sg13_lv_nmos w=0.74u l=0.13u
CRM1_7 rm1_7 0 2f
XRP1_7b rb1_7 rm1_7 vres vres sg13_lv_pmos w=1.12u l=0.13u
XRN1_7b rb1_7 rm1_7 0 0 sg13_lv_nmos w=0.74u l=0.13u
CRB1_7 rb1_7 0 2f
VMG1 gn1 0 0
VI1_0 in1_0 0 1.2
VI1_1 in1_1 0 0
VI1_2 in1_2 0 1.2
VI1_3 in1_3 0 0
VI1_4 in1_4 0 1.2
VI1_5 in1_5 0 0
VI1_6 in1_6 0 1.2
VI1_7 in1_7 0 0
XP1_0 o1_0 in1_0 rail1 rail1 sg13_lv_pmos w=1.12u l=0.13u
XN1_0 o1_0 in1_0 gn1 gn1 sg13_lv_nmos w=0.74u l=0.13u
CL1_0 o1_0 gn1 2f
XP1_1 o1_1 in1_1 rail1 rail1 sg13_lv_pmos w=1.12u l=0.13u
XN1_1 o1_1 in1_1 gn1 gn1 sg13_lv_nmos w=0.74u l=0.13u
CL1_1 o1_1 gn1 2f
XP1_2 o1_2 in1_2 rail1 rail1 sg13_lv_pmos w=1.12u l=0.13u
XN1_2 o1_2 in1_2 gn1 gn1 sg13_lv_nmos w=0.74u l=0.13u
CL1_2 o1_2 gn1 2f
XP1_3 o1_3 in1_3 rail1 rail1 sg13_lv_pmos w=1.12u l=0.13u
XN1_3 o1_3 in1_3 gn1 gn1 sg13_lv_nmos w=0.74u l=0.13u
CL1_3 o1_3 gn1 2f
XP1_4 o1_4 in1_4 rail1 rail1 sg13_lv_pmos w=1.12u l=0.13u
XN1_4 o1_4 in1_4 gn1 gn1 sg13_lv_nmos w=0.74u l=0.13u
CL1_4 o1_4 gn1 2f
XP1_5 o1_5 in1_5 rail1 rail1 sg13_lv_pmos w=1.12u l=0.13u
XN1_5 o1_5 in1_5 gn1 gn1 sg13_lv_nmos w=0.74u l=0.13u
CL1_5 o1_5 gn1 2f
XP1_6 o1_6 in1_6 rail1 rail1 sg13_lv_pmos w=1.12u l=0.13u
XN1_6 o1_6 in1_6 gn1 gn1 sg13_lv_nmos w=0.74u l=0.13u
CL1_6 o1_6 gn1 2f
XP1_7 o1_7 in1_7 rail1 rail1 sg13_lv_pmos w=1.12u l=0.13u
XN1_7 o1_7 in1_7 gn1 gn1 sg13_lv_nmos w=0.74u l=0.13u
CL1_7 o1_7 gn1 2f
VMG2 gn2 0 0
XP2_0 o2_0 o1_0 rail2 rail2 sg13_lv_pmos w=1.12u l=0.13u
XN2_0 o2_0 o1_0 gn2 gn2 sg13_lv_nmos w=0.74u l=0.13u
CL2_0 o2_0 gn2 2f
XP2_1 o2_1 o1_1 rail2 rail2 sg13_lv_pmos w=1.12u l=0.13u
XN2_1 o2_1 o1_1 gn2 gn2 sg13_lv_nmos w=0.74u l=0.13u
CL2_1 o2_1 gn2 2f
XP2_2 o2_2 o1_2 rail2 rail2 sg13_lv_pmos w=1.12u l=0.13u
XN2_2 o2_2 o1_2 gn2 gn2 sg13_lv_nmos w=0.74u l=0.13u
CL2_2 o2_2 gn2 2f
XP2_3 o2_3 o1_3 rail2 rail2 sg13_lv_pmos w=1.12u l=0.13u
XN2_3 o2_3 o1_3 gn2 gn2 sg13_lv_nmos w=0.74u l=0.13u
CL2_3 o2_3 gn2 2f
XP2_4 o2_4 o1_4 rail2 rail2 sg13_lv_pmos w=1.12u l=0.13u
XN2_4 o2_4 o1_4 gn2 gn2 sg13_lv_nmos w=0.74u l=0.13u
CL2_4 o2_4 gn2 2f
XP2_5 o2_5 o1_5 rail2 rail2 sg13_lv_pmos w=1.12u l=0.13u
XN2_5 o2_5 o1_5 gn2 gn2 sg13_lv_nmos w=0.74u l=0.13u
CL2_5 o2_5 gn2 2f
XP2_6 o2_6 o1_6 rail2 rail2 sg13_lv_pmos w=1.12u l=0.13u
XN2_6 o2_6 o1_6 gn2 gn2 sg13_lv_nmos w=0.74u l=0.13u
CL2_6 o2_6 gn2 2f
XP2_7 o2_7 o1_7 rail2 rail2 sg13_lv_pmos w=1.12u l=0.13u
XN2_7 o2_7 o1_7 gn2 gn2 sg13_lv_nmos w=0.74u l=0.13u
CL2_7 o2_7 gn2 2f
VMG3 gn3 0 0
XP3_0 o3_0 o2_0 rail3 rail3 sg13_lv_pmos w=1.12u l=0.13u
XN3_0 o3_0 o2_0 gn3 gn3 sg13_lv_nmos w=0.74u l=0.13u
CL3_0 o3_0 gn3 2f
XP3_1 o3_1 o2_1 rail3 rail3 sg13_lv_pmos w=1.12u l=0.13u
XN3_1 o3_1 o2_1 gn3 gn3 sg13_lv_nmos w=0.74u l=0.13u
CL3_1 o3_1 gn3 2f
XP3_2 o3_2 o2_2 rail3 rail3 sg13_lv_pmos w=1.12u l=0.13u
XN3_2 o3_2 o2_2 gn3 gn3 sg13_lv_nmos w=0.74u l=0.13u
CL3_2 o3_2 gn3 2f
XP3_3 o3_3 o2_3 rail3 rail3 sg13_lv_pmos w=1.12u l=0.13u
XN3_3 o3_3 o2_3 gn3 gn3 sg13_lv_nmos w=0.74u l=0.13u
CL3_3 o3_3 gn3 2f
XP3_4 o3_4 o2_4 rail3 rail3 sg13_lv_pmos w=1.12u l=0.13u
XN3_4 o3_4 o2_4 gn3 gn3 sg13_lv_nmos w=0.74u l=0.13u
CL3_4 o3_4 gn3 2f
XP3_5 o3_5 o2_5 rail3 rail3 sg13_lv_pmos w=1.12u l=0.13u
XN3_5 o3_5 o2_5 gn3 gn3 sg13_lv_nmos w=0.74u l=0.13u
CL3_5 o3_5 gn3 2f
XP3_6 o3_6 o2_6 rail3 rail3 sg13_lv_pmos w=1.12u l=0.13u
XN3_6 o3_6 o2_6 gn3 gn3 sg13_lv_nmos w=0.74u l=0.13u
CL3_6 o3_6 gn3 2f
XP3_7 o3_7 o2_7 rail3 rail3 sg13_lv_pmos w=1.12u l=0.13u
XN3_7 o3_7 o2_7 gn3 gn3 sg13_lv_nmos w=0.74u l=0.13u
CL3_7 o3_7 gn3 2f
L1 res1 mid1 {LT}
R1 mid1 sw1 {RS}
XSWN1 sw1 gt1 rail1 0 sg13_lv_nmos w=10u l=0.13u
XSWP1 sw1 gtp1 rail1 vhi sg13_lv_pmos w=20u l=0.13u
XPK1 sw1 pk1 0 0 sg13_lv_nmos w=2u l=0.13u
L2 a2 mid2 {LT}
R2 mid2 sw2 {RS}
XSWN2 sw2 gt2 rail2 0 sg13_lv_nmos w=10u l=0.13u
XSWP2 sw2 gtp2 rail2 vhi sg13_lv_pmos w=20u l=0.13u
XPK2 sw2 pk2 0 0 sg13_lv_nmos w=2u l=0.13u
XSWSN2 a2 gt2 rail1 0 sg13_lv_nmos w=10u l=0.13u
XSWSP2 a2 gtp2 rail1 vhi sg13_lv_pmos w=20u l=0.13u
L3 a3 mid3 {LT}
R3 mid3 sw3 {RS}
XSWN3 sw3 gt3 rail3 0 sg13_lv_nmos w=10u l=0.13u
XSWP3 sw3 gtp3 rail3 vhi sg13_lv_pmos w=20u l=0.13u
XPK3 sw3 pk3 0 0 sg13_lv_nmos w=2u l=0.13u
XSWSN3 a3 gt3 rail2 0 sg13_lv_nmos w=10u l=0.13u
XSWSP3 a3 gtp3 rail2 vhi sg13_lv_pmos w=20u l=0.13u
VGT1 gt1 0 PWL(0 0 198p 0 200p 1.5 6400p 1.5)
VGTP1 gtp1 0 PWL(0 1.5 198p 1.5 200p 0 6400p 0)
VPK1 pk1 0 0
VGT2 gt2 0 0
VGTP2 gtp2 0 1.5
VPK2 pk2 0 1.5
VGT3 gt3 0 0
VGTP3 gtp3 0 1.5
VPK3 pk3 0 1.5
.ic V(res1)=1.2 V(rail1)=0 V(rail2)=0 V(rail3)=0 V(a2)=0 V(a3)=0
.tran 0.1p 359.153p 0 0.0884183p
.print tran I(L1) I(L2) I(L3) V(rail1) V(rail2) V(rail3) V(res1) V(sw1) V(sw2) V(sw3) V(a2) V(a3) V(rm1_0) V(rb1_0) V(rm1_1) V(rb1_1)
.end
