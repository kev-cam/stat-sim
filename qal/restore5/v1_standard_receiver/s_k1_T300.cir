.hdl "/usr/local/share/xyce/verilog-a/psp103/psp103.va"
.include "/usr/local/src/kestrel/sim/models/sg13g2_psp103_tt.lib"
.include "/usr/local/src/stat-sim/qal/sg13lv_compat.sp"
.OPTIONS TIMEINT METHOD=GEAR RELTOL=1e-6 ABSTOL=1e-15 CHGTOL=1e-17
.param LT=15n RS=10
VHI vhi 0 1.5
VRES vres 0 1.2
CRES1 res1 0 35.979f
XRP1_0a rm1_0 o1_0 vres vres sg13_lv_pmos w=1.12u l=0.13u
XRN1_0a rm1_0 o1_0 0 0 sg13_lv_nmos w=0.74u l=0.13u
CRM1_0 rm1_0 0 2f
XRP1_0b rb1_0 rm1_0 vres vres sg13_lv_pmos w=1.12u l=0.13u
XRN1_0b rb1_0 rm1_0 0 0 sg13_lv_nmos w=0.74u l=0.13u
CRB1_0 rb1_0 0 2f
XRP1_1a rm1_1 o1_1 vres vres sg13_lv_pmos w=1.12u l=0.13u
XRN1_1a rm1_1 o1_1 0 0 sg13_lv_nmos w=0.74u l=0.13u
CRM1_1 rm1_1 0 2f
XRP1_1b rb1_1 rm1_1 vres vres sg13_lv_pmos w=1.12u l=0.13u
XRN1_1b rb1_1 rm1_1 0 0 sg13_lv_nmos w=0.74u l=0.13u
CRB1_1 rb1_1 0 2f
XRP1_2a rm1_2 o1_2 vres vres sg13_lv_pmos w=1.12u l=0.13u
XRN1_2a rm1_2 o1_2 0 0 sg13_lv_nmos w=0.74u l=0.13u
CRM1_2 rm1_2 0 2f
XRP1_2b rb1_2 rm1_2 vres vres sg13_lv_pmos w=1.12u l=0.13u
XRN1_2b rb1_2 rm1_2 0 0 sg13_lv_nmos w=0.74u l=0.13u
CRB1_2 rb1_2 0 2f
XRP1_3a rm1_3 o1_3 vres vres sg13_lv_pmos w=1.12u l=0.13u
XRN1_3a rm1_3 o1_3 0 0 sg13_lv_nmos w=0.74u l=0.13u
CRM1_3 rm1_3 0 2f
XRP1_3b rb1_3 rm1_3 vres vres sg13_lv_pmos w=1.12u l=0.13u
XRN1_3b rb1_3 rm1_3 0 0 sg13_lv_nmos w=0.74u l=0.13u
CRB1_3 rb1_3 0 2f
XRP1_4a rm1_4 o1_4 vres vres sg13_lv_pmos w=1.12u l=0.13u
XRN1_4a rm1_4 o1_4 0 0 sg13_lv_nmos w=0.74u l=0.13u
CRM1_4 rm1_4 0 2f
XRP1_4b rb1_4 rm1_4 vres vres sg13_lv_pmos w=1.12u l=0.13u
XRN1_4b rb1_4 rm1_4 0 0 sg13_lv_nmos w=0.74u l=0.13u
CRB1_4 rb1_4 0 2f
XRP1_5a rm1_5 o1_5 vres vres sg13_lv_pmos w=1.12u l=0.13u
XRN1_5a rm1_5 o1_5 0 0 sg13_lv_nmos w=0.74u l=0.13u
CRM1_5 rm1_5 0 2f
XRP1_5b rb1_5 rm1_5 vres vres sg13_lv_pmos w=1.12u l=0.13u
XRN1_5b rb1_5 rm1_5 0 0 sg13_lv_nmos w=0.74u l=0.13u
CRB1_5 rb1_5 0 2f
XRP1_6a rm1_6 o1_6 vres vres sg13_lv_pmos w=1.12u l=0.13u
XRN1_6a rm1_6 o1_6 0 0 sg13_lv_nmos w=0.74u l=0.13u
CRM1_6 rm1_6 0 2f
XRP1_6b rb1_6 rm1_6 vres vres sg13_lv_pmos w=1.12u l=0.13u
XRN1_6b rb1_6 rm1_6 0 0 sg13_lv_nmos w=0.74u l=0.13u
CRB1_6 rb1_6 0 2f
XRP1_7a rm1_7 o1_7 vres vres sg13_lv_pmos w=1.12u l=0.13u
XRN1_7a rm1_7 o1_7 0 0 sg13_lv_nmos w=0.74u l=0.13u
CRM1_7 rm1_7 0 2f
XRP1_7b rb1_7 rm1_7 vres vres sg13_lv_pmos w=1.12u l=0.13u
XRN1_7b rb1_7 rm1_7 0 0 sg13_lv_nmos w=0.74u l=0.13u
CRB1_7 rb1_7 0 2f
VMG1 gn1 0 0
VI1_0 in1_0 0 1.2
VI1_1 in1_1 0 0
VI1_2 in1_2 0 1.2
VI1_3 in1_3 0 0
VI1_4 in1_4 0 1.2
VI1_5 in1_5 0 0
VI1_6 in1_6 0 1.2
VI1_7 in1_7 0 0
XP1_0 o1_0 in1_0 rail1 rail1 sg13_lv_pmos w=1.12u l=0.13u
XN1_0 o1_0 in1_0 gn1 gn1 sg13_lv_nmos w=0.74u l=0.13u
CL1_0 o1_0 gn1 2f
XP1_1 o1_1 in1_1 rail1 rail1 sg13_lv_pmos w=1.12u l=0.13u
XN1_1 o1_1 in1_1 gn1 gn1 sg13_lv_nmos w=0.74u l=0.13u
CL1_1 o1_1 gn1 2f
XP1_2 o1_2 in1_2 rail1 rail1 sg13_lv_pmos w=1.12u l=0.13u
XN1_2 o1_2 in1_2 gn1 gn1 sg13_lv_nmos w=0.74u l=0.13u
CL1_2 o1_2 gn1 2f
XP1_3 o1_3 in1_3 rail1 rail1 sg13_lv_pmos w=1.12u l=0.13u
XN1_3 o1_3 in1_3 gn1 gn1 sg13_lv_nmos w=0.74u l=0.13u
CL1_3 o1_3 gn1 2f
XP1_4 o1_4 in1_4 rail1 rail1 sg13_lv_pmos w=1.12u l=0.13u
XN1_4 o1_4 in1_4 gn1 gn1 sg13_lv_nmos w=0.74u l=0.13u
CL1_4 o1_4 gn1 2f
XP1_5 o1_5 in1_5 rail1 rail1 sg13_lv_pmos w=1.12u l=0.13u
XN1_5 o1_5 in1_5 gn1 gn1 sg13_lv_nmos w=0.74u l=0.13u
CL1_5 o1_5 gn1 2f
XP1_6 o1_6 in1_6 rail1 rail1 sg13_lv_pmos w=1.12u l=0.13u
XN1_6 o1_6 in1_6 gn1 gn1 sg13_lv_nmos w=0.74u l=0.13u
CL1_6 o1_6 gn1 2f
XP1_7 o1_7 in1_7 rail1 rail1 sg13_lv_pmos w=1.12u l=0.13u
XN1_7 o1_7 in1_7 gn1 gn1 sg13_lv_nmos w=0.74u l=0.13u
CL1_7 o1_7 gn1 2f
L1 res1 mid1 {LT}
R1 mid1 sw1 {RS}
XSWN1 sw1 gt1 rail1 0 sg13_lv_nmos w=10u l=0.13u
XSWP1 sw1 gtp1 rail1 vhi sg13_lv_pmos w=20u l=0.13u
XPK1 sw1 pk1 0 0 sg13_lv_nmos w=2u l=0.13u
VGT1 gt1 0 PWL(0 0 198p 0 200p 1.5 265.549p 1.5 267.549p 0)
VGTP1 gtp1 0 PWL(0 1.5 198p 1.5 200p 0 265.549p 0 267.549p 1.5)
VPK1 pk1 0 PWL(0 0 267.549p 0 269.549p 1.5)
CXqlt1 xqlt1 0 1
BXqlt1 0 xqlt1 I={ I(L1) }
RXqlt1 xqlt1 0 0.01
CXea1 xea1 0 1
BXea1 0 xea1 I={ V(res1)*I(L1) }
RXea1 xea1 0 0.01
CXean1 xean1 0 1
BXean1 0 xean1 I={ V(res1)*I(L1) }
RXean1 xean1 0 0.01
CXeb1 xeb1 0 1
BXeb1 0 xeb1 I={ V(rail1)*I(L1) }
RXeb1 xeb1 0 0.01
CXer1 xer1 0 1
BXer1 0 xer1 I={ I(L1)*I(L1)*10 }
RXer1 xer1 0 0.01
CXesw1 xesw1 0 1
BXesw1 0 xesw1 I={ V(sw1)*I(L1) }
RXesw1 xesw1 0 0.01
CXqg1 xqg1 0 1
BXqg1 0 xqg1 I={ I(VMG1) }
RXqg1 xqg1 0 0.01
CXqres xqres 0 1
BXqres 0 xqres I={ -I(VRES) }
RXqres xqres 0 0.01
CXqhi xqhi 0 1
BXqhi 0 xqhi I={ -I(VHI) }
RXqhi xqhi 0 0.01
CXqi1 xqi1 0 1
BXqi1 0 xqi1 I={ -(I(VI1_0)+I(VI1_1)+I(VI1_2)+I(VI1_3)+I(VI1_4)+I(VI1_5)+I(VI1_6)+I(VI1_7)) }
RXqi1 xqi1 0 0.01
CXegt xegt 0 1
BXegt 0 xegt I={ -V(gt1)*I(VGT1)-V(gtp1)*I(VGTP1)-V(pk1)*I(VPK1) }
RXegt xegt 0 0.01
.ic V(res1)=1.2 V(rail1)=0
.tran 0.1p 1000p 0 0.0884183p
.measure tran QLT1_Z FIND V(xqlt1) AT=1.500000p
.measure tran QLT1_B1 FIND V(xqlt1) AT=266.548701p
.measure tran QLT1_K1 FIND V(xqlt1) AT=501.000000p
.measure tran QLT1_D FIND V(xqlt1) AT=996.000000p
.measure tran EA1_Z FIND V(xea1) AT=1.500000p
.measure tran EA1_B1 FIND V(xea1) AT=266.548701p
.measure tran EA1_K1 FIND V(xea1) AT=501.000000p
.measure tran EA1_D FIND V(xea1) AT=996.000000p
.measure tran EAN1_Z FIND V(xean1) AT=1.500000p
.measure tran EAN1_B1 FIND V(xean1) AT=266.548701p
.measure tran EAN1_K1 FIND V(xean1) AT=501.000000p
.measure tran EAN1_D FIND V(xean1) AT=996.000000p
.measure tran EB1_Z FIND V(xeb1) AT=1.500000p
.measure tran EB1_B1 FIND V(xeb1) AT=266.548701p
.measure tran EB1_K1 FIND V(xeb1) AT=501.000000p
.measure tran EB1_D FIND V(xeb1) AT=996.000000p
.measure tran ER1_Z FIND V(xer1) AT=1.500000p
.measure tran ER1_B1 FIND V(xer1) AT=266.548701p
.measure tran ER1_K1 FIND V(xer1) AT=501.000000p
.measure tran ER1_D FIND V(xer1) AT=996.000000p
.measure tran ESW1_Z FIND V(xesw1) AT=1.500000p
.measure tran ESW1_B1 FIND V(xesw1) AT=266.548701p
.measure tran ESW1_K1 FIND V(xesw1) AT=501.000000p
.measure tran ESW1_D FIND V(xesw1) AT=996.000000p
.measure tran QG1_Z FIND V(xqg1) AT=1.500000p
.measure tran QG1_B1 FIND V(xqg1) AT=266.548701p
.measure tran QG1_K1 FIND V(xqg1) AT=501.000000p
.measure tran QG1_D FIND V(xqg1) AT=996.000000p
.measure tran QRES_Z FIND V(xqres) AT=1.500000p
.measure tran QRES_B1 FIND V(xqres) AT=266.548701p
.measure tran QRES_K1 FIND V(xqres) AT=501.000000p
.measure tran QRES_D FIND V(xqres) AT=996.000000p
.measure tran QHI_Z FIND V(xqhi) AT=1.500000p
.measure tran QHI_B1 FIND V(xqhi) AT=266.548701p
.measure tran QHI_K1 FIND V(xqhi) AT=501.000000p
.measure tran QHI_D FIND V(xqhi) AT=996.000000p
.measure tran QI1_Z FIND V(xqi1) AT=1.500000p
.measure tran QI1_B1 FIND V(xqi1) AT=266.548701p
.measure tran QI1_K1 FIND V(xqi1) AT=501.000000p
.measure tran QI1_D FIND V(xqi1) AT=996.000000p
.measure tran EGT_Z FIND V(xegt) AT=1.500000p
.measure tran EGT_B1 FIND V(xegt) AT=266.548701p
.measure tran EGT_K1 FIND V(xegt) AT=501.000000p
.measure tran EGT_D FIND V(xegt) AT=996.000000p
.measure tran VR1Z FIND V(rail1) AT=1.500000p
.measure tran VS1Z FIND V(res1) AT=1.500000p
.measure tran VR1B1 FIND V(rail1) AT=266.548701p
.measure tran VS1B1 FIND V(res1) AT=266.548701p
.measure tran VR1K1 FIND V(rail1) AT=501.000000p
.measure tran VS1K1 FIND V(res1) AT=501.000000p
.measure tran VR1D FIND V(rail1) AT=996.000000p
.measure tran VS1D FIND V(res1) AT=996.000000p
.measure tran VR1PK MAX V(rail1) FROM=200p TO=1000p
.measure tran O1_0S FIND V(o1_0) AT=501.000000p
.measure tran O1_0E FIND V(o1_0) AT=996.000000p
.measure tran G1_0B FIND V(in1_0) AT=501.000000p
.measure tran G1_0C FIND V(in1_0) AT=199.000000p
.measure tran G1_0X MIN V(in1_0) FROM=200p TO=500p
.measure tran O1_1S FIND V(o1_1) AT=501.000000p
.measure tran O1_1E FIND V(o1_1) AT=996.000000p
.measure tran G1_1B FIND V(in1_1) AT=501.000000p
.measure tran G1_1C FIND V(in1_1) AT=199.000000p
.measure tran G1_1X MAX V(in1_1) FROM=200p TO=500p
.measure tran O1_2S FIND V(o1_2) AT=501.000000p
.measure tran O1_2E FIND V(o1_2) AT=996.000000p
.measure tran G1_2B FIND V(in1_2) AT=501.000000p
.measure tran G1_2C FIND V(in1_2) AT=199.000000p
.measure tran G1_2X MIN V(in1_2) FROM=200p TO=500p
.measure tran O1_3S FIND V(o1_3) AT=501.000000p
.measure tran O1_3E FIND V(o1_3) AT=996.000000p
.measure tran G1_3B FIND V(in1_3) AT=501.000000p
.measure tran G1_3C FIND V(in1_3) AT=199.000000p
.measure tran G1_3X MAX V(in1_3) FROM=200p TO=500p
.measure tran O1_4S FIND V(o1_4) AT=501.000000p
.measure tran O1_4E FIND V(o1_4) AT=996.000000p
.measure tran G1_4B FIND V(in1_4) AT=501.000000p
.measure tran G1_4C FIND V(in1_4) AT=199.000000p
.measure tran G1_4X MIN V(in1_4) FROM=200p TO=500p
.measure tran O1_5S FIND V(o1_5) AT=501.000000p
.measure tran O1_5E FIND V(o1_5) AT=996.000000p
.measure tran G1_5B FIND V(in1_5) AT=501.000000p
.measure tran G1_5C FIND V(in1_5) AT=199.000000p
.measure tran G1_5X MAX V(in1_5) FROM=200p TO=500p
.measure tran O1_6S FIND V(o1_6) AT=501.000000p
.measure tran O1_6E FIND V(o1_6) AT=996.000000p
.measure tran G1_6B FIND V(in1_6) AT=501.000000p
.measure tran G1_6C FIND V(in1_6) AT=199.000000p
.measure tran G1_6X MIN V(in1_6) FROM=200p TO=500p
.measure tran O1_7S FIND V(o1_7) AT=501.000000p
.measure tran O1_7E FIND V(o1_7) AT=996.000000p
.measure tran G1_7B FIND V(in1_7) AT=501.000000p
.measure tran G1_7C FIND V(in1_7) AT=199.000000p
.measure tran G1_7X MAX V(in1_7) FROM=200p TO=500p
.measure tran IZ1 FIND I(L1) AT=266.548701p
.measure tran IPK1 MAX I(L1) FROM=200p TO=1000p
.print tran V(rail1) V(res1) I(L1) V(o1_0) V(o1_1) V(o1_2) V(o1_3) V(o1_4) V(o1_5) V(o1_6) V(o1_7) V(rm1_0) V(rb1_0) V(rm1_1) V(rb1_1)
.end
