.hdl "/usr/local/share/xyce/verilog-a/psp103/psp103.va"
.include "/usr/local/src/kestrel/sim/models/sg13g2_psp103_tt.lib"
.include "/usr/local/src/stat-sim/qal/sg13lv_compat.sp"
.OPTIONS TIMEINT METHOD=GEAR RELTOL=1e-6 ABSTOL=1e-15 CHGTOL=1e-17
VHI vhi 0 2.174
VMG1 gn1 0 0
VI1_0 in1_0 0 1.65
VI1_1 in1_1 0 1.65
VI1_2 in1_2 0 1.65
VI1_3 in1_3 0 0
VI1_4 in1_4 0 1.65
VI1_5 in1_5 0 0
VI1_6 in1_6 0 0
VI1_7 in1_7 0 1.65
XP1_0 o1_0 in1_0 rail1 rail1 sg13_lv_pmos w=1.12u l=0.13u
XN1_0 o1_0 in1_0 gn1 gn1 sg13_lv_nmos w=0.74u l=0.13u
CL1_0 o1_0 gn1 2f
XP1_1 o1_1 in1_1 rail1 rail1 sg13_lv_pmos w=1.12u l=0.13u
XN1_1 o1_1 in1_1 gn1 gn1 sg13_lv_nmos w=0.74u l=0.13u
CL1_1 o1_1 gn1 2f
XP1_2 o1_2 in1_2 rail1 rail1 sg13_lv_pmos w=1.12u l=0.13u
XN1_2 o1_2 in1_2 gn1 gn1 sg13_lv_nmos w=0.74u l=0.13u
CL1_2 o1_2 gn1 2f
XP1_3 o1_3 in1_3 rail1 rail1 sg13_lv_pmos w=1.12u l=0.13u
XN1_3 o1_3 in1_3 gn1 gn1 sg13_lv_nmos w=0.74u l=0.13u
CL1_3 o1_3 gn1 2f
XP1_4 o1_4 in1_4 rail1 rail1 sg13_lv_pmos w=1.12u l=0.13u
XN1_4 o1_4 in1_4 gn1 gn1 sg13_lv_nmos w=0.74u l=0.13u
CL1_4 o1_4 gn1 2f
XP1_5 o1_5 in1_5 rail1 rail1 sg13_lv_pmos w=1.12u l=0.13u
XN1_5 o1_5 in1_5 gn1 gn1 sg13_lv_nmos w=0.74u l=0.13u
CL1_5 o1_5 gn1 2f
XP1_6 o1_6 in1_6 rail1 rail1 sg13_lv_pmos w=1.12u l=0.13u
XN1_6 o1_6 in1_6 gn1 gn1 sg13_lv_nmos w=0.74u l=0.13u
CL1_6 o1_6 gn1 2f
XP1_7 o1_7 in1_7 rail1 rail1 sg13_lv_pmos w=1.12u l=0.13u
XN1_7 o1_7 in1_7 gn1 gn1 sg13_lv_nmos w=0.74u l=0.13u
CL1_7 o1_7 gn1 2f
VMG2 gn2 0 0
XP2_0 o2_0 o1_0 rail2 rail2 sg13_lv_pmos w=1.12u l=0.13u
XN2_0 o2_0 o1_0 gn2 gn2 sg13_lv_nmos w=0.74u l=0.13u
CL2_0 o2_0 gn2 2f
XP2_1 o2_1 o1_1 rail2 rail2 sg13_lv_pmos w=1.12u l=0.13u
XN2_1 o2_1 o1_1 gn2 gn2 sg13_lv_nmos w=0.74u l=0.13u
CL2_1 o2_1 gn2 2f
XP2_2 o2_2 o1_2 rail2 rail2 sg13_lv_pmos w=1.12u l=0.13u
XN2_2 o2_2 o1_2 gn2 gn2 sg13_lv_nmos w=0.74u l=0.13u
CL2_2 o2_2 gn2 2f
XP2_3 o2_3 o1_3 rail2 rail2 sg13_lv_pmos w=1.12u l=0.13u
XN2_3 o2_3 o1_3 gn2 gn2 sg13_lv_nmos w=0.74u l=0.13u
CL2_3 o2_3 gn2 2f
XP2_4 o2_4 o1_4 rail2 rail2 sg13_lv_pmos w=1.12u l=0.13u
XN2_4 o2_4 o1_4 gn2 gn2 sg13_lv_nmos w=0.74u l=0.13u
CL2_4 o2_4 gn2 2f
XP2_5 o2_5 o1_5 rail2 rail2 sg13_lv_pmos w=1.12u l=0.13u
XN2_5 o2_5 o1_5 gn2 gn2 sg13_lv_nmos w=0.74u l=0.13u
CL2_5 o2_5 gn2 2f
XP2_6 o2_6 o1_6 rail2 rail2 sg13_lv_pmos w=1.12u l=0.13u
XN2_6 o2_6 o1_6 gn2 gn2 sg13_lv_nmos w=0.74u l=0.13u
CL2_6 o2_6 gn2 2f
XP2_7 o2_7 o1_7 rail2 rail2 sg13_lv_pmos w=1.12u l=0.13u
XN2_7 o2_7 o1_7 gn2 gn2 sg13_lv_nmos w=0.74u l=0.13u
CL2_7 o2_7 gn2 2f
VMG3 gn3 0 0
XP3_0 o3_0 o2_0 rail3 rail3 sg13_lv_pmos w=1.12u l=0.13u
XN3_0 o3_0 o2_0 gn3 gn3 sg13_lv_nmos w=0.74u l=0.13u
CL3_0 o3_0 gn3 2f
XP3_1 o3_1 o2_1 rail3 rail3 sg13_lv_pmos w=1.12u l=0.13u
XN3_1 o3_1 o2_1 gn3 gn3 sg13_lv_nmos w=0.74u l=0.13u
CL3_1 o3_1 gn3 2f
XP3_2 o3_2 o2_2 rail3 rail3 sg13_lv_pmos w=1.12u l=0.13u
XN3_2 o3_2 o2_2 gn3 gn3 sg13_lv_nmos w=0.74u l=0.13u
CL3_2 o3_2 gn3 2f
XP3_3 o3_3 o2_3 rail3 rail3 sg13_lv_pmos w=1.12u l=0.13u
XN3_3 o3_3 o2_3 gn3 gn3 sg13_lv_nmos w=0.74u l=0.13u
CL3_3 o3_3 gn3 2f
XP3_4 o3_4 o2_4 rail3 rail3 sg13_lv_pmos w=1.12u l=0.13u
XN3_4 o3_4 o2_4 gn3 gn3 sg13_lv_nmos w=0.74u l=0.13u
CL3_4 o3_4 gn3 2f
XP3_5 o3_5 o2_5 rail3 rail3 sg13_lv_pmos w=1.12u l=0.13u
XN3_5 o3_5 o2_5 gn3 gn3 sg13_lv_nmos w=0.74u l=0.13u
CL3_5 o3_5 gn3 2f
XP3_6 o3_6 o2_6 rail3 rail3 sg13_lv_pmos w=1.12u l=0.13u
XN3_6 o3_6 o2_6 gn3 gn3 sg13_lv_nmos w=0.74u l=0.13u
CL3_6 o3_6 gn3 2f
XP3_7 o3_7 o2_7 rail3 rail3 sg13_lv_pmos w=1.12u l=0.13u
XN3_7 o3_7 o2_7 gn3 gn3 sg13_lv_nmos w=0.74u l=0.13u
CL3_7 o3_7 gn3 2f
VMG4 gn4 0 0
XP4_0 o4_0 o3_0 rail4 rail4 sg13_lv_pmos w=1.12u l=0.13u
XN4_0 o4_0 o3_0 gn4 gn4 sg13_lv_nmos w=0.74u l=0.13u
CL4_0 o4_0 gn4 2f
XP4_1 o4_1 o3_1 rail4 rail4 sg13_lv_pmos w=1.12u l=0.13u
XN4_1 o4_1 o3_1 gn4 gn4 sg13_lv_nmos w=0.74u l=0.13u
CL4_1 o4_1 gn4 2f
XP4_2 o4_2 o3_2 rail4 rail4 sg13_lv_pmos w=1.12u l=0.13u
XN4_2 o4_2 o3_2 gn4 gn4 sg13_lv_nmos w=0.74u l=0.13u
CL4_2 o4_2 gn4 2f
XP4_3 o4_3 o3_3 rail4 rail4 sg13_lv_pmos w=1.12u l=0.13u
XN4_3 o4_3 o3_3 gn4 gn4 sg13_lv_nmos w=0.74u l=0.13u
CL4_3 o4_3 gn4 2f
XP4_4 o4_4 o3_4 rail4 rail4 sg13_lv_pmos w=1.12u l=0.13u
XN4_4 o4_4 o3_4 gn4 gn4 sg13_lv_nmos w=0.74u l=0.13u
CL4_4 o4_4 gn4 2f
XP4_5 o4_5 o3_5 rail4 rail4 sg13_lv_pmos w=1.12u l=0.13u
XN4_5 o4_5 o3_5 gn4 gn4 sg13_lv_nmos w=0.74u l=0.13u
CL4_5 o4_5 gn4 2f
XP4_6 o4_6 o3_6 rail4 rail4 sg13_lv_pmos w=1.12u l=0.13u
XN4_6 o4_6 o3_6 gn4 gn4 sg13_lv_nmos w=0.74u l=0.13u
CL4_6 o4_6 gn4 2f
XP4_7 o4_7 o3_7 rail4 rail4 sg13_lv_pmos w=1.12u l=0.13u
XN4_7 o4_7 o3_7 gn4 gn4 sg13_lv_nmos w=0.74u l=0.13u
CL4_7 o4_7 gn4 2f
CT1 tnk1 0 359.79f
L1 tnk1 mid1 15n
R1 mid1 sw1 10
XSWN1 sw1 gt1 rail1 0 sg13_lv_nmos w=10u l=0.13u
XSWP1 sw1 gtp1 rail1 vhi sg13_lv_pmos w=20u l=0.13u
XPK1 sw1 pk1 tnk1 tnk1 sg13_lv_nmos w=2u l=0.13u
CT2 tnk2 0 359.79f
L2 tnk2 mid2 15n
R2 mid2 sw2 10
XSWN2 sw2 gt2 rail2 0 sg13_lv_nmos w=10u l=0.13u
XSWP2 sw2 gtp2 rail2 vhi sg13_lv_pmos w=20u l=0.13u
XPK2 sw2 pk2 tnk2 tnk2 sg13_lv_nmos w=2u l=0.13u
CT3 tnk3 0 359.79f
L3 tnk3 mid3 15n
R3 mid3 sw3 10
XSWN3 sw3 gt3 rail3 0 sg13_lv_nmos w=10u l=0.13u
XSWP3 sw3 gtp3 rail3 vhi sg13_lv_pmos w=20u l=0.13u
XPK3 sw3 pk3 tnk3 tnk3 sg13_lv_nmos w=2u l=0.13u
CT4 tnk4 0 359.79f
L4 tnk4 mid4 15n
R4 mid4 sw4 10
XSWN4 sw4 gt4 rail4 0 sg13_lv_nmos w=10u l=0.13u
XSWP4 sw4 gtp4 rail4 vhi sg13_lv_pmos w=20u l=0.13u
XPK4 sw4 pk4 tnk4 tnk4 sg13_lv_nmos w=2u l=0.13u
VGT1 gt1 0 PWL(0 0 198p 0 200p 2.174 324.978p 2.174 326.978p 0 758p 0 760p 2.174 6981.98p 2.174)
VGTP1 gtp1 0 PWL(0 2.174 198p 2.174 200p 0 324.978p 0 326.978p 2.174 758p 2.174 760p 0 6981.98p 0)
VPK1 pk1 0 PWL(0 2.174 198p 2.174 200p 0 324.978p 0 326.978p 2.174 758p 2.174 760p 0 6981.98p 0)
VGT2 gt2 0 PWL(0 0 338p 0 340p 2.174 468.441p 2.174 470.441p 0)
VGTP2 gtp2 0 PWL(0 2.174 338p 2.174 340p 0 468.441p 0 470.441p 2.174)
VPK2 pk2 0 PWL(0 2.174 338p 2.174 340p 0 468.441p 0 470.441p 2.174)
VGT3 gt3 0 PWL(0 0 478p 0 480p 2.174 604.596p 2.174 606.596p 0)
VGTP3 gtp3 0 PWL(0 2.174 478p 2.174 480p 0 604.596p 0 606.596p 2.174)
VPK3 pk3 0 PWL(0 2.174 478p 2.174 480p 0 604.596p 0 606.596p 2.174)
VGT4 gt4 0 PWL(0 0 618p 0 620p 2.174 746.385p 2.174 748.385p 0)
VGTP4 gtp4 0 PWL(0 2.174 618p 2.174 620p 0 746.385p 0 748.385p 2.174)
VPK4 pk4 0 PWL(0 2.174 618p 2.174 620p 0 746.385p 0 748.385p 2.174)
.ic V(tnk1)=0.9075 V(rail1)=0 V(sw1)=0.9075 V(tnk2)=0.9075 V(rail2)=0 V(sw2)=0.9075 V(tnk3)=0.9075 V(rail3)=0 V(sw3)=0.9075 V(tnk4)=0.9075 V(rail4)=0 V(sw4)=0.9075
.tran 0.1p 1021.98p 0 0.25p
.print tran I(L1) I(L2) I(L3) I(L4) V(rail1) V(rail2) V(rail3) V(rail4) V(tnk1) V(tnk2) V(tnk3) V(tnk4)
.end
