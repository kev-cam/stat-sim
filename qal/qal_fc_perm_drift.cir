* CANDIDATE 5: PERMANENTLY-CONNECTED 5-TIER STACK (no recharge switch at all).
* 5 tier decoupling caps in series across +-1.5 V; 3.0 V / 0.6 V = 5 EXACTLY, so every tier sits at
* the bank swing level by construction. Each tier's bank draws its per-hop top-up as a load current
* (MEASURED need: 1.96 fJ/hop at dV=0.6 => q_hop = 3.27 fC per 100 ps hop => I = 32.7 uA per tier).
* There is NO recharge switch => no gate drive, no switching parasitic. Only the series interconnect R.
* Copy A: BALANCED (all tiers draw 32.7 uA)   -> do the tiers hold at 0.600 V?
* Copy B: 5% IMBALANCED on tier 1             -> how fast do the tiers drift? (the load-bearing risk)
.OPTIONS TIMEINT METHOD=GEAR RELTOL=1e-8 ABSTOL=1e-18
.param CF=300f VR=1.5 IL=32.7u RS=5

* ================= A: balanced =================
VPA vpa 0 {VR}
VNA vna 0 {-VR}
RSA vpa a5 {RS}
CA1 vna a1 {CF}
CA2 a1  a2 {CF}
CA3 a2  a3 {CF}
CA4 a3  a4 {CF}
CA5 a4  a5 {CF}
* per-tier load: current drawn ACROSS each cap (bank top-up), from the cap's high node to its low node
IA1 a1 vna {IL}
IA2 a2 a1  {IL}
IA3 a3 a2  {IL}
IA4 a4 a3  {IL}
IA5 a5 a4  {IL}
FQA 0 qa VPA 1.0
CQA qa 0 1e-15
RQA qa 0 1e15
.IC V(a1)=-0.9 V(a2)=-0.3 V(a3)=0.3 V(a4)=0.9

* ================= B: tier 1 draws 5% more =================
VPB vpb 0 {VR}
VNB vnb 0 {-VR}
RSB vpb b5 {RS}
CB1 vnb b1 {CF}
CB2 b1  b2 {CF}
CB3 b2  b3 {CF}
CB4 b3  b4 {CF}
CB5 b4  b5 {CF}
IB1 b1 vnb {IL*1.05}
IB2 b2 b1  {IL}
IB3 b3 b2  {IL}
IB4 b4 b3  {IL}
IB5 b5 b4  {IL}
FQB 0 qb VPB 1.0
CQB qb 0 1e-15
RQB qb 0 1e15
.IC V(b1)=-0.9 V(b2)=-0.3 V(b3)=0.3 V(b4)=0.9

.tran 1p 20000p UIC

* --- A: tier voltages at start and end of 200 hop periods (20 ns) ---
.measure tran A_T1_0  FIND V(a1) AT=10p
.measure tran A_T1_E  FIND V(a1) AT=19990p
.measure tran A_T2_E  FIND V(a2) AT=19990p
.measure tran A_T3_E  FIND V(a3) AT=19990p
.measure tran A_T4_E  FIND V(a4) AT=19990p
.measure tran A_T5_E  FIND V(a5) AT=19990p
.measure tran A_Q_0   FIND V(qa) AT=10p
.measure tran A_Q_E   FIND V(qa) AT=19990p

* --- B: drift under 5% tier imbalance ---
.measure tran B_T1_E  FIND V(b1) AT=19990p
.measure tran B_T2_E  FIND V(b2) AT=19990p
.measure tran B_T3_E  FIND V(b3) AT=19990p
.measure tran B_T4_E  FIND V(b4) AT=19990p
.measure tran B_T5_E  FIND V(b5) AT=19990p
.measure tran B_Q_E   FIND V(qb) AT=19990p
.end
