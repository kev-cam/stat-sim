.hdl "/usr/local/share/xyce/verilog-a/psp103/psp103.va"
.include "/usr/local/src/kestrel/sim/models/sg13g2_psp103_tt.lib"
.include "/usr/local/src/stat-sim/qal/sg13lv_compat.sp"
.OPTIONS TIMEINT METHOD=GEAR RELTOL=1e-6 ABSTOL=1e-15 CHGTOL=1e-17
.include "/usr/local/src/IHP-Open-PDK/ihp-sg13g2/libs.ref/sg13g2_stdcell/spice/sg13g2_stdcell.spice"
VHI vhi 0 1.5
VMG1 gn1 0 0
VS_s_a0 s_a0 0 1.65
VS_s_a1 s_a1 0 1.65
VS_s_a10 s_a10 0 0
VS_s_a11 s_a11 0 1.65
VS_s_a12 s_a12 0 0
VS_s_a13 s_a13 0 0
VS_s_a14 s_a14 0 0
VS_s_a15 s_a15 0 0
VS_s_a16 s_a16 0 1.65
VS_s_a17 s_a17 0 1.65
VS_s_a18 s_a18 0 0
VS_s_a19 s_a19 0 0
VS_s_a2 s_a2 0 0
VS_s_a20 s_a20 0 0
VS_s_a21 s_a21 0 1.65
VS_s_a22 s_a22 0 0
VS_s_a23 s_a23 0 1.65
VS_s_a24 s_a24 0 1.65
VS_s_a25 s_a25 0 0
VS_s_a26 s_a26 0 1.65
VS_s_a27 s_a27 0 0
VS_s_a28 s_a28 0 0
VS_s_a29 s_a29 0 0
VS_s_a3 s_a3 0 0
VS_s_a30 s_a30 0 0
VS_s_a31 s_a31 0 1.65
VS_s_a4 s_a4 0 1.65
VS_s_a5 s_a5 0 0
VS_s_a6 s_a6 0 1.65
VS_s_a7 s_a7 0 1.65
VS_s_a8 s_a8 0 0
VS_s_a9 s_a9 0 0
VS_s_d0 s_d0 0 1.65
VS_s_d1 s_d1 0 1.65
VS_s_d10 s_d10 0 1.65
VS_s_d11 s_d11 0 0
VS_s_d12 s_d12 0 1.65
VS_s_d13 s_d13 0 0
VS_s_d14 s_d14 0 0
VS_s_d15 s_d15 0 1.65
VS_s_d16 s_d16 0 0
VS_s_d17 s_d17 0 0
VS_s_d18 s_d18 0 0
VS_s_d19 s_d19 0 0
VS_s_d2 s_d2 0 1.65
VS_s_d20 s_d20 0 0
VS_s_d21 s_d21 0 0
VS_s_d22 s_d22 0 1.65
VS_s_d23 s_d23 0 1.65
VS_s_d24 s_d24 0 1.65
VS_s_d25 s_d25 0 1.65
VS_s_d26 s_d26 0 0
VS_s_d27 s_d27 0 1.65
VS_s_d28 s_d28 0 1.65
VS_s_d29 s_d29 0 0
VS_s_d3 s_d3 0 0
VS_s_d30 s_d30 0 1.65
VS_s_d31 s_d31 0 1.65
VS_s_d4 s_d4 0 1.65
VS_s_d5 s_d5 0 1.65
VS_s_d6 s_d6 0 1.65
VS_s_d7 s_d7 0 0
VS_s_d8 s_d8 0 1.65
VS_s_d9 s_d9 0 0
XINV1_0 o1_0 s_d0 rail1 gn1 sg13g2_inv_1
CL1_0 o1_0 gn1 2f
XINV1_1 o1_1 s_d1 rail1 gn1 sg13g2_inv_1
CL1_1 o1_1 gn1 2f
XINV1_2 o1_2 s_d2 rail1 gn1 sg13g2_inv_1
CL1_2 o1_2 gn1 2f
XINV1_3 o1_3 s_d3 rail1 gn1 sg13g2_inv_1
CL1_3 o1_3 gn1 2f
XINV1_4 o1_4 s_d4 rail1 gn1 sg13g2_inv_1
CL1_4 o1_4 gn1 2f
XINV1_5 o1_5 s_d5 rail1 gn1 sg13g2_inv_1
CL1_5 o1_5 gn1 2f
XINV1_6 o1_6 s_d6 rail1 gn1 sg13g2_inv_1
CL1_6 o1_6 gn1 2f
XINV1_7 o1_7 s_d7 rail1 gn1 sg13g2_inv_1
CL1_7 o1_7 gn1 2f
XINV1_8 o1_8 s_d8 rail1 gn1 sg13g2_inv_1
CL1_8 o1_8 gn1 2f
XINV1_9 o1_9 s_d9 rail1 gn1 sg13g2_inv_1
CL1_9 o1_9 gn1 2f
XINV1_10 o1_10 s_d10 rail1 gn1 sg13g2_inv_1
CL1_10 o1_10 gn1 2f
XINV1_11 o1_11 s_d11 rail1 gn1 sg13g2_inv_1
CL1_11 o1_11 gn1 2f
XINV1_12 o1_12 s_d12 rail1 gn1 sg13g2_inv_1
CL1_12 o1_12 gn1 2f
XINV1_13 o1_13 s_d13 rail1 gn1 sg13g2_inv_1
CL1_13 o1_13 gn1 2f
XINV1_14 o1_14 s_d14 rail1 gn1 sg13g2_inv_1
CL1_14 o1_14 gn1 2f
XINV1_15 o1_15 s_d15 rail1 gn1 sg13g2_inv_1
CL1_15 o1_15 gn1 2f
XINV1_16 o1_16 s_d16 rail1 gn1 sg13g2_inv_1
CL1_16 o1_16 gn1 2f
XINV1_17 o1_17 s_d17 rail1 gn1 sg13g2_inv_1
CL1_17 o1_17 gn1 2f
XINV1_18 o1_18 s_d18 rail1 gn1 sg13g2_inv_1
CL1_18 o1_18 gn1 2f
XINV1_19 o1_19 s_d19 rail1 gn1 sg13g2_inv_1
CL1_19 o1_19 gn1 2f
XINV1_20 o1_20 s_d20 rail1 gn1 sg13g2_inv_1
CL1_20 o1_20 gn1 2f
XINV1_21 o1_21 s_d21 rail1 gn1 sg13g2_inv_1
CL1_21 o1_21 gn1 2f
XINV1_22 o1_22 s_d22 rail1 gn1 sg13g2_inv_1
CL1_22 o1_22 gn1 2f
XINV1_23 o1_23 s_d23 rail1 gn1 sg13g2_inv_1
CL1_23 o1_23 gn1 2f
XINV1_24 o1_24 s_d24 rail1 gn1 sg13g2_inv_1
CL1_24 o1_24 gn1 2f
XINV1_25 o1_25 s_d25 rail1 gn1 sg13g2_inv_1
CL1_25 o1_25 gn1 2f
XINV1_26 o1_26 s_d26 rail1 gn1 sg13g2_inv_1
CL1_26 o1_26 gn1 2f
XINV1_27 o1_27 s_d27 rail1 gn1 sg13g2_inv_1
CL1_27 o1_27 gn1 2f
XINV1_28 o1_28 s_d28 rail1 gn1 sg13g2_inv_1
CL1_28 o1_28 gn1 2f
XINV1_29 o1_29 s_d29 rail1 gn1 sg13g2_inv_1
CL1_29 o1_29 gn1 2f
XINV1_30 o1_30 s_d30 rail1 gn1 sg13g2_inv_1
CL1_30 o1_30 gn1 2f
XINV1_31 o1_31 s_d31 rail1 gn1 sg13g2_inv_1
CL1_31 o1_31 gn1 2f
VMG2 gn2 0 0
XXOR22_0 o2_0 o1_0 s_a0 rail2 gn2 sg13g2_xor2_1
CL2_0 o2_0 gn2 2f
CW2_0 o2_0 gn2 7.767000f
XXOR22_1 o2_1 o1_1 s_a1 rail2 gn2 sg13g2_xor2_1
CL2_1 o2_1 gn2 2f
CW2_1 o2_1 gn2 7.767000f
XXOR22_2 o2_2 o1_2 s_a2 rail2 gn2 sg13g2_xor2_1
CL2_2 o2_2 gn2 2f
CW2_2 o2_2 gn2 7.767000f
XXOR22_3 o2_3 o1_3 s_a3 rail2 gn2 sg13g2_xor2_1
CL2_3 o2_3 gn2 2f
CW2_3 o2_3 gn2 7.767000f
XXOR22_4 o2_4 o1_4 s_a4 rail2 gn2 sg13g2_xor2_1
CL2_4 o2_4 gn2 2f
CW2_4 o2_4 gn2 7.767000f
XXOR22_5 o2_5 o1_5 s_a5 rail2 gn2 sg13g2_xor2_1
CL2_5 o2_5 gn2 2f
CW2_5 o2_5 gn2 7.767000f
XXOR22_6 o2_6 o1_6 s_a6 rail2 gn2 sg13g2_xor2_1
CL2_6 o2_6 gn2 2f
CW2_6 o2_6 gn2 7.767000f
XXOR22_7 o2_7 o1_7 s_a7 rail2 gn2 sg13g2_xor2_1
CL2_7 o2_7 gn2 2f
CW2_7 o2_7 gn2 7.767000f
XXOR22_8 o2_8 o1_8 s_a8 rail2 gn2 sg13g2_xor2_1
CL2_8 o2_8 gn2 2f
CW2_8 o2_8 gn2 7.767000f
XXOR22_9 o2_9 o1_9 s_a9 rail2 gn2 sg13g2_xor2_1
CL2_9 o2_9 gn2 2f
CW2_9 o2_9 gn2 7.767000f
XXOR22_10 o2_10 o1_10 s_a10 rail2 gn2 sg13g2_xor2_1
CL2_10 o2_10 gn2 2f
CW2_10 o2_10 gn2 7.767000f
XXOR22_11 o2_11 o1_11 s_a11 rail2 gn2 sg13g2_xor2_1
CL2_11 o2_11 gn2 2f
CW2_11 o2_11 gn2 7.767000f
XXOR22_12 o2_12 o1_12 s_a12 rail2 gn2 sg13g2_xor2_1
CL2_12 o2_12 gn2 2f
CW2_12 o2_12 gn2 7.767000f
XXOR22_13 o2_13 o1_13 s_a13 rail2 gn2 sg13g2_xor2_1
CL2_13 o2_13 gn2 2f
CW2_13 o2_13 gn2 7.767000f
XXOR22_14 o2_14 o1_14 s_a14 rail2 gn2 sg13g2_xor2_1
CL2_14 o2_14 gn2 2f
CW2_14 o2_14 gn2 7.767000f
XXOR22_15 o2_15 o1_15 s_a15 rail2 gn2 sg13g2_xor2_1
CL2_15 o2_15 gn2 2f
CW2_15 o2_15 gn2 7.767000f
XXOR22_16 o2_16 o1_16 s_a16 rail2 gn2 sg13g2_xor2_1
CL2_16 o2_16 gn2 2f
CW2_16 o2_16 gn2 7.767000f
XXOR22_17 o2_17 o1_17 s_a17 rail2 gn2 sg13g2_xor2_1
CL2_17 o2_17 gn2 2f
CW2_17 o2_17 gn2 7.767000f
XXOR22_18 o2_18 o1_18 s_a18 rail2 gn2 sg13g2_xor2_1
CL2_18 o2_18 gn2 2f
CW2_18 o2_18 gn2 7.767000f
XXOR22_19 o2_19 o1_19 s_a19 rail2 gn2 sg13g2_xor2_1
CL2_19 o2_19 gn2 2f
CW2_19 o2_19 gn2 7.767000f
XXOR22_20 o2_20 o1_20 s_a20 rail2 gn2 sg13g2_xor2_1
CL2_20 o2_20 gn2 2f
CW2_20 o2_20 gn2 7.767000f
XXOR22_21 o2_21 o1_21 s_a21 rail2 gn2 sg13g2_xor2_1
CL2_21 o2_21 gn2 2f
CW2_21 o2_21 gn2 7.767000f
XXOR22_22 o2_22 o1_22 s_a22 rail2 gn2 sg13g2_xor2_1
CL2_22 o2_22 gn2 2f
CW2_22 o2_22 gn2 7.767000f
XXOR22_23 o2_23 o1_23 s_a23 rail2 gn2 sg13g2_xor2_1
CL2_23 o2_23 gn2 2f
CW2_23 o2_23 gn2 7.767000f
XXOR22_24 o2_24 o1_24 s_a24 rail2 gn2 sg13g2_xor2_1
CL2_24 o2_24 gn2 2f
CW2_24 o2_24 gn2 7.767000f
XXOR22_25 o2_25 o1_25 s_a25 rail2 gn2 sg13g2_xor2_1
CL2_25 o2_25 gn2 2f
CW2_25 o2_25 gn2 7.767000f
XXOR22_26 o2_26 o1_26 s_a26 rail2 gn2 sg13g2_xor2_1
CL2_26 o2_26 gn2 2f
CW2_26 o2_26 gn2 7.767000f
XXOR22_27 o2_27 o1_27 s_a27 rail2 gn2 sg13g2_xor2_1
CL2_27 o2_27 gn2 2f
CW2_27 o2_27 gn2 7.767000f
XXOR22_28 o2_28 o1_28 s_a28 rail2 gn2 sg13g2_xor2_1
CL2_28 o2_28 gn2 2f
CW2_28 o2_28 gn2 7.767000f
XXOR22_29 o2_29 o1_29 s_a29 rail2 gn2 sg13g2_xor2_1
CL2_29 o2_29 gn2 2f
CW2_29 o2_29 gn2 7.767000f
XXOR22_30 o2_30 o1_30 s_a30 rail2 gn2 sg13g2_xor2_1
CL2_30 o2_30 gn2 2f
CW2_30 o2_30 gn2 7.767000f
XXOR22_31 o2_31 o1_31 s_a31 rail2 gn2 sg13g2_xor2_1
CL2_31 o2_31 gn2 2f
CW2_31 o2_31 gn2 7.767000f
VMG3 gn3 0 0
XINV3_0 o3_0 o2_16 rail3 gn3 sg13g2_inv_1
CL3_0 o3_0 gn3 2f
XINV3_1 o3_1 o2_17 rail3 gn3 sg13g2_inv_1
CL3_1 o3_1 gn3 2f
XINV3_2 o3_2 o2_18 rail3 gn3 sg13g2_inv_1
CL3_2 o3_2 gn3 2f
XINV3_3 o3_3 o2_19 rail3 gn3 sg13g2_inv_1
CL3_3 o3_3 gn3 2f
XINV3_4 o3_4 o2_20 rail3 gn3 sg13g2_inv_1
CL3_4 o3_4 gn3 2f
XINV3_5 o3_5 o2_21 rail3 gn3 sg13g2_inv_1
CL3_5 o3_5 gn3 2f
XINV3_6 o3_6 o2_22 rail3 gn3 sg13g2_inv_1
CL3_6 o3_6 gn3 2f
XINV3_7 o3_7 o2_23 rail3 gn3 sg13g2_inv_1
CL3_7 o3_7 gn3 2f
XINV3_8 o3_8 o2_24 rail3 gn3 sg13g2_inv_1
CL3_8 o3_8 gn3 2f
XINV3_9 o3_9 o2_25 rail3 gn3 sg13g2_inv_1
CL3_9 o3_9 gn3 2f
XINV3_10 o3_10 o2_26 rail3 gn3 sg13g2_inv_1
CL3_10 o3_10 gn3 2f
XINV3_11 o3_11 o2_27 rail3 gn3 sg13g2_inv_1
CL3_11 o3_11 gn3 2f
XINV3_12 o3_12 o2_28 rail3 gn3 sg13g2_inv_1
CL3_12 o3_12 gn3 2f
XINV3_13 o3_13 o2_29 rail3 gn3 sg13g2_inv_1
CL3_13 o3_13 gn3 2f
XINV3_14 o3_14 o2_30 rail3 gn3 sg13g2_inv_1
CL3_14 o3_14 gn3 2f
XINV3_15 o3_15 o2_31 rail3 gn3 sg13g2_inv_1
CL3_15 o3_15 gn3 2f
XINV3_16 o3_16 o2_0 rail3 gn3 sg13g2_inv_1
CL3_16 o3_16 gn3 2f
XINV3_17 o3_17 o2_1 rail3 gn3 sg13g2_inv_1
CL3_17 o3_17 gn3 2f
XINV3_18 o3_18 o2_2 rail3 gn3 sg13g2_inv_1
CL3_18 o3_18 gn3 2f
XINV3_19 o3_19 o2_3 rail3 gn3 sg13g2_inv_1
CL3_19 o3_19 gn3 2f
XINV3_20 o3_20 o2_4 rail3 gn3 sg13g2_inv_1
CL3_20 o3_20 gn3 2f
XINV3_21 o3_21 o2_5 rail3 gn3 sg13g2_inv_1
CL3_21 o3_21 gn3 2f
XINV3_22 o3_22 o2_6 rail3 gn3 sg13g2_inv_1
CL3_22 o3_22 gn3 2f
XINV3_23 o3_23 o2_7 rail3 gn3 sg13g2_inv_1
CL3_23 o3_23 gn3 2f
XINV3_24 o3_24 o2_8 rail3 gn3 sg13g2_inv_1
CL3_24 o3_24 gn3 2f
XINV3_25 o3_25 o2_9 rail3 gn3 sg13g2_inv_1
CL3_25 o3_25 gn3 2f
XINV3_26 o3_26 o2_10 rail3 gn3 sg13g2_inv_1
CL3_26 o3_26 gn3 2f
XINV3_27 o3_27 o2_11 rail3 gn3 sg13g2_inv_1
CL3_27 o3_27 gn3 2f
XINV3_28 o3_28 o2_12 rail3 gn3 sg13g2_inv_1
CL3_28 o3_28 gn3 2f
XINV3_29 o3_29 o2_13 rail3 gn3 sg13g2_inv_1
CL3_29 o3_29 gn3 2f
XINV3_30 o3_30 o2_14 rail3 gn3 sg13g2_inv_1
CL3_30 o3_30 gn3 2f
XINV3_31 o3_31 o2_15 rail3 gn3 sg13g2_inv_1
CL3_31 o3_31 gn3 2f
CT1 tnk1 0 1439.16f
L1 tnk1 mid1 15n
R1 mid1 sw1 10
XSWN1 sw1 gt1 rail1 0 sg13_lv_nmos w=20u l=0.13u
XSWP1 sw1 gtp1 rail1 vhi sg13_lv_pmos w=40u l=0.13u
XPK1 sw1 pk1 tnk1 tnk1 sg13_lv_nmos w=4u l=0.13u
CT2 tnk2 0 7121.24f
L2 tnk2 mid2 15n
R2 mid2 sw2 10
XSWN2 sw2 gt2 rail2 0 sg13_lv_nmos w=40u l=0.13u
XSWP2 sw2 gtp2 rail2 vhi sg13_lv_pmos w=80u l=0.13u
XPK2 sw2 pk2 tnk2 tnk2 sg13_lv_nmos w=8u l=0.13u
CT3 tnk3 0 1439.16f
L3 tnk3 mid3 15n
R3 mid3 sw3 10
XSWN3 sw3 gt3 rail3 0 sg13_lv_nmos w=20u l=0.13u
XSWP3 sw3 gtp3 rail3 vhi sg13_lv_pmos w=40u l=0.13u
XPK3 sw3 pk3 tnk3 tnk3 sg13_lv_nmos w=4u l=0.13u
VGT1 gt1 0 PWL(0 0 198p 0 200p 1.5 408.532p 1.5 410.532p 0 2798p 0 2800p 1.5 3042.95p 1.5 3044.95p 0)
VGTP1 gtp1 0 PWL(0 1.5 198p 1.5 200p 0 408.532p 0 410.532p 1.5 2798p 1.5 2800p 0 3042.95p 0 3044.95p 1.5)
VPK1 pk1 0 PWL(0 1.5 198p 1.5 200p 0 408.532p 0 410.532p 1.5 2798p 1.5 2800p 0 3042.95p 0 3044.95p 1.5)
VGT2 gt2 0 PWL(0 0 848p 0 850p 1.5 1190.04p 1.5 1192.04p 0 3448p 0 3450p 1.5 3707.93p 1.5 3709.93p 0)
VGTP2 gtp2 0 PWL(0 1.5 848p 1.5 850p 0 1190.04p 0 1192.04p 1.5 3448p 1.5 3450p 0 3707.93p 0 3709.93p 1.5)
VPK2 pk2 0 PWL(0 1.5 848p 1.5 850p 0 1190.04p 0 1192.04p 1.5 3448p 1.5 3450p 0 3707.93p 0 3709.93p 1.5)
VGT3 gt3 0 PWL(0 0 1498p 0 1500p 1.5 1703.64p 1.5 1705.64p 0 4098p 0 4100p 1.5 4332.08p 1.5 4334.08p 0)
VGTP3 gtp3 0 PWL(0 1.5 1498p 1.5 1500p 0 1703.64p 0 1705.64p 1.5 4098p 1.5 4100p 0 4332.08p 0 4334.08p 1.5)
VPK3 pk3 0 PWL(0 1.5 1498p 1.5 1500p 0 1703.64p 0 1705.64p 1.5 4098p 1.5 4100p 0 4332.08p 0 4334.08p 1.5)
CXqlt1 xqlt1 0 1
BXqlt1 0 xqlt1 I={ I(L1) }
RXqlt1 xqlt1 0 0.01
CXea1 xea1 0 1
BXea1 0 xea1 I={ V(tnk1)*I(L1) }
RXea1 xea1 0 0.01
CXeb1 xeb1 0 1
BXeb1 0 xeb1 I={ V(rail1)*I(L1) }
RXeb1 xeb1 0 0.01
CXesw1 xesw1 0 1
BXesw1 0 xesw1 I={ V(sw1)*I(L1) }
RXesw1 xesw1 0 0.01
CXer1 xer1 0 1
BXer1 0 xer1 I={ I(L1)*I(L1)*10 }
RXer1 xer1 0 0.01
CXqg1 xqg1 0 1
BXqg1 0 xqg1 I={ I(VMG1) }
RXqg1 xqg1 0 0.01
CXqlt2 xqlt2 0 1
BXqlt2 0 xqlt2 I={ I(L2) }
RXqlt2 xqlt2 0 0.01
CXea2 xea2 0 1
BXea2 0 xea2 I={ V(tnk2)*I(L2) }
RXea2 xea2 0 0.01
CXeb2 xeb2 0 1
BXeb2 0 xeb2 I={ V(rail2)*I(L2) }
RXeb2 xeb2 0 0.01
CXesw2 xesw2 0 1
BXesw2 0 xesw2 I={ V(sw2)*I(L2) }
RXesw2 xesw2 0 0.01
CXer2 xer2 0 1
BXer2 0 xer2 I={ I(L2)*I(L2)*10 }
RXer2 xer2 0 0.01
CXqg2 xqg2 0 1
BXqg2 0 xqg2 I={ I(VMG2) }
RXqg2 xqg2 0 0.01
CXqlt3 xqlt3 0 1
BXqlt3 0 xqlt3 I={ I(L3) }
RXqlt3 xqlt3 0 0.01
CXea3 xea3 0 1
BXea3 0 xea3 I={ V(tnk3)*I(L3) }
RXea3 xea3 0 0.01
CXeb3 xeb3 0 1
BXeb3 0 xeb3 I={ V(rail3)*I(L3) }
RXeb3 xeb3 0 0.01
CXesw3 xesw3 0 1
BXesw3 0 xesw3 I={ V(sw3)*I(L3) }
RXesw3 xesw3 0 0.01
CXer3 xer3 0 1
BXer3 0 xer3 I={ I(L3)*I(L3)*10 }
RXer3 xer3 0 0.01
CXqg3 xqg3 0 1
BXqg3 0 xqg3 I={ I(VMG3) }
RXqg3 xqg3 0 0.01
CXqi1 xqi1 0 1
BXqi1 0 xqi1 I={ -(I(VS_s_a0)+I(VS_s_a1)+I(VS_s_a10)+I(VS_s_a11)+I(VS_s_a12)+I(VS_s_a13)+I(VS_s_a14)+I(VS_s_a15)+I(VS_s_a16)+I(VS_s_a17)+I(VS_s_a18)+I(VS_s_a19)+I(VS_s_a2)+I(VS_s_a20)+I(VS_s_a21)+I(VS_s_a22)+I(VS_s_a23)+I(VS_s_a24)+I(VS_s_a25)+I(VS_s_a26)+I(VS_s_a27)+I(VS_s_a28)+I(VS_s_a29)+I(VS_s_a3)+I(VS_s_a30)+I(VS_s_a31)+I(VS_s_a4)+I(VS_s_a5)+I(VS_s_a6)+I(VS_s_a7)+I(VS_s_a8)+I(VS_s_a9)+I(VS_s_d0)+I(VS_s_d1)+I(VS_s_d10)+I(VS_s_d11)+I(VS_s_d12)+I(VS_s_d13)+I(VS_s_d14)+I(VS_s_d15)+I(VS_s_d16)+I(VS_s_d17)+I(VS_s_d18)+I(VS_s_d19)+I(VS_s_d2)+I(VS_s_d20)+I(VS_s_d21)+I(VS_s_d22)+I(VS_s_d23)+I(VS_s_d24)+I(VS_s_d25)+I(VS_s_d26)+I(VS_s_d27)+I(VS_s_d28)+I(VS_s_d29)+I(VS_s_d3)+I(VS_s_d30)+I(VS_s_d31)+I(VS_s_d4)+I(VS_s_d5)+I(VS_s_d6)+I(VS_s_d7)+I(VS_s_d8)+I(VS_s_d9)) }
RXqi1 xqi1 0 0.01
CXei1 xei1 0 1
BXei1 0 xei1 I={ -(V(s_a0)*I(VS_s_a0)+V(s_a1)*I(VS_s_a1)+V(s_a10)*I(VS_s_a10)+V(s_a11)*I(VS_s_a11)+V(s_a12)*I(VS_s_a12)+V(s_a13)*I(VS_s_a13)+V(s_a14)*I(VS_s_a14)+V(s_a15)*I(VS_s_a15)+V(s_a16)*I(VS_s_a16)+V(s_a17)*I(VS_s_a17)+V(s_a18)*I(VS_s_a18)+V(s_a19)*I(VS_s_a19)+V(s_a2)*I(VS_s_a2)+V(s_a20)*I(VS_s_a20)+V(s_a21)*I(VS_s_a21)+V(s_a22)*I(VS_s_a22)+V(s_a23)*I(VS_s_a23)+V(s_a24)*I(VS_s_a24)+V(s_a25)*I(VS_s_a25)+V(s_a26)*I(VS_s_a26)+V(s_a27)*I(VS_s_a27)+V(s_a28)*I(VS_s_a28)+V(s_a29)*I(VS_s_a29)+V(s_a3)*I(VS_s_a3)+V(s_a30)*I(VS_s_a30)+V(s_a31)*I(VS_s_a31)+V(s_a4)*I(VS_s_a4)+V(s_a5)*I(VS_s_a5)+V(s_a6)*I(VS_s_a6)+V(s_a7)*I(VS_s_a7)+V(s_a8)*I(VS_s_a8)+V(s_a9)*I(VS_s_a9)+V(s_d0)*I(VS_s_d0)+V(s_d1)*I(VS_s_d1)+V(s_d10)*I(VS_s_d10)+V(s_d11)*I(VS_s_d11)+V(s_d12)*I(VS_s_d12)+V(s_d13)*I(VS_s_d13)+V(s_d14)*I(VS_s_d14)+V(s_d15)*I(VS_s_d15)+V(s_d16)*I(VS_s_d16)+V(s_d17)*I(VS_s_d17)+V(s_d18)*I(VS_s_d18)+V(s_d19)*I(VS_s_d19)+V(s_d2)*I(VS_s_d2)+V(s_d20)*I(VS_s_d20)+V(s_d21)*I(VS_s_d21)+V(s_d22)*I(VS_s_d22)+V(s_d23)*I(VS_s_d23)+V(s_d24)*I(VS_s_d24)+V(s_d25)*I(VS_s_d25)+V(s_d26)*I(VS_s_d26)+V(s_d27)*I(VS_s_d27)+V(s_d28)*I(VS_s_d28)+V(s_d29)*I(VS_s_d29)+V(s_d3)*I(VS_s_d3)+V(s_d30)*I(VS_s_d30)+V(s_d31)*I(VS_s_d31)+V(s_d4)*I(VS_s_d4)+V(s_d5)*I(VS_s_d5)+V(s_d6)*I(VS_s_d6)+V(s_d7)*I(VS_s_d7)+V(s_d8)*I(VS_s_d8)+V(s_d9)*I(VS_s_d9)) }
RXei1 xei1 0 0.01
CXegt xegt 0 1
BXegt 0 xegt I={ -V(gt1)*I(VGT1)-V(gtp1)*I(VGTP1)-V(pk1)*I(VPK1)-V(gt2)*I(VGT2)-V(gtp2)*I(VGTP2)-V(pk2)*I(VPK2)-V(gt3)*I(VGT3)-V(gtp3)*I(VGTP3)-V(pk3)*I(VPK3) }
RXegt xegt 0 0.01
CXehi xehi 0 1
BXehi 0 xehi I={ -1.5*I(VHI) }
RXehi xehi 0 0.01
.ic V(tnk1)=0.9075 V(rail1)=0 V(sw1)=0.9075 V(tnk2)=0.9075 V(rail2)=0 V(sw2)=0.9075 V(tnk3)=0.9075 V(rail3)=0 V(sw3)=0.9075
.tran 0.1p 4832.08p 0 0.25p
.measure tran QLT1_Z FIND V(xqlt1) AT=1.500000p
.measure tran QLT1_O1 FIND V(xqlt1) AT=409.531554p
.measure tran QLT1_B1 FIND V(xqlt1) AT=851.000000p
.measure tran QLT1_R1 FIND V(xqlt1) AT=2799.000000p
.measure tran QLT1_Q1 FIND V(xqlt1) AT=3043.952153p
.measure tran QLT1_D FIND V(xqlt1) AT=4828.076359p
.measure tran EA1_Z FIND V(xea1) AT=1.500000p
.measure tran EA1_O1 FIND V(xea1) AT=409.531554p
.measure tran EA1_B1 FIND V(xea1) AT=851.000000p
.measure tran EA1_R1 FIND V(xea1) AT=2799.000000p
.measure tran EA1_Q1 FIND V(xea1) AT=3043.952153p
.measure tran EA1_D FIND V(xea1) AT=4828.076359p
.measure tran EB1_Z FIND V(xeb1) AT=1.500000p
.measure tran EB1_O1 FIND V(xeb1) AT=409.531554p
.measure tran EB1_B1 FIND V(xeb1) AT=851.000000p
.measure tran EB1_R1 FIND V(xeb1) AT=2799.000000p
.measure tran EB1_Q1 FIND V(xeb1) AT=3043.952153p
.measure tran EB1_D FIND V(xeb1) AT=4828.076359p
.measure tran ESW1_Z FIND V(xesw1) AT=1.500000p
.measure tran ESW1_O1 FIND V(xesw1) AT=409.531554p
.measure tran ESW1_B1 FIND V(xesw1) AT=851.000000p
.measure tran ESW1_R1 FIND V(xesw1) AT=2799.000000p
.measure tran ESW1_Q1 FIND V(xesw1) AT=3043.952153p
.measure tran ESW1_D FIND V(xesw1) AT=4828.076359p
.measure tran ER1_Z FIND V(xer1) AT=1.500000p
.measure tran ER1_O1 FIND V(xer1) AT=409.531554p
.measure tran ER1_B1 FIND V(xer1) AT=851.000000p
.measure tran ER1_R1 FIND V(xer1) AT=2799.000000p
.measure tran ER1_Q1 FIND V(xer1) AT=3043.952153p
.measure tran ER1_D FIND V(xer1) AT=4828.076359p
.measure tran QG1_Z FIND V(xqg1) AT=1.500000p
.measure tran QG1_O1 FIND V(xqg1) AT=409.531554p
.measure tran QG1_B1 FIND V(xqg1) AT=851.000000p
.measure tran QG1_R1 FIND V(xqg1) AT=2799.000000p
.measure tran QG1_Q1 FIND V(xqg1) AT=3043.952153p
.measure tran QG1_D FIND V(xqg1) AT=4828.076359p
.measure tran QLT2_Z FIND V(xqlt2) AT=1.500000p
.measure tran QLT2_O2 FIND V(xqlt2) AT=1191.038462p
.measure tran QLT2_B2 FIND V(xqlt2) AT=1501.000000p
.measure tran QLT2_R2 FIND V(xqlt2) AT=3449.000000p
.measure tran QLT2_Q2 FIND V(xqlt2) AT=3708.930862p
.measure tran QLT2_D FIND V(xqlt2) AT=4828.076359p
.measure tran EA2_Z FIND V(xea2) AT=1.500000p
.measure tran EA2_O2 FIND V(xea2) AT=1191.038462p
.measure tran EA2_B2 FIND V(xea2) AT=1501.000000p
.measure tran EA2_R2 FIND V(xea2) AT=3449.000000p
.measure tran EA2_Q2 FIND V(xea2) AT=3708.930862p
.measure tran EA2_D FIND V(xea2) AT=4828.076359p
.measure tran EB2_Z FIND V(xeb2) AT=1.500000p
.measure tran EB2_O2 FIND V(xeb2) AT=1191.038462p
.measure tran EB2_B2 FIND V(xeb2) AT=1501.000000p
.measure tran EB2_R2 FIND V(xeb2) AT=3449.000000p
.measure tran EB2_Q2 FIND V(xeb2) AT=3708.930862p
.measure tran EB2_D FIND V(xeb2) AT=4828.076359p
.measure tran ESW2_Z FIND V(xesw2) AT=1.500000p
.measure tran ESW2_O2 FIND V(xesw2) AT=1191.038462p
.measure tran ESW2_B2 FIND V(xesw2) AT=1501.000000p
.measure tran ESW2_R2 FIND V(xesw2) AT=3449.000000p
.measure tran ESW2_Q2 FIND V(xesw2) AT=3708.930862p
.measure tran ESW2_D FIND V(xesw2) AT=4828.076359p
.measure tran ER2_Z FIND V(xer2) AT=1.500000p
.measure tran ER2_O2 FIND V(xer2) AT=1191.038462p
.measure tran ER2_B2 FIND V(xer2) AT=1501.000000p
.measure tran ER2_R2 FIND V(xer2) AT=3449.000000p
.measure tran ER2_Q2 FIND V(xer2) AT=3708.930862p
.measure tran ER2_D FIND V(xer2) AT=4828.076359p
.measure tran QG2_Z FIND V(xqg2) AT=1.500000p
.measure tran QG2_O2 FIND V(xqg2) AT=1191.038462p
.measure tran QG2_B2 FIND V(xqg2) AT=1501.000000p
.measure tran QG2_R2 FIND V(xqg2) AT=3449.000000p
.measure tran QG2_Q2 FIND V(xqg2) AT=3708.930862p
.measure tran QG2_D FIND V(xqg2) AT=4828.076359p
.measure tran QLT3_Z FIND V(xqlt3) AT=1.500000p
.measure tran QLT3_O3 FIND V(xqlt3) AT=1704.641037p
.measure tran QLT3_B3 FIND V(xqlt3) AT=2151.000000p
.measure tran QLT3_R3 FIND V(xqlt3) AT=4099.000000p
.measure tran QLT3_Q3 FIND V(xqlt3) AT=4333.076359p
.measure tran QLT3_D FIND V(xqlt3) AT=4828.076359p
.measure tran EA3_Z FIND V(xea3) AT=1.500000p
.measure tran EA3_O3 FIND V(xea3) AT=1704.641037p
.measure tran EA3_B3 FIND V(xea3) AT=2151.000000p
.measure tran EA3_R3 FIND V(xea3) AT=4099.000000p
.measure tran EA3_Q3 FIND V(xea3) AT=4333.076359p
.measure tran EA3_D FIND V(xea3) AT=4828.076359p
.measure tran EB3_Z FIND V(xeb3) AT=1.500000p
.measure tran EB3_O3 FIND V(xeb3) AT=1704.641037p
.measure tran EB3_B3 FIND V(xeb3) AT=2151.000000p
.measure tran EB3_R3 FIND V(xeb3) AT=4099.000000p
.measure tran EB3_Q3 FIND V(xeb3) AT=4333.076359p
.measure tran EB3_D FIND V(xeb3) AT=4828.076359p
.measure tran ESW3_Z FIND V(xesw3) AT=1.500000p
.measure tran ESW3_O3 FIND V(xesw3) AT=1704.641037p
.measure tran ESW3_B3 FIND V(xesw3) AT=2151.000000p
.measure tran ESW3_R3 FIND V(xesw3) AT=4099.000000p
.measure tran ESW3_Q3 FIND V(xesw3) AT=4333.076359p
.measure tran ESW3_D FIND V(xesw3) AT=4828.076359p
.measure tran ER3_Z FIND V(xer3) AT=1.500000p
.measure tran ER3_O3 FIND V(xer3) AT=1704.641037p
.measure tran ER3_B3 FIND V(xer3) AT=2151.000000p
.measure tran ER3_R3 FIND V(xer3) AT=4099.000000p
.measure tran ER3_Q3 FIND V(xer3) AT=4333.076359p
.measure tran ER3_D FIND V(xer3) AT=4828.076359p
.measure tran QG3_Z FIND V(xqg3) AT=1.500000p
.measure tran QG3_O3 FIND V(xqg3) AT=1704.641037p
.measure tran QG3_B3 FIND V(xqg3) AT=2151.000000p
.measure tran QG3_R3 FIND V(xqg3) AT=4099.000000p
.measure tran QG3_Q3 FIND V(xqg3) AT=4333.076359p
.measure tran QG3_D FIND V(xqg3) AT=4828.076359p
.measure tran QI1_Z FIND V(xqi1) AT=1.500000p
.measure tran QI1_O1 FIND V(xqi1) AT=409.531554p
.measure tran QI1_B1 FIND V(xqi1) AT=851.000000p
.measure tran QI1_R1 FIND V(xqi1) AT=2799.000000p
.measure tran QI1_Q1 FIND V(xqi1) AT=3043.952153p
.measure tran QI1_D FIND V(xqi1) AT=4828.076359p
.measure tran EI1_Z FIND V(xei1) AT=1.500000p
.measure tran EI1_O1 FIND V(xei1) AT=409.531554p
.measure tran EI1_B1 FIND V(xei1) AT=851.000000p
.measure tran EI1_R1 FIND V(xei1) AT=2799.000000p
.measure tran EI1_Q1 FIND V(xei1) AT=3043.952153p
.measure tran EI1_D FIND V(xei1) AT=4828.076359p
.measure tran EGT_Z FIND V(xegt) AT=1.500000p
.measure tran EGT_O1 FIND V(xegt) AT=409.531554p
.measure tran EGT_B1 FIND V(xegt) AT=851.000000p
.measure tran EGT_R1 FIND V(xegt) AT=2799.000000p
.measure tran EGT_Q1 FIND V(xegt) AT=3043.952153p
.measure tran EGT_O2 FIND V(xegt) AT=1191.038462p
.measure tran EGT_B2 FIND V(xegt) AT=1501.000000p
.measure tran EGT_R2 FIND V(xegt) AT=3449.000000p
.measure tran EGT_Q2 FIND V(xegt) AT=3708.930862p
.measure tran EGT_O3 FIND V(xegt) AT=1704.641037p
.measure tran EGT_B3 FIND V(xegt) AT=2151.000000p
.measure tran EGT_R3 FIND V(xegt) AT=4099.000000p
.measure tran EGT_Q3 FIND V(xegt) AT=4333.076359p
.measure tran EGT_D FIND V(xegt) AT=4828.076359p
.measure tran EHI_Z FIND V(xehi) AT=1.500000p
.measure tran EHI_O1 FIND V(xehi) AT=409.531554p
.measure tran EHI_B1 FIND V(xehi) AT=851.000000p
.measure tran EHI_R1 FIND V(xehi) AT=2799.000000p
.measure tran EHI_Q1 FIND V(xehi) AT=3043.952153p
.measure tran EHI_O2 FIND V(xehi) AT=1191.038462p
.measure tran EHI_B2 FIND V(xehi) AT=1501.000000p
.measure tran EHI_R2 FIND V(xehi) AT=3449.000000p
.measure tran EHI_Q2 FIND V(xehi) AT=3708.930862p
.measure tran EHI_O3 FIND V(xehi) AT=1704.641037p
.measure tran EHI_B3 FIND V(xehi) AT=2151.000000p
.measure tran EHI_R3 FIND V(xehi) AT=4099.000000p
.measure tran EHI_Q3 FIND V(xehi) AT=4333.076359p
.measure tran EHI_D FIND V(xehi) AT=4828.076359p
.measure tran VR1Z FIND V(rail1) AT=1.500000p
.measure tran VT1Z FIND V(tnk1) AT=1.500000p
.measure tran VR1O1 FIND V(rail1) AT=409.531554p
.measure tran VT1O1 FIND V(tnk1) AT=409.531554p
.measure tran VR1B1 FIND V(rail1) AT=851.000000p
.measure tran VT1B1 FIND V(tnk1) AT=851.000000p
.measure tran VR1R1 FIND V(rail1) AT=2799.000000p
.measure tran VT1R1 FIND V(tnk1) AT=2799.000000p
.measure tran VR1Q1 FIND V(rail1) AT=3043.952153p
.measure tran VT1Q1 FIND V(tnk1) AT=3043.952153p
.measure tran VR1O2 FIND V(rail1) AT=1191.038462p
.measure tran VT1O2 FIND V(tnk1) AT=1191.038462p
.measure tran VR1B2 FIND V(rail1) AT=1501.000000p
.measure tran VT1B2 FIND V(tnk1) AT=1501.000000p
.measure tran VR1R2 FIND V(rail1) AT=3449.000000p
.measure tran VT1R2 FIND V(tnk1) AT=3449.000000p
.measure tran VR1Q2 FIND V(rail1) AT=3708.930862p
.measure tran VT1Q2 FIND V(tnk1) AT=3708.930862p
.measure tran VR1O3 FIND V(rail1) AT=1704.641037p
.measure tran VT1O3 FIND V(tnk1) AT=1704.641037p
.measure tran VR1B3 FIND V(rail1) AT=2151.000000p
.measure tran VT1B3 FIND V(tnk1) AT=2151.000000p
.measure tran VR1R3 FIND V(rail1) AT=4099.000000p
.measure tran VT1R3 FIND V(tnk1) AT=4099.000000p
.measure tran VR1Q3 FIND V(rail1) AT=4333.076359p
.measure tran VT1Q3 FIND V(tnk1) AT=4333.076359p
.measure tran VR1D FIND V(rail1) AT=4828.076359p
.measure tran VT1D FIND V(tnk1) AT=4828.076359p
.measure tran VR1PK MAX V(rail1) FROM=200p TO=4832.08p
.measure tran IZ1 FIND I(L1) AT=409.531554p
.measure tran IZQ1 FIND I(L1) AT=3043.952153p
.measure tran IPK1 MAX I(L1) FROM=200p TO=4832.08p
.measure tran O1_0B FIND V(o1_0) AT=851.000000p
.measure tran O1_0E FIND V(o1_0) AT=4828.076359p
.measure tran O1_0O FIND V(o1_0) AT=409.531554p
.measure tran O1_0Q FIND V(o1_0) AT=3043.952153p
.measure tran O1_1B FIND V(o1_1) AT=851.000000p
.measure tran O1_1E FIND V(o1_1) AT=4828.076359p
.measure tran O1_1O FIND V(o1_1) AT=409.531554p
.measure tran O1_1Q FIND V(o1_1) AT=3043.952153p
.measure tran O1_2B FIND V(o1_2) AT=851.000000p
.measure tran O1_2E FIND V(o1_2) AT=4828.076359p
.measure tran O1_2O FIND V(o1_2) AT=409.531554p
.measure tran O1_2Q FIND V(o1_2) AT=3043.952153p
.measure tran O1_3B FIND V(o1_3) AT=851.000000p
.measure tran O1_3E FIND V(o1_3) AT=4828.076359p
.measure tran O1_3O FIND V(o1_3) AT=409.531554p
.measure tran O1_3Q FIND V(o1_3) AT=3043.952153p
.measure tran O1_4B FIND V(o1_4) AT=851.000000p
.measure tran O1_4E FIND V(o1_4) AT=4828.076359p
.measure tran O1_4O FIND V(o1_4) AT=409.531554p
.measure tran O1_4Q FIND V(o1_4) AT=3043.952153p
.measure tran O1_5B FIND V(o1_5) AT=851.000000p
.measure tran O1_5E FIND V(o1_5) AT=4828.076359p
.measure tran O1_5O FIND V(o1_5) AT=409.531554p
.measure tran O1_5Q FIND V(o1_5) AT=3043.952153p
.measure tran O1_6B FIND V(o1_6) AT=851.000000p
.measure tran O1_6E FIND V(o1_6) AT=4828.076359p
.measure tran O1_6O FIND V(o1_6) AT=409.531554p
.measure tran O1_6Q FIND V(o1_6) AT=3043.952153p
.measure tran O1_7B FIND V(o1_7) AT=851.000000p
.measure tran O1_7E FIND V(o1_7) AT=4828.076359p
.measure tran O1_7O FIND V(o1_7) AT=409.531554p
.measure tran O1_7Q FIND V(o1_7) AT=3043.952153p
.measure tran O1_8B FIND V(o1_8) AT=851.000000p
.measure tran O1_8E FIND V(o1_8) AT=4828.076359p
.measure tran O1_8O FIND V(o1_8) AT=409.531554p
.measure tran O1_8Q FIND V(o1_8) AT=3043.952153p
.measure tran O1_9B FIND V(o1_9) AT=851.000000p
.measure tran O1_9E FIND V(o1_9) AT=4828.076359p
.measure tran O1_9O FIND V(o1_9) AT=409.531554p
.measure tran O1_9Q FIND V(o1_9) AT=3043.952153p
.measure tran O1_10B FIND V(o1_10) AT=851.000000p
.measure tran O1_10E FIND V(o1_10) AT=4828.076359p
.measure tran O1_10O FIND V(o1_10) AT=409.531554p
.measure tran O1_10Q FIND V(o1_10) AT=3043.952153p
.measure tran O1_11B FIND V(o1_11) AT=851.000000p
.measure tran O1_11E FIND V(o1_11) AT=4828.076359p
.measure tran O1_11O FIND V(o1_11) AT=409.531554p
.measure tran O1_11Q FIND V(o1_11) AT=3043.952153p
.measure tran O1_12B FIND V(o1_12) AT=851.000000p
.measure tran O1_12E FIND V(o1_12) AT=4828.076359p
.measure tran O1_12O FIND V(o1_12) AT=409.531554p
.measure tran O1_12Q FIND V(o1_12) AT=3043.952153p
.measure tran O1_13B FIND V(o1_13) AT=851.000000p
.measure tran O1_13E FIND V(o1_13) AT=4828.076359p
.measure tran O1_13O FIND V(o1_13) AT=409.531554p
.measure tran O1_13Q FIND V(o1_13) AT=3043.952153p
.measure tran O1_14B FIND V(o1_14) AT=851.000000p
.measure tran O1_14E FIND V(o1_14) AT=4828.076359p
.measure tran O1_14O FIND V(o1_14) AT=409.531554p
.measure tran O1_14Q FIND V(o1_14) AT=3043.952153p
.measure tran O1_15B FIND V(o1_15) AT=851.000000p
.measure tran O1_15E FIND V(o1_15) AT=4828.076359p
.measure tran O1_15O FIND V(o1_15) AT=409.531554p
.measure tran O1_15Q FIND V(o1_15) AT=3043.952153p
.measure tran O1_16B FIND V(o1_16) AT=851.000000p
.measure tran O1_16E FIND V(o1_16) AT=4828.076359p
.measure tran O1_16O FIND V(o1_16) AT=409.531554p
.measure tran O1_16Q FIND V(o1_16) AT=3043.952153p
.measure tran O1_17B FIND V(o1_17) AT=851.000000p
.measure tran O1_17E FIND V(o1_17) AT=4828.076359p
.measure tran O1_17O FIND V(o1_17) AT=409.531554p
.measure tran O1_17Q FIND V(o1_17) AT=3043.952153p
.measure tran O1_18B FIND V(o1_18) AT=851.000000p
.measure tran O1_18E FIND V(o1_18) AT=4828.076359p
.measure tran O1_18O FIND V(o1_18) AT=409.531554p
.measure tran O1_18Q FIND V(o1_18) AT=3043.952153p
.measure tran O1_19B FIND V(o1_19) AT=851.000000p
.measure tran O1_19E FIND V(o1_19) AT=4828.076359p
.measure tran O1_19O FIND V(o1_19) AT=409.531554p
.measure tran O1_19Q FIND V(o1_19) AT=3043.952153p
.measure tran O1_20B FIND V(o1_20) AT=851.000000p
.measure tran O1_20E FIND V(o1_20) AT=4828.076359p
.measure tran O1_20O FIND V(o1_20) AT=409.531554p
.measure tran O1_20Q FIND V(o1_20) AT=3043.952153p
.measure tran O1_21B FIND V(o1_21) AT=851.000000p
.measure tran O1_21E FIND V(o1_21) AT=4828.076359p
.measure tran O1_21O FIND V(o1_21) AT=409.531554p
.measure tran O1_21Q FIND V(o1_21) AT=3043.952153p
.measure tran O1_22B FIND V(o1_22) AT=851.000000p
.measure tran O1_22E FIND V(o1_22) AT=4828.076359p
.measure tran O1_22O FIND V(o1_22) AT=409.531554p
.measure tran O1_22Q FIND V(o1_22) AT=3043.952153p
.measure tran O1_23B FIND V(o1_23) AT=851.000000p
.measure tran O1_23E FIND V(o1_23) AT=4828.076359p
.measure tran O1_23O FIND V(o1_23) AT=409.531554p
.measure tran O1_23Q FIND V(o1_23) AT=3043.952153p
.measure tran O1_24B FIND V(o1_24) AT=851.000000p
.measure tran O1_24E FIND V(o1_24) AT=4828.076359p
.measure tran O1_24O FIND V(o1_24) AT=409.531554p
.measure tran O1_24Q FIND V(o1_24) AT=3043.952153p
.measure tran O1_25B FIND V(o1_25) AT=851.000000p
.measure tran O1_25E FIND V(o1_25) AT=4828.076359p
.measure tran O1_25O FIND V(o1_25) AT=409.531554p
.measure tran O1_25Q FIND V(o1_25) AT=3043.952153p
.measure tran O1_26B FIND V(o1_26) AT=851.000000p
.measure tran O1_26E FIND V(o1_26) AT=4828.076359p
.measure tran O1_26O FIND V(o1_26) AT=409.531554p
.measure tran O1_26Q FIND V(o1_26) AT=3043.952153p
.measure tran O1_27B FIND V(o1_27) AT=851.000000p
.measure tran O1_27E FIND V(o1_27) AT=4828.076359p
.measure tran O1_27O FIND V(o1_27) AT=409.531554p
.measure tran O1_27Q FIND V(o1_27) AT=3043.952153p
.measure tran O1_28B FIND V(o1_28) AT=851.000000p
.measure tran O1_28E FIND V(o1_28) AT=4828.076359p
.measure tran O1_28O FIND V(o1_28) AT=409.531554p
.measure tran O1_28Q FIND V(o1_28) AT=3043.952153p
.measure tran O1_29B FIND V(o1_29) AT=851.000000p
.measure tran O1_29E FIND V(o1_29) AT=4828.076359p
.measure tran O1_29O FIND V(o1_29) AT=409.531554p
.measure tran O1_29Q FIND V(o1_29) AT=3043.952153p
.measure tran O1_30B FIND V(o1_30) AT=851.000000p
.measure tran O1_30E FIND V(o1_30) AT=4828.076359p
.measure tran O1_30O FIND V(o1_30) AT=409.531554p
.measure tran O1_30Q FIND V(o1_30) AT=3043.952153p
.measure tran O1_31B FIND V(o1_31) AT=851.000000p
.measure tran O1_31E FIND V(o1_31) AT=4828.076359p
.measure tran O1_31O FIND V(o1_31) AT=409.531554p
.measure tran O1_31Q FIND V(o1_31) AT=3043.952153p
.measure tran VR2Z FIND V(rail2) AT=1.500000p
.measure tran VT2Z FIND V(tnk2) AT=1.500000p
.measure tran VR2O1 FIND V(rail2) AT=409.531554p
.measure tran VT2O1 FIND V(tnk2) AT=409.531554p
.measure tran VR2B1 FIND V(rail2) AT=851.000000p
.measure tran VT2B1 FIND V(tnk2) AT=851.000000p
.measure tran VR2R1 FIND V(rail2) AT=2799.000000p
.measure tran VT2R1 FIND V(tnk2) AT=2799.000000p
.measure tran VR2Q1 FIND V(rail2) AT=3043.952153p
.measure tran VT2Q1 FIND V(tnk2) AT=3043.952153p
.measure tran VR2O2 FIND V(rail2) AT=1191.038462p
.measure tran VT2O2 FIND V(tnk2) AT=1191.038462p
.measure tran VR2B2 FIND V(rail2) AT=1501.000000p
.measure tran VT2B2 FIND V(tnk2) AT=1501.000000p
.measure tran VR2R2 FIND V(rail2) AT=3449.000000p
.measure tran VT2R2 FIND V(tnk2) AT=3449.000000p
.measure tran VR2Q2 FIND V(rail2) AT=3708.930862p
.measure tran VT2Q2 FIND V(tnk2) AT=3708.930862p
.measure tran VR2O3 FIND V(rail2) AT=1704.641037p
.measure tran VT2O3 FIND V(tnk2) AT=1704.641037p
.measure tran VR2B3 FIND V(rail2) AT=2151.000000p
.measure tran VT2B3 FIND V(tnk2) AT=2151.000000p
.measure tran VR2R3 FIND V(rail2) AT=4099.000000p
.measure tran VT2R3 FIND V(tnk2) AT=4099.000000p
.measure tran VR2Q3 FIND V(rail2) AT=4333.076359p
.measure tran VT2Q3 FIND V(tnk2) AT=4333.076359p
.measure tran VR2D FIND V(rail2) AT=4828.076359p
.measure tran VT2D FIND V(tnk2) AT=4828.076359p
.measure tran VR2PK MAX V(rail2) FROM=850p TO=4832.08p
.measure tran IZ2 FIND I(L2) AT=1191.038462p
.measure tran IZQ2 FIND I(L2) AT=3708.930862p
.measure tran IPK2 MAX I(L2) FROM=850p TO=4832.08p
.measure tran O2_0B FIND V(o2_0) AT=1501.000000p
.measure tran O2_0E FIND V(o2_0) AT=4828.076359p
.measure tran O2_0O FIND V(o2_0) AT=1191.038462p
.measure tran O2_0Q FIND V(o2_0) AT=3708.930862p
.measure tran O2_1B FIND V(o2_1) AT=1501.000000p
.measure tran O2_1E FIND V(o2_1) AT=4828.076359p
.measure tran O2_1O FIND V(o2_1) AT=1191.038462p
.measure tran O2_1Q FIND V(o2_1) AT=3708.930862p
.measure tran O2_2B FIND V(o2_2) AT=1501.000000p
.measure tran O2_2E FIND V(o2_2) AT=4828.076359p
.measure tran O2_2O FIND V(o2_2) AT=1191.038462p
.measure tran O2_2Q FIND V(o2_2) AT=3708.930862p
.measure tran O2_3B FIND V(o2_3) AT=1501.000000p
.measure tran O2_3E FIND V(o2_3) AT=4828.076359p
.measure tran O2_3O FIND V(o2_3) AT=1191.038462p
.measure tran O2_3Q FIND V(o2_3) AT=3708.930862p
.measure tran O2_4B FIND V(o2_4) AT=1501.000000p
.measure tran O2_4E FIND V(o2_4) AT=4828.076359p
.measure tran O2_4O FIND V(o2_4) AT=1191.038462p
.measure tran O2_4Q FIND V(o2_4) AT=3708.930862p
.measure tran O2_5B FIND V(o2_5) AT=1501.000000p
.measure tran O2_5E FIND V(o2_5) AT=4828.076359p
.measure tran O2_5O FIND V(o2_5) AT=1191.038462p
.measure tran O2_5Q FIND V(o2_5) AT=3708.930862p
.measure tran O2_6B FIND V(o2_6) AT=1501.000000p
.measure tran O2_6E FIND V(o2_6) AT=4828.076359p
.measure tran O2_6O FIND V(o2_6) AT=1191.038462p
.measure tran O2_6Q FIND V(o2_6) AT=3708.930862p
.measure tran O2_7B FIND V(o2_7) AT=1501.000000p
.measure tran O2_7E FIND V(o2_7) AT=4828.076359p
.measure tran O2_7O FIND V(o2_7) AT=1191.038462p
.measure tran O2_7Q FIND V(o2_7) AT=3708.930862p
.measure tran O2_8B FIND V(o2_8) AT=1501.000000p
.measure tran O2_8E FIND V(o2_8) AT=4828.076359p
.measure tran O2_8O FIND V(o2_8) AT=1191.038462p
.measure tran O2_8Q FIND V(o2_8) AT=3708.930862p
.measure tran O2_9B FIND V(o2_9) AT=1501.000000p
.measure tran O2_9E FIND V(o2_9) AT=4828.076359p
.measure tran O2_9O FIND V(o2_9) AT=1191.038462p
.measure tran O2_9Q FIND V(o2_9) AT=3708.930862p
.measure tran O2_10B FIND V(o2_10) AT=1501.000000p
.measure tran O2_10E FIND V(o2_10) AT=4828.076359p
.measure tran O2_10O FIND V(o2_10) AT=1191.038462p
.measure tran O2_10Q FIND V(o2_10) AT=3708.930862p
.measure tran O2_11B FIND V(o2_11) AT=1501.000000p
.measure tran O2_11E FIND V(o2_11) AT=4828.076359p
.measure tran O2_11O FIND V(o2_11) AT=1191.038462p
.measure tran O2_11Q FIND V(o2_11) AT=3708.930862p
.measure tran O2_12B FIND V(o2_12) AT=1501.000000p
.measure tran O2_12E FIND V(o2_12) AT=4828.076359p
.measure tran O2_12O FIND V(o2_12) AT=1191.038462p
.measure tran O2_12Q FIND V(o2_12) AT=3708.930862p
.measure tran O2_13B FIND V(o2_13) AT=1501.000000p
.measure tran O2_13E FIND V(o2_13) AT=4828.076359p
.measure tran O2_13O FIND V(o2_13) AT=1191.038462p
.measure tran O2_13Q FIND V(o2_13) AT=3708.930862p
.measure tran O2_14B FIND V(o2_14) AT=1501.000000p
.measure tran O2_14E FIND V(o2_14) AT=4828.076359p
.measure tran O2_14O FIND V(o2_14) AT=1191.038462p
.measure tran O2_14Q FIND V(o2_14) AT=3708.930862p
.measure tran O2_15B FIND V(o2_15) AT=1501.000000p
.measure tran O2_15E FIND V(o2_15) AT=4828.076359p
.measure tran O2_15O FIND V(o2_15) AT=1191.038462p
.measure tran O2_15Q FIND V(o2_15) AT=3708.930862p
.measure tran O2_16B FIND V(o2_16) AT=1501.000000p
.measure tran O2_16E FIND V(o2_16) AT=4828.076359p
.measure tran O2_16O FIND V(o2_16) AT=1191.038462p
.measure tran O2_16Q FIND V(o2_16) AT=3708.930862p
.measure tran O2_17B FIND V(o2_17) AT=1501.000000p
.measure tran O2_17E FIND V(o2_17) AT=4828.076359p
.measure tran O2_17O FIND V(o2_17) AT=1191.038462p
.measure tran O2_17Q FIND V(o2_17) AT=3708.930862p
.measure tran O2_18B FIND V(o2_18) AT=1501.000000p
.measure tran O2_18E FIND V(o2_18) AT=4828.076359p
.measure tran O2_18O FIND V(o2_18) AT=1191.038462p
.measure tran O2_18Q FIND V(o2_18) AT=3708.930862p
.measure tran O2_19B FIND V(o2_19) AT=1501.000000p
.measure tran O2_19E FIND V(o2_19) AT=4828.076359p
.measure tran O2_19O FIND V(o2_19) AT=1191.038462p
.measure tran O2_19Q FIND V(o2_19) AT=3708.930862p
.measure tran O2_20B FIND V(o2_20) AT=1501.000000p
.measure tran O2_20E FIND V(o2_20) AT=4828.076359p
.measure tran O2_20O FIND V(o2_20) AT=1191.038462p
.measure tran O2_20Q FIND V(o2_20) AT=3708.930862p
.measure tran O2_21B FIND V(o2_21) AT=1501.000000p
.measure tran O2_21E FIND V(o2_21) AT=4828.076359p
.measure tran O2_21O FIND V(o2_21) AT=1191.038462p
.measure tran O2_21Q FIND V(o2_21) AT=3708.930862p
.measure tran O2_22B FIND V(o2_22) AT=1501.000000p
.measure tran O2_22E FIND V(o2_22) AT=4828.076359p
.measure tran O2_22O FIND V(o2_22) AT=1191.038462p
.measure tran O2_22Q FIND V(o2_22) AT=3708.930862p
.measure tran O2_23B FIND V(o2_23) AT=1501.000000p
.measure tran O2_23E FIND V(o2_23) AT=4828.076359p
.measure tran O2_23O FIND V(o2_23) AT=1191.038462p
.measure tran O2_23Q FIND V(o2_23) AT=3708.930862p
.measure tran O2_24B FIND V(o2_24) AT=1501.000000p
.measure tran O2_24E FIND V(o2_24) AT=4828.076359p
.measure tran O2_24O FIND V(o2_24) AT=1191.038462p
.measure tran O2_24Q FIND V(o2_24) AT=3708.930862p
.measure tran O2_25B FIND V(o2_25) AT=1501.000000p
.measure tran O2_25E FIND V(o2_25) AT=4828.076359p
.measure tran O2_25O FIND V(o2_25) AT=1191.038462p
.measure tran O2_25Q FIND V(o2_25) AT=3708.930862p
.measure tran O2_26B FIND V(o2_26) AT=1501.000000p
.measure tran O2_26E FIND V(o2_26) AT=4828.076359p
.measure tran O2_26O FIND V(o2_26) AT=1191.038462p
.measure tran O2_26Q FIND V(o2_26) AT=3708.930862p
.measure tran O2_27B FIND V(o2_27) AT=1501.000000p
.measure tran O2_27E FIND V(o2_27) AT=4828.076359p
.measure tran O2_27O FIND V(o2_27) AT=1191.038462p
.measure tran O2_27Q FIND V(o2_27) AT=3708.930862p
.measure tran O2_28B FIND V(o2_28) AT=1501.000000p
.measure tran O2_28E FIND V(o2_28) AT=4828.076359p
.measure tran O2_28O FIND V(o2_28) AT=1191.038462p
.measure tran O2_28Q FIND V(o2_28) AT=3708.930862p
.measure tran O2_29B FIND V(o2_29) AT=1501.000000p
.measure tran O2_29E FIND V(o2_29) AT=4828.076359p
.measure tran O2_29O FIND V(o2_29) AT=1191.038462p
.measure tran O2_29Q FIND V(o2_29) AT=3708.930862p
.measure tran O2_30B FIND V(o2_30) AT=1501.000000p
.measure tran O2_30E FIND V(o2_30) AT=4828.076359p
.measure tran O2_30O FIND V(o2_30) AT=1191.038462p
.measure tran O2_30Q FIND V(o2_30) AT=3708.930862p
.measure tran O2_31B FIND V(o2_31) AT=1501.000000p
.measure tran O2_31E FIND V(o2_31) AT=4828.076359p
.measure tran O2_31O FIND V(o2_31) AT=1191.038462p
.measure tran O2_31Q FIND V(o2_31) AT=3708.930862p
.measure tran VR3Z FIND V(rail3) AT=1.500000p
.measure tran VT3Z FIND V(tnk3) AT=1.500000p
.measure tran VR3O1 FIND V(rail3) AT=409.531554p
.measure tran VT3O1 FIND V(tnk3) AT=409.531554p
.measure tran VR3B1 FIND V(rail3) AT=851.000000p
.measure tran VT3B1 FIND V(tnk3) AT=851.000000p
.measure tran VR3R1 FIND V(rail3) AT=2799.000000p
.measure tran VT3R1 FIND V(tnk3) AT=2799.000000p
.measure tran VR3Q1 FIND V(rail3) AT=3043.952153p
.measure tran VT3Q1 FIND V(tnk3) AT=3043.952153p
.measure tran VR3O2 FIND V(rail3) AT=1191.038462p
.measure tran VT3O2 FIND V(tnk3) AT=1191.038462p
.measure tran VR3B2 FIND V(rail3) AT=1501.000000p
.measure tran VT3B2 FIND V(tnk3) AT=1501.000000p
.measure tran VR3R2 FIND V(rail3) AT=3449.000000p
.measure tran VT3R2 FIND V(tnk3) AT=3449.000000p
.measure tran VR3Q2 FIND V(rail3) AT=3708.930862p
.measure tran VT3Q2 FIND V(tnk3) AT=3708.930862p
.measure tran VR3O3 FIND V(rail3) AT=1704.641037p
.measure tran VT3O3 FIND V(tnk3) AT=1704.641037p
.measure tran VR3B3 FIND V(rail3) AT=2151.000000p
.measure tran VT3B3 FIND V(tnk3) AT=2151.000000p
.measure tran VR3R3 FIND V(rail3) AT=4099.000000p
.measure tran VT3R3 FIND V(tnk3) AT=4099.000000p
.measure tran VR3Q3 FIND V(rail3) AT=4333.076359p
.measure tran VT3Q3 FIND V(tnk3) AT=4333.076359p
.measure tran VR3D FIND V(rail3) AT=4828.076359p
.measure tran VT3D FIND V(tnk3) AT=4828.076359p
.measure tran VR3PK MAX V(rail3) FROM=1500p TO=4832.08p
.measure tran IZ3 FIND I(L3) AT=1704.641037p
.measure tran IZQ3 FIND I(L3) AT=4333.076359p
.measure tran IPK3 MAX I(L3) FROM=1500p TO=4832.08p
.measure tran O3_0B FIND V(o3_0) AT=2151.000000p
.measure tran O3_0E FIND V(o3_0) AT=4828.076359p
.measure tran O3_0O FIND V(o3_0) AT=1704.641037p
.measure tran O3_0Q FIND V(o3_0) AT=4333.076359p
.measure tran O3_1B FIND V(o3_1) AT=2151.000000p
.measure tran O3_1E FIND V(o3_1) AT=4828.076359p
.measure tran O3_1O FIND V(o3_1) AT=1704.641037p
.measure tran O3_1Q FIND V(o3_1) AT=4333.076359p
.measure tran O3_2B FIND V(o3_2) AT=2151.000000p
.measure tran O3_2E FIND V(o3_2) AT=4828.076359p
.measure tran O3_2O FIND V(o3_2) AT=1704.641037p
.measure tran O3_2Q FIND V(o3_2) AT=4333.076359p
.measure tran O3_3B FIND V(o3_3) AT=2151.000000p
.measure tran O3_3E FIND V(o3_3) AT=4828.076359p
.measure tran O3_3O FIND V(o3_3) AT=1704.641037p
.measure tran O3_3Q FIND V(o3_3) AT=4333.076359p
.measure tran O3_4B FIND V(o3_4) AT=2151.000000p
.measure tran O3_4E FIND V(o3_4) AT=4828.076359p
.measure tran O3_4O FIND V(o3_4) AT=1704.641037p
.measure tran O3_4Q FIND V(o3_4) AT=4333.076359p
.measure tran O3_5B FIND V(o3_5) AT=2151.000000p
.measure tran O3_5E FIND V(o3_5) AT=4828.076359p
.measure tran O3_5O FIND V(o3_5) AT=1704.641037p
.measure tran O3_5Q FIND V(o3_5) AT=4333.076359p
.measure tran O3_6B FIND V(o3_6) AT=2151.000000p
.measure tran O3_6E FIND V(o3_6) AT=4828.076359p
.measure tran O3_6O FIND V(o3_6) AT=1704.641037p
.measure tran O3_6Q FIND V(o3_6) AT=4333.076359p
.measure tran O3_7B FIND V(o3_7) AT=2151.000000p
.measure tran O3_7E FIND V(o3_7) AT=4828.076359p
.measure tran O3_7O FIND V(o3_7) AT=1704.641037p
.measure tran O3_7Q FIND V(o3_7) AT=4333.076359p
.measure tran O3_8B FIND V(o3_8) AT=2151.000000p
.measure tran O3_8E FIND V(o3_8) AT=4828.076359p
.measure tran O3_8O FIND V(o3_8) AT=1704.641037p
.measure tran O3_8Q FIND V(o3_8) AT=4333.076359p
.measure tran O3_9B FIND V(o3_9) AT=2151.000000p
.measure tran O3_9E FIND V(o3_9) AT=4828.076359p
.measure tran O3_9O FIND V(o3_9) AT=1704.641037p
.measure tran O3_9Q FIND V(o3_9) AT=4333.076359p
.measure tran O3_10B FIND V(o3_10) AT=2151.000000p
.measure tran O3_10E FIND V(o3_10) AT=4828.076359p
.measure tran O3_10O FIND V(o3_10) AT=1704.641037p
.measure tran O3_10Q FIND V(o3_10) AT=4333.076359p
.measure tran O3_11B FIND V(o3_11) AT=2151.000000p
.measure tran O3_11E FIND V(o3_11) AT=4828.076359p
.measure tran O3_11O FIND V(o3_11) AT=1704.641037p
.measure tran O3_11Q FIND V(o3_11) AT=4333.076359p
.measure tran O3_12B FIND V(o3_12) AT=2151.000000p
.measure tran O3_12E FIND V(o3_12) AT=4828.076359p
.measure tran O3_12O FIND V(o3_12) AT=1704.641037p
.measure tran O3_12Q FIND V(o3_12) AT=4333.076359p
.measure tran O3_13B FIND V(o3_13) AT=2151.000000p
.measure tran O3_13E FIND V(o3_13) AT=4828.076359p
.measure tran O3_13O FIND V(o3_13) AT=1704.641037p
.measure tran O3_13Q FIND V(o3_13) AT=4333.076359p
.measure tran O3_14B FIND V(o3_14) AT=2151.000000p
.measure tran O3_14E FIND V(o3_14) AT=4828.076359p
.measure tran O3_14O FIND V(o3_14) AT=1704.641037p
.measure tran O3_14Q FIND V(o3_14) AT=4333.076359p
.measure tran O3_15B FIND V(o3_15) AT=2151.000000p
.measure tran O3_15E FIND V(o3_15) AT=4828.076359p
.measure tran O3_15O FIND V(o3_15) AT=1704.641037p
.measure tran O3_15Q FIND V(o3_15) AT=4333.076359p
.measure tran O3_16B FIND V(o3_16) AT=2151.000000p
.measure tran O3_16E FIND V(o3_16) AT=4828.076359p
.measure tran O3_16O FIND V(o3_16) AT=1704.641037p
.measure tran O3_16Q FIND V(o3_16) AT=4333.076359p
.measure tran O3_17B FIND V(o3_17) AT=2151.000000p
.measure tran O3_17E FIND V(o3_17) AT=4828.076359p
.measure tran O3_17O FIND V(o3_17) AT=1704.641037p
.measure tran O3_17Q FIND V(o3_17) AT=4333.076359p
.measure tran O3_18B FIND V(o3_18) AT=2151.000000p
.measure tran O3_18E FIND V(o3_18) AT=4828.076359p
.measure tran O3_18O FIND V(o3_18) AT=1704.641037p
.measure tran O3_18Q FIND V(o3_18) AT=4333.076359p
.measure tran O3_19B FIND V(o3_19) AT=2151.000000p
.measure tran O3_19E FIND V(o3_19) AT=4828.076359p
.measure tran O3_19O FIND V(o3_19) AT=1704.641037p
.measure tran O3_19Q FIND V(o3_19) AT=4333.076359p
.measure tran O3_20B FIND V(o3_20) AT=2151.000000p
.measure tran O3_20E FIND V(o3_20) AT=4828.076359p
.measure tran O3_20O FIND V(o3_20) AT=1704.641037p
.measure tran O3_20Q FIND V(o3_20) AT=4333.076359p
.measure tran O3_21B FIND V(o3_21) AT=2151.000000p
.measure tran O3_21E FIND V(o3_21) AT=4828.076359p
.measure tran O3_21O FIND V(o3_21) AT=1704.641037p
.measure tran O3_21Q FIND V(o3_21) AT=4333.076359p
.measure tran O3_22B FIND V(o3_22) AT=2151.000000p
.measure tran O3_22E FIND V(o3_22) AT=4828.076359p
.measure tran O3_22O FIND V(o3_22) AT=1704.641037p
.measure tran O3_22Q FIND V(o3_22) AT=4333.076359p
.measure tran O3_23B FIND V(o3_23) AT=2151.000000p
.measure tran O3_23E FIND V(o3_23) AT=4828.076359p
.measure tran O3_23O FIND V(o3_23) AT=1704.641037p
.measure tran O3_23Q FIND V(o3_23) AT=4333.076359p
.measure tran O3_24B FIND V(o3_24) AT=2151.000000p
.measure tran O3_24E FIND V(o3_24) AT=4828.076359p
.measure tran O3_24O FIND V(o3_24) AT=1704.641037p
.measure tran O3_24Q FIND V(o3_24) AT=4333.076359p
.measure tran O3_25B FIND V(o3_25) AT=2151.000000p
.measure tran O3_25E FIND V(o3_25) AT=4828.076359p
.measure tran O3_25O FIND V(o3_25) AT=1704.641037p
.measure tran O3_25Q FIND V(o3_25) AT=4333.076359p
.measure tran O3_26B FIND V(o3_26) AT=2151.000000p
.measure tran O3_26E FIND V(o3_26) AT=4828.076359p
.measure tran O3_26O FIND V(o3_26) AT=1704.641037p
.measure tran O3_26Q FIND V(o3_26) AT=4333.076359p
.measure tran O3_27B FIND V(o3_27) AT=2151.000000p
.measure tran O3_27E FIND V(o3_27) AT=4828.076359p
.measure tran O3_27O FIND V(o3_27) AT=1704.641037p
.measure tran O3_27Q FIND V(o3_27) AT=4333.076359p
.measure tran O3_28B FIND V(o3_28) AT=2151.000000p
.measure tran O3_28E FIND V(o3_28) AT=4828.076359p
.measure tran O3_28O FIND V(o3_28) AT=1704.641037p
.measure tran O3_28Q FIND V(o3_28) AT=4333.076359p
.measure tran O3_29B FIND V(o3_29) AT=2151.000000p
.measure tran O3_29E FIND V(o3_29) AT=4828.076359p
.measure tran O3_29O FIND V(o3_29) AT=1704.641037p
.measure tran O3_29Q FIND V(o3_29) AT=4333.076359p
.measure tran O3_30B FIND V(o3_30) AT=2151.000000p
.measure tran O3_30E FIND V(o3_30) AT=4828.076359p
.measure tran O3_30O FIND V(o3_30) AT=1704.641037p
.measure tran O3_30Q FIND V(o3_30) AT=4333.076359p
.measure tran O3_31B FIND V(o3_31) AT=2151.000000p
.measure tran O3_31E FIND V(o3_31) AT=4828.076359p
.measure tran O3_31O FIND V(o3_31) AT=1704.641037p
.measure tran O3_31Q FIND V(o3_31) AT=4333.076359p
.print tran V(rail1) V(rail2) V(rail3) V(tnk1) V(tnk2) V(tnk3) I(L1) I(L2) I(L3) V(sw1) V(sw2) V(sw3) V(o1_0) V(o1_1) V(o1_2) V(o1_3) V(o1_4) V(o1_5) V(o1_6) V(o1_7) V(o1_8) V(o1_9) V(o1_10) V(o1_11) V(o1_12) V(o1_13) V(o1_14) V(o1_15) V(o1_16) V(o1_17) V(o1_18) V(o1_19) V(o1_20) V(o1_21) V(o1_22) V(o1_23) V(o1_24) V(o1_25) V(o1_26) V(o1_27) V(o1_28) V(o1_29) V(o1_30) V(o1_31) V(o2_0) V(o2_1) V(o2_2) V(o2_3) V(o2_4) V(o2_5) V(o2_6) V(o2_7) V(o2_8) V(o2_9) V(o2_10) V(o2_11) V(o2_12) V(o2_13) V(o2_14) V(o2_15) V(o2_16) V(o2_17) V(o2_18) V(o2_19) V(o2_20) V(o2_21) V(o2_22) V(o2_23) V(o2_24) V(o2_25) V(o2_26) V(o2_27) V(o2_28) V(o2_29) V(o2_30) V(o2_31) V(o3_0) V(o3_1) V(o3_2) V(o3_3) V(o3_4) V(o3_5) V(o3_6) V(o3_7) V(o3_8) V(o3_9) V(o3_10) V(o3_11) V(o3_12) V(o3_13) V(o3_14) V(o3_15) V(o3_16) V(o3_17) V(o3_18) V(o3_19) V(o3_20) V(o3_21) V(o3_22) V(o3_23) V(o3_24) V(o3_25) V(o3_26) V(o3_27) V(o3_28) V(o3_29) V(o3_30) V(o3_31)
.end
