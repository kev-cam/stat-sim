.hdl "/usr/local/share/xyce/verilog-a/psp103/psp103.va"
.include "/usr/local/src/kestrel/sim/models/sg13g2_psp103_tt.lib"
.include "/usr/local/src/stat-sim/qal/sg13lv_compat.sp"
.OPTIONS TIMEINT METHOD=GEAR RELTOL=1e-6 ABSTOL=1e-15 CHGTOL=1e-17
.include "/usr/local/src/IHP-Open-PDK/ihp-sg13g2/libs.ref/sg13g2_stdcell/spice/sg13g2_stdcell.spice"
VDD vdd 0 1.1
VGNDM gnm 0 0
VS_a0 s_a0 0 PWL(0 1.65 200p 1.65 202p 0 1700p 0 1702p 1.65)
VS_a1 s_a1 0 PWL(0 1.65 200p 1.65 202p 0 1700p 0 1702p 1.65)
VS_a10 s_a10 0 PWL(0 0 200p 0 202p 1.65 1700p 1.65 1702p 0)
VS_a11 s_a11 0 PWL(0 1.65 200p 1.65 202p 0 1700p 0 1702p 1.65)
VS_a12 s_a12 0 PWL(0 0 200p 0 202p 1.65 1700p 1.65 1702p 0)
VS_a13 s_a13 0 PWL(0 0 200p 0 202p 1.65 1700p 1.65 1702p 0)
VS_a14 s_a14 0 PWL(0 0 200p 0 202p 1.65 1700p 1.65 1702p 0)
VS_a15 s_a15 0 PWL(0 0 200p 0 202p 1.65 1700p 1.65 1702p 0)
VS_a16 s_a16 0 PWL(0 1.65 200p 1.65 202p 0 1700p 0 1702p 1.65)
VS_a17 s_a17 0 PWL(0 1.65 200p 1.65 202p 0 1700p 0 1702p 1.65)
VS_a18 s_a18 0 PWL(0 0 200p 0 202p 1.65 1700p 1.65 1702p 0)
VS_a19 s_a19 0 PWL(0 0 200p 0 202p 1.65 1700p 1.65 1702p 0)
VS_a2 s_a2 0 PWL(0 0 200p 0 202p 1.65 1700p 1.65 1702p 0)
VS_a20 s_a20 0 PWL(0 0 200p 0 202p 1.65 1700p 1.65 1702p 0)
VS_a21 s_a21 0 PWL(0 1.65 200p 1.65 202p 0 1700p 0 1702p 1.65)
VS_a22 s_a22 0 PWL(0 0 200p 0 202p 1.65 1700p 1.65 1702p 0)
VS_a23 s_a23 0 PWL(0 1.65 200p 1.65 202p 0 1700p 0 1702p 1.65)
VS_a24 s_a24 0 PWL(0 1.65 200p 1.65 202p 0 1700p 0 1702p 1.65)
VS_a25 s_a25 0 PWL(0 0 200p 0 202p 1.65 1700p 1.65 1702p 0)
VS_a26 s_a26 0 PWL(0 1.65 200p 1.65 202p 0 1700p 0 1702p 1.65)
VS_a27 s_a27 0 PWL(0 0 200p 0 202p 1.65 1700p 1.65 1702p 0)
VS_a28 s_a28 0 PWL(0 0 200p 0 202p 1.65 1700p 1.65 1702p 0)
VS_a29 s_a29 0 PWL(0 0 200p 0 202p 1.65 1700p 1.65 1702p 0)
VS_a3 s_a3 0 PWL(0 0 200p 0 202p 1.65 1700p 1.65 1702p 0)
VS_a30 s_a30 0 PWL(0 0 200p 0 202p 1.65 1700p 1.65 1702p 0)
VS_a31 s_a31 0 PWL(0 1.65 200p 1.65 202p 0 1700p 0 1702p 1.65)
VS_a4 s_a4 0 PWL(0 1.65 200p 1.65 202p 0 1700p 0 1702p 1.65)
VS_a5 s_a5 0 PWL(0 0 200p 0 202p 1.65 1700p 1.65 1702p 0)
VS_a6 s_a6 0 PWL(0 1.65 200p 1.65 202p 0 1700p 0 1702p 1.65)
VS_a7 s_a7 0 PWL(0 1.65 200p 1.65 202p 0 1700p 0 1702p 1.65)
VS_a8 s_a8 0 PWL(0 0 200p 0 202p 1.65 1700p 1.65 1702p 0)
VS_a9 s_a9 0 PWL(0 0 200p 0 202p 1.65 1700p 1.65 1702p 0)
VS_d0 s_d0 0 0
VS_d1 s_d1 0 0
VS_d10 s_d10 0 0
VS_d11 s_d11 0 1.65
VS_d12 s_d12 0 0
VS_d13 s_d13 0 1.65
VS_d14 s_d14 0 1.65
VS_d15 s_d15 0 0
VS_d16 s_d16 0 1.65
VS_d17 s_d17 0 1.65
VS_d18 s_d18 0 1.65
VS_d19 s_d19 0 1.65
VS_d2 s_d2 0 0
VS_d20 s_d20 0 1.65
VS_d21 s_d21 0 1.65
VS_d22 s_d22 0 0
VS_d23 s_d23 0 0
VS_d24 s_d24 0 0
VS_d25 s_d25 0 0
VS_d26 s_d26 0 1.65
VS_d27 s_d27 0 0
VS_d28 s_d28 0 0
VS_d29 s_d29 0 1.65
VS_d3 s_d3 0 1.65
VS_d30 s_d30 0 0
VS_d31 s_d31 0 0
VS_d4 s_d4 0 0
VS_d5 s_d5 0 0
VS_d6 s_d6 0 0
VS_d7 s_d7 0 1.65
VS_d8 s_d8 0 0
VS_d9 s_d9 0 1.65
XXOR20 n0 s_d16 s_a16 vdd gnm sg13g2_xor2_1
CL0 n0 gnm 2f
XXOR21 n1 s_d17 s_a17 vdd gnm sg13g2_xor2_1
CL1 n1 gnm 2f
XXOR22 n2 s_d18 s_a18 vdd gnm sg13g2_xor2_1
CL2 n2 gnm 2f
XXOR23 n3 s_d19 s_a19 vdd gnm sg13g2_xor2_1
CL3 n3 gnm 2f
XXOR24 n4 s_d20 s_a20 vdd gnm sg13g2_xor2_1
CL4 n4 gnm 2f
XXOR25 n5 s_d21 s_a21 vdd gnm sg13g2_xor2_1
CL5 n5 gnm 2f
XXOR26 n6 s_d22 s_a22 vdd gnm sg13g2_xor2_1
CL6 n6 gnm 2f
XXOR27 n7 s_d23 s_a23 vdd gnm sg13g2_xor2_1
CL7 n7 gnm 2f
XXOR28 n8 s_d24 s_a24 vdd gnm sg13g2_xor2_1
CL8 n8 gnm 2f
XXOR29 n9 s_d25 s_a25 vdd gnm sg13g2_xor2_1
CL9 n9 gnm 2f
XXOR210 n10 s_d26 s_a26 vdd gnm sg13g2_xor2_1
CL10 n10 gnm 2f
XXOR211 n11 s_d27 s_a27 vdd gnm sg13g2_xor2_1
CL11 n11 gnm 2f
XXOR212 n12 s_d28 s_a28 vdd gnm sg13g2_xor2_1
CL12 n12 gnm 2f
XXOR213 n13 s_d29 s_a29 vdd gnm sg13g2_xor2_1
CL13 n13 gnm 2f
XXOR214 n14 s_d30 s_a30 vdd gnm sg13g2_xor2_1
CL14 n14 gnm 2f
XXOR215 n15 s_d31 s_a31 vdd gnm sg13g2_xor2_1
CL15 n15 gnm 2f
XXOR216 n16 s_d0 s_a0 vdd gnm sg13g2_xor2_1
CL16 n16 gnm 2f
XXOR217 n17 s_d1 s_a1 vdd gnm sg13g2_xor2_1
CL17 n17 gnm 2f
XXOR218 n18 s_d2 s_a2 vdd gnm sg13g2_xor2_1
CL18 n18 gnm 2f
XXOR219 n19 s_d3 s_a3 vdd gnm sg13g2_xor2_1
CL19 n19 gnm 2f
XXOR220 n20 s_d4 s_a4 vdd gnm sg13g2_xor2_1
CL20 n20 gnm 2f
XXOR221 n21 s_d5 s_a5 vdd gnm sg13g2_xor2_1
CL21 n21 gnm 2f
XXOR222 n22 s_d6 s_a6 vdd gnm sg13g2_xor2_1
CL22 n22 gnm 2f
XXOR223 n23 s_d7 s_a7 vdd gnm sg13g2_xor2_1
CL23 n23 gnm 2f
XXOR224 n24 s_d8 s_a8 vdd gnm sg13g2_xor2_1
CL24 n24 gnm 2f
XXOR225 n25 s_d9 s_a9 vdd gnm sg13g2_xor2_1
CL25 n25 gnm 2f
XXOR226 n26 s_d10 s_a10 vdd gnm sg13g2_xor2_1
CL26 n26 gnm 2f
XXOR227 n27 s_d11 s_a11 vdd gnm sg13g2_xor2_1
CL27 n27 gnm 2f
XXOR228 n28 s_d12 s_a12 vdd gnm sg13g2_xor2_1
CL28 n28 gnm 2f
XXOR229 n29 s_d13 s_a13 vdd gnm sg13g2_xor2_1
CL29 n29 gnm 2f
XXOR230 n30 s_d14 s_a14 vdd gnm sg13g2_xor2_1
CL30 n30 gnm 2f
XXOR231 n31 s_d15 s_a15 vdd gnm sg13g2_xor2_1
CL31 n31 gnm 2f
CXqvdd xqvdd 0 1
BXqvdd 0 xqvdd I={ -I(VDD) }
RXqvdd xqvdd 0 0.01
.tran 0.1p 2202p 0 0.25p
.measure tran QVDD_Z FIND V(xqvdd) AT=1.500000p
.measure tran QVDD_A FIND V(xqvdd) AT=201.000000p
.measure tran QVDD_B FIND V(xqvdd) AT=1701.000000p
.measure tran QVDD_D FIND V(xqvdd) AT=2198.000000p
.measure tran M_n0 FIND V(n0) AT=2198.000000p
.measure tran C_n0 FIND V(n0) AT=1696.000000p
.measure tran M_n1 FIND V(n1) AT=2198.000000p
.measure tran C_n1 FIND V(n1) AT=1696.000000p
.measure tran M_n2 FIND V(n2) AT=2198.000000p
.measure tran C_n2 FIND V(n2) AT=1696.000000p
.measure tran M_n3 FIND V(n3) AT=2198.000000p
.measure tran C_n3 FIND V(n3) AT=1696.000000p
.measure tran M_n4 FIND V(n4) AT=2198.000000p
.measure tran C_n4 FIND V(n4) AT=1696.000000p
.measure tran M_n5 FIND V(n5) AT=2198.000000p
.measure tran C_n5 FIND V(n5) AT=1696.000000p
.measure tran M_n6 FIND V(n6) AT=2198.000000p
.measure tran C_n6 FIND V(n6) AT=1696.000000p
.measure tran M_n7 FIND V(n7) AT=2198.000000p
.measure tran C_n7 FIND V(n7) AT=1696.000000p
.measure tran M_n8 FIND V(n8) AT=2198.000000p
.measure tran C_n8 FIND V(n8) AT=1696.000000p
.measure tran M_n9 FIND V(n9) AT=2198.000000p
.measure tran C_n9 FIND V(n9) AT=1696.000000p
.measure tran M_n10 FIND V(n10) AT=2198.000000p
.measure tran C_n10 FIND V(n10) AT=1696.000000p
.measure tran M_n11 FIND V(n11) AT=2198.000000p
.measure tran C_n11 FIND V(n11) AT=1696.000000p
.measure tran M_n12 FIND V(n12) AT=2198.000000p
.measure tran C_n12 FIND V(n12) AT=1696.000000p
.measure tran M_n13 FIND V(n13) AT=2198.000000p
.measure tran C_n13 FIND V(n13) AT=1696.000000p
.measure tran M_n14 FIND V(n14) AT=2198.000000p
.measure tran C_n14 FIND V(n14) AT=1696.000000p
.measure tran M_n15 FIND V(n15) AT=2198.000000p
.measure tran C_n15 FIND V(n15) AT=1696.000000p
.measure tran M_n16 FIND V(n16) AT=2198.000000p
.measure tran C_n16 FIND V(n16) AT=1696.000000p
.measure tran M_n17 FIND V(n17) AT=2198.000000p
.measure tran C_n17 FIND V(n17) AT=1696.000000p
.measure tran M_n18 FIND V(n18) AT=2198.000000p
.measure tran C_n18 FIND V(n18) AT=1696.000000p
.measure tran M_n19 FIND V(n19) AT=2198.000000p
.measure tran C_n19 FIND V(n19) AT=1696.000000p
.measure tran M_n20 FIND V(n20) AT=2198.000000p
.measure tran C_n20 FIND V(n20) AT=1696.000000p
.measure tran M_n21 FIND V(n21) AT=2198.000000p
.measure tran C_n21 FIND V(n21) AT=1696.000000p
.measure tran M_n22 FIND V(n22) AT=2198.000000p
.measure tran C_n22 FIND V(n22) AT=1696.000000p
.measure tran M_n23 FIND V(n23) AT=2198.000000p
.measure tran C_n23 FIND V(n23) AT=1696.000000p
.measure tran M_n24 FIND V(n24) AT=2198.000000p
.measure tran C_n24 FIND V(n24) AT=1696.000000p
.measure tran M_n25 FIND V(n25) AT=2198.000000p
.measure tran C_n25 FIND V(n25) AT=1696.000000p
.measure tran M_n26 FIND V(n26) AT=2198.000000p
.measure tran C_n26 FIND V(n26) AT=1696.000000p
.measure tran M_n27 FIND V(n27) AT=2198.000000p
.measure tran C_n27 FIND V(n27) AT=1696.000000p
.measure tran M_n28 FIND V(n28) AT=2198.000000p
.measure tran C_n28 FIND V(n28) AT=1696.000000p
.measure tran M_n29 FIND V(n29) AT=2198.000000p
.measure tran C_n29 FIND V(n29) AT=1696.000000p
.measure tran M_n30 FIND V(n30) AT=2198.000000p
.measure tran C_n30 FIND V(n30) AT=1696.000000p
.measure tran M_n31 FIND V(n31) AT=2198.000000p
.measure tran C_n31 FIND V(n31) AT=1696.000000p
.print tran V(vdd) I(VDD) V(xqvdd) V(n0) V(n1) V(n2) V(n3) V(n4) V(n5) V(n6) V(n7) V(n8) V(n9) V(n10) V(n11) V(n12) V(n13) V(n14) V(n15) V(n16) V(n17) V(n18) V(n19) V(n20) V(n21) V(n22) V(n23) V(n24) V(n25) V(n26) V(n27) V(n28) V(n29) V(n30) V(n31)
.end
