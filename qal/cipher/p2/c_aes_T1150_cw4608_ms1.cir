.hdl "/usr/local/share/xyce/verilog-a/psp103/psp103.va"
.include "/usr/local/src/kestrel/sim/models/sg13g2_psp103_tt.lib"
.include "/usr/local/src/stat-sim/qal/sg13lv_compat.sp"
.OPTIONS TIMEINT METHOD=GEAR RELTOL=1e-6 ABSTOL=1e-15 CHGTOL=1e-17
.include "/usr/local/src/IHP-Open-PDK/ihp-sg13g2/libs.ref/sg13g2_stdcell/spice/sg13g2_stdcell.spice"
VHI vhi 0 1.5
VMG1 gn1 0 0
VS_s_rk0 s_rk0 0 0
VS_s_rk1 s_rk1 0 1.65
VS_s_rk10 s_rk10 0 0
VS_s_rk100 s_rk100 0 1.65
VS_s_rk101 s_rk101 0 0
VS_s_rk102 s_rk102 0 1.65
VS_s_rk103 s_rk103 0 0
VS_s_rk104 s_rk104 0 1.65
VS_s_rk105 s_rk105 0 1.65
VS_s_rk106 s_rk106 0 1.65
VS_s_rk107 s_rk107 0 0
VS_s_rk108 s_rk108 0 1.65
VS_s_rk109 s_rk109 0 1.65
VS_s_rk11 s_rk11 0 0
VS_s_rk110 s_rk110 0 1.65
VS_s_rk111 s_rk111 0 0
VS_s_rk112 s_rk112 0 0
VS_s_rk113 s_rk113 0 0
VS_s_rk114 s_rk114 0 0
VS_s_rk115 s_rk115 0 1.65
VS_s_rk116 s_rk116 0 1.65
VS_s_rk117 s_rk117 0 0
VS_s_rk118 s_rk118 0 0
VS_s_rk119 s_rk119 0 1.65
VS_s_rk12 s_rk12 0 1.65
VS_s_rk120 s_rk120 0 1.65
VS_s_rk121 s_rk121 0 0
VS_s_rk122 s_rk122 0 1.65
VS_s_rk123 s_rk123 0 1.65
VS_s_rk124 s_rk124 0 1.65
VS_s_rk125 s_rk125 0 1.65
VS_s_rk126 s_rk126 0 0
VS_s_rk127 s_rk127 0 1.65
VS_s_rk13 s_rk13 0 0
VS_s_rk14 s_rk14 0 0
VS_s_rk15 s_rk15 0 0
VS_s_rk16 s_rk16 0 0
VS_s_rk17 s_rk17 0 0
VS_s_rk18 s_rk18 0 1.65
VS_s_rk19 s_rk19 0 0
VS_s_rk2 s_rk2 0 1.65
VS_s_rk20 s_rk20 0 1.65
VS_s_rk21 s_rk21 0 1.65
VS_s_rk22 s_rk22 0 0
VS_s_rk23 s_rk23 0 0
VS_s_rk24 s_rk24 0 1.65
VS_s_rk25 s_rk25 0 0
VS_s_rk26 s_rk26 0 0
VS_s_rk27 s_rk27 0 1.65
VS_s_rk28 s_rk28 0 1.65
VS_s_rk29 s_rk29 0 0
VS_s_rk3 s_rk3 0 1.65
VS_s_rk30 s_rk30 0 1.65
VS_s_rk31 s_rk31 0 0
VS_s_rk32 s_rk32 0 0
VS_s_rk33 s_rk33 0 1.65
VS_s_rk34 s_rk34 0 0
VS_s_rk35 s_rk35 0 1.65
VS_s_rk36 s_rk36 0 1.65
VS_s_rk37 s_rk37 0 1.65
VS_s_rk38 s_rk38 0 1.65
VS_s_rk39 s_rk39 0 0
VS_s_rk4 s_rk4 0 0
VS_s_rk40 s_rk40 0 1.65
VS_s_rk41 s_rk41 0 1.65
VS_s_rk42 s_rk42 0 1.65
VS_s_rk43 s_rk43 0 1.65
VS_s_rk44 s_rk44 0 1.65
VS_s_rk45 s_rk45 0 0
VS_s_rk46 s_rk46 0 0
VS_s_rk47 s_rk47 0 1.65
VS_s_rk48 s_rk48 0 0
VS_s_rk49 s_rk49 0 0
VS_s_rk5 s_rk5 0 0
VS_s_rk50 s_rk50 0 0
VS_s_rk51 s_rk51 0 0
VS_s_rk52 s_rk52 0 0
VS_s_rk53 s_rk53 0 1.65
VS_s_rk54 s_rk54 0 0
VS_s_rk55 s_rk55 0 1.65
VS_s_rk56 s_rk56 0 1.65
VS_s_rk57 s_rk57 0 0
VS_s_rk58 s_rk58 0 1.65
VS_s_rk59 s_rk59 0 0
VS_s_rk6 s_rk6 0 0
VS_s_rk60 s_rk60 0 0
VS_s_rk61 s_rk61 0 0
VS_s_rk62 s_rk62 0 1.65
VS_s_rk63 s_rk63 0 1.65
VS_s_rk64 s_rk64 0 0
VS_s_rk65 s_rk65 0 1.65
VS_s_rk66 s_rk66 0 1.65
VS_s_rk67 s_rk67 0 0
VS_s_rk68 s_rk68 0 0
VS_s_rk69 s_rk69 0 1.65
VS_s_rk7 s_rk7 0 0
VS_s_rk70 s_rk70 0 1.65
VS_s_rk71 s_rk71 0 1.65
VS_s_rk72 s_rk72 0 1.65
VS_s_rk73 s_rk73 0 1.65
VS_s_rk74 s_rk74 0 0
VS_s_rk75 s_rk75 0 1.65
VS_s_rk76 s_rk76 0 0
VS_s_rk77 s_rk77 0 0
VS_s_rk78 s_rk78 0 0
VS_s_rk79 s_rk79 0 0
VS_s_rk8 s_rk8 0 1.65
VS_s_rk80 s_rk80 0 0
VS_s_rk81 s_rk81 0 0
VS_s_rk82 s_rk82 0 1.65
VS_s_rk83 s_rk83 0 1.65
VS_s_rk84 s_rk84 0 0
VS_s_rk85 s_rk85 0 1.65
VS_s_rk86 s_rk86 0 0
VS_s_rk87 s_rk87 0 0
VS_s_rk88 s_rk88 0 1.65
VS_s_rk89 s_rk89 0 0
VS_s_rk9 s_rk9 0 1.65
VS_s_rk90 s_rk90 0 0
VS_s_rk91 s_rk91 0 0
VS_s_rk92 s_rk92 0 1.65
VS_s_rk93 s_rk93 0 1.65
VS_s_rk94 s_rk94 0 0
VS_s_rk95 s_rk95 0 0
VS_s_rk96 s_rk96 0 0
VS_s_rk97 s_rk97 0 1.65
VS_s_rk98 s_rk98 0 0
VS_s_rk99 s_rk99 0 0
VS_s_st0 s_st0 0 0
VS_s_st1 s_st1 0 1.65
VS_s_st10 s_st10 0 0
VS_s_st100 s_st100 0 1.65
VS_s_st101 s_st101 0 0
VS_s_st102 s_st102 0 1.65
VS_s_st103 s_st103 0 1.65
VS_s_st104 s_st104 0 0
VS_s_st105 s_st105 0 1.65
VS_s_st106 s_st106 0 0
VS_s_st107 s_st107 0 1.65
VS_s_st108 s_st108 0 1.65
VS_s_st109 s_st109 0 1.65
VS_s_st11 s_st11 0 1.65
VS_s_st110 s_st110 0 1.65
VS_s_st111 s_st111 0 1.65
VS_s_st112 s_st112 0 0
VS_s_st113 s_st113 0 1.65
VS_s_st114 s_st114 0 0
VS_s_st115 s_st115 0 1.65
VS_s_st116 s_st116 0 1.65
VS_s_st117 s_st117 0 0
VS_s_st118 s_st118 0 0
VS_s_st119 s_st119 0 0
VS_s_st12 s_st12 0 1.65
VS_s_st120 s_st120 0 0
VS_s_st121 s_st121 0 1.65
VS_s_st122 s_st122 0 0
VS_s_st123 s_st123 0 1.65
VS_s_st124 s_st124 0 1.65
VS_s_st125 s_st125 0 1.65
VS_s_st126 s_st126 0 0
VS_s_st127 s_st127 0 0
VS_s_st13 s_st13 0 1.65
VS_s_st14 s_st14 0 1.65
VS_s_st15 s_st15 0 0
VS_s_st16 s_st16 0 0
VS_s_st17 s_st17 0 1.65
VS_s_st18 s_st18 0 0
VS_s_st19 s_st19 0 1.65
VS_s_st2 s_st2 0 0
VS_s_st20 s_st20 0 1.65
VS_s_st21 s_st21 0 0
VS_s_st22 s_st22 0 0
VS_s_st23 s_st23 0 1.65
VS_s_st24 s_st24 0 0
VS_s_st25 s_st25 0 1.65
VS_s_st26 s_st26 0 0
VS_s_st27 s_st27 0 1.65
VS_s_st28 s_st28 0 1.65
VS_s_st29 s_st29 0 1.65
VS_s_st3 s_st3 0 1.65
VS_s_st30 s_st30 0 0
VS_s_st31 s_st31 0 1.65
VS_s_st32 s_st32 0 0
VS_s_st33 s_st33 0 1.65
VS_s_st34 s_st34 0 0
VS_s_st35 s_st35 0 1.65
VS_s_st36 s_st36 0 1.65
VS_s_st37 s_st37 0 0
VS_s_st38 s_st38 0 1.65
VS_s_st39 s_st39 0 1.65
VS_s_st4 s_st4 0 1.65
VS_s_st40 s_st40 0 0
VS_s_st41 s_st41 0 1.65
VS_s_st42 s_st42 0 0
VS_s_st43 s_st43 0 1.65
VS_s_st44 s_st44 0 1.65
VS_s_st45 s_st45 0 1.65
VS_s_st46 s_st46 0 1.65
VS_s_st47 s_st47 0 1.65
VS_s_st48 s_st48 0 0
VS_s_st49 s_st49 0 1.65
VS_s_st5 s_st5 0 0
VS_s_st50 s_st50 0 0
VS_s_st51 s_st51 0 1.65
VS_s_st52 s_st52 0 1.65
VS_s_st53 s_st53 0 0
VS_s_st54 s_st54 0 0
VS_s_st55 s_st55 0 0
VS_s_st56 s_st56 0 0
VS_s_st57 s_st57 0 1.65
VS_s_st58 s_st58 0 0
VS_s_st59 s_st59 0 1.65
VS_s_st6 s_st6 0 1.65
VS_s_st60 s_st60 0 1.65
VS_s_st61 s_st61 0 1.65
VS_s_st62 s_st62 0 0
VS_s_st63 s_st63 0 0
VS_s_st64 s_st64 0 0
VS_s_st65 s_st65 0 1.65
VS_s_st66 s_st66 0 0
VS_s_st67 s_st67 0 1.65
VS_s_st68 s_st68 0 1.65
VS_s_st69 s_st69 0 0
VS_s_st7 s_st7 0 0
VS_s_st70 s_st70 0 1.65
VS_s_st71 s_st71 0 0
VS_s_st72 s_st72 0 0
VS_s_st73 s_st73 0 1.65
VS_s_st74 s_st74 0 0
VS_s_st75 s_st75 0 1.65
VS_s_st76 s_st76 0 1.65
VS_s_st77 s_st77 0 1.65
VS_s_st78 s_st78 0 1.65
VS_s_st79 s_st79 0 0
VS_s_st8 s_st8 0 0
VS_s_st80 s_st80 0 0
VS_s_st81 s_st81 0 1.65
VS_s_st82 s_st82 0 0
VS_s_st83 s_st83 0 1.65
VS_s_st84 s_st84 0 1.65
VS_s_st85 s_st85 0 0
VS_s_st86 s_st86 0 0
VS_s_st87 s_st87 0 1.65
VS_s_st88 s_st88 0 0
VS_s_st89 s_st89 0 1.65
VS_s_st9 s_st9 0 1.65
VS_s_st90 s_st90 0 0
VS_s_st91 s_st91 0 1.65
VS_s_st92 s_st92 0 1.65
VS_s_st93 s_st93 0 1.65
VS_s_st94 s_st94 0 0
VS_s_st95 s_st95 0 1.65
VS_s_st96 s_st96 0 0
VS_s_st97 s_st97 0 1.65
VS_s_st98 s_st98 0 0
VS_s_st99 s_st99 0 1.65
XINV1_0 o1_0 s_st0 rail1 gn1 sg13g2_inv_1
CL1_0 o1_0 gn1 2f
XINV1_1 o1_1 s_st1 rail1 gn1 sg13g2_inv_1
CL1_1 o1_1 gn1 2f
XINV1_2 o1_2 s_st2 rail1 gn1 sg13g2_inv_1
CL1_2 o1_2 gn1 2f
XINV1_3 o1_3 s_st3 rail1 gn1 sg13g2_inv_1
CL1_3 o1_3 gn1 2f
XINV1_4 o1_4 s_st4 rail1 gn1 sg13g2_inv_1
CL1_4 o1_4 gn1 2f
XINV1_5 o1_5 s_st5 rail1 gn1 sg13g2_inv_1
CL1_5 o1_5 gn1 2f
XINV1_6 o1_6 s_st6 rail1 gn1 sg13g2_inv_1
CL1_6 o1_6 gn1 2f
XINV1_7 o1_7 s_st7 rail1 gn1 sg13g2_inv_1
CL1_7 o1_7 gn1 2f
XINV1_8 o1_8 s_st8 rail1 gn1 sg13g2_inv_1
CL1_8 o1_8 gn1 2f
XINV1_9 o1_9 s_st9 rail1 gn1 sg13g2_inv_1
CL1_9 o1_9 gn1 2f
XINV1_10 o1_10 s_st10 rail1 gn1 sg13g2_inv_1
CL1_10 o1_10 gn1 2f
XINV1_11 o1_11 s_st11 rail1 gn1 sg13g2_inv_1
CL1_11 o1_11 gn1 2f
XINV1_12 o1_12 s_st12 rail1 gn1 sg13g2_inv_1
CL1_12 o1_12 gn1 2f
XINV1_13 o1_13 s_st13 rail1 gn1 sg13g2_inv_1
CL1_13 o1_13 gn1 2f
XINV1_14 o1_14 s_st14 rail1 gn1 sg13g2_inv_1
CL1_14 o1_14 gn1 2f
XINV1_15 o1_15 s_st15 rail1 gn1 sg13g2_inv_1
CL1_15 o1_15 gn1 2f
XINV1_16 o1_16 s_st16 rail1 gn1 sg13g2_inv_1
CL1_16 o1_16 gn1 2f
XINV1_17 o1_17 s_st17 rail1 gn1 sg13g2_inv_1
CL1_17 o1_17 gn1 2f
XINV1_18 o1_18 s_st18 rail1 gn1 sg13g2_inv_1
CL1_18 o1_18 gn1 2f
XINV1_19 o1_19 s_st19 rail1 gn1 sg13g2_inv_1
CL1_19 o1_19 gn1 2f
XINV1_20 o1_20 s_st20 rail1 gn1 sg13g2_inv_1
CL1_20 o1_20 gn1 2f
XINV1_21 o1_21 s_st21 rail1 gn1 sg13g2_inv_1
CL1_21 o1_21 gn1 2f
XINV1_22 o1_22 s_st22 rail1 gn1 sg13g2_inv_1
CL1_22 o1_22 gn1 2f
XINV1_23 o1_23 s_st23 rail1 gn1 sg13g2_inv_1
CL1_23 o1_23 gn1 2f
XINV1_24 o1_24 s_st24 rail1 gn1 sg13g2_inv_1
CL1_24 o1_24 gn1 2f
XINV1_25 o1_25 s_st25 rail1 gn1 sg13g2_inv_1
CL1_25 o1_25 gn1 2f
XINV1_26 o1_26 s_st26 rail1 gn1 sg13g2_inv_1
CL1_26 o1_26 gn1 2f
XINV1_27 o1_27 s_st27 rail1 gn1 sg13g2_inv_1
CL1_27 o1_27 gn1 2f
XINV1_28 o1_28 s_st28 rail1 gn1 sg13g2_inv_1
CL1_28 o1_28 gn1 2f
XINV1_29 o1_29 s_st29 rail1 gn1 sg13g2_inv_1
CL1_29 o1_29 gn1 2f
XINV1_30 o1_30 s_st30 rail1 gn1 sg13g2_inv_1
CL1_30 o1_30 gn1 2f
XINV1_31 o1_31 s_st31 rail1 gn1 sg13g2_inv_1
CL1_31 o1_31 gn1 2f
XINV1_32 o1_32 s_st32 rail1 gn1 sg13g2_inv_1
CL1_32 o1_32 gn1 2f
XINV1_33 o1_33 s_st33 rail1 gn1 sg13g2_inv_1
CL1_33 o1_33 gn1 2f
XINV1_34 o1_34 s_st34 rail1 gn1 sg13g2_inv_1
CL1_34 o1_34 gn1 2f
XINV1_35 o1_35 s_st35 rail1 gn1 sg13g2_inv_1
CL1_35 o1_35 gn1 2f
XINV1_36 o1_36 s_st36 rail1 gn1 sg13g2_inv_1
CL1_36 o1_36 gn1 2f
XINV1_37 o1_37 s_st37 rail1 gn1 sg13g2_inv_1
CL1_37 o1_37 gn1 2f
XINV1_38 o1_38 s_st38 rail1 gn1 sg13g2_inv_1
CL1_38 o1_38 gn1 2f
XINV1_39 o1_39 s_st39 rail1 gn1 sg13g2_inv_1
CL1_39 o1_39 gn1 2f
XINV1_40 o1_40 s_st40 rail1 gn1 sg13g2_inv_1
CL1_40 o1_40 gn1 2f
XINV1_41 o1_41 s_st41 rail1 gn1 sg13g2_inv_1
CL1_41 o1_41 gn1 2f
XINV1_42 o1_42 s_st42 rail1 gn1 sg13g2_inv_1
CL1_42 o1_42 gn1 2f
XINV1_43 o1_43 s_st43 rail1 gn1 sg13g2_inv_1
CL1_43 o1_43 gn1 2f
XINV1_44 o1_44 s_st44 rail1 gn1 sg13g2_inv_1
CL1_44 o1_44 gn1 2f
XINV1_45 o1_45 s_st45 rail1 gn1 sg13g2_inv_1
CL1_45 o1_45 gn1 2f
XINV1_46 o1_46 s_st46 rail1 gn1 sg13g2_inv_1
CL1_46 o1_46 gn1 2f
XINV1_47 o1_47 s_st47 rail1 gn1 sg13g2_inv_1
CL1_47 o1_47 gn1 2f
XINV1_48 o1_48 s_st48 rail1 gn1 sg13g2_inv_1
CL1_48 o1_48 gn1 2f
XINV1_49 o1_49 s_st49 rail1 gn1 sg13g2_inv_1
CL1_49 o1_49 gn1 2f
XINV1_50 o1_50 s_st50 rail1 gn1 sg13g2_inv_1
CL1_50 o1_50 gn1 2f
XINV1_51 o1_51 s_st51 rail1 gn1 sg13g2_inv_1
CL1_51 o1_51 gn1 2f
XINV1_52 o1_52 s_st52 rail1 gn1 sg13g2_inv_1
CL1_52 o1_52 gn1 2f
XINV1_53 o1_53 s_st53 rail1 gn1 sg13g2_inv_1
CL1_53 o1_53 gn1 2f
XINV1_54 o1_54 s_st54 rail1 gn1 sg13g2_inv_1
CL1_54 o1_54 gn1 2f
XINV1_55 o1_55 s_st55 rail1 gn1 sg13g2_inv_1
CL1_55 o1_55 gn1 2f
XINV1_56 o1_56 s_st56 rail1 gn1 sg13g2_inv_1
CL1_56 o1_56 gn1 2f
XINV1_57 o1_57 s_st57 rail1 gn1 sg13g2_inv_1
CL1_57 o1_57 gn1 2f
XINV1_58 o1_58 s_st58 rail1 gn1 sg13g2_inv_1
CL1_58 o1_58 gn1 2f
XINV1_59 o1_59 s_st59 rail1 gn1 sg13g2_inv_1
CL1_59 o1_59 gn1 2f
XINV1_60 o1_60 s_st60 rail1 gn1 sg13g2_inv_1
CL1_60 o1_60 gn1 2f
XINV1_61 o1_61 s_st61 rail1 gn1 sg13g2_inv_1
CL1_61 o1_61 gn1 2f
XINV1_62 o1_62 s_st62 rail1 gn1 sg13g2_inv_1
CL1_62 o1_62 gn1 2f
XINV1_63 o1_63 s_st63 rail1 gn1 sg13g2_inv_1
CL1_63 o1_63 gn1 2f
XINV1_64 o1_64 s_st64 rail1 gn1 sg13g2_inv_1
CL1_64 o1_64 gn1 2f
XINV1_65 o1_65 s_st65 rail1 gn1 sg13g2_inv_1
CL1_65 o1_65 gn1 2f
XINV1_66 o1_66 s_st66 rail1 gn1 sg13g2_inv_1
CL1_66 o1_66 gn1 2f
XINV1_67 o1_67 s_st67 rail1 gn1 sg13g2_inv_1
CL1_67 o1_67 gn1 2f
XINV1_68 o1_68 s_st68 rail1 gn1 sg13g2_inv_1
CL1_68 o1_68 gn1 2f
XINV1_69 o1_69 s_st69 rail1 gn1 sg13g2_inv_1
CL1_69 o1_69 gn1 2f
XINV1_70 o1_70 s_st70 rail1 gn1 sg13g2_inv_1
CL1_70 o1_70 gn1 2f
XINV1_71 o1_71 s_st71 rail1 gn1 sg13g2_inv_1
CL1_71 o1_71 gn1 2f
XINV1_72 o1_72 s_st72 rail1 gn1 sg13g2_inv_1
CL1_72 o1_72 gn1 2f
XINV1_73 o1_73 s_st73 rail1 gn1 sg13g2_inv_1
CL1_73 o1_73 gn1 2f
XINV1_74 o1_74 s_st74 rail1 gn1 sg13g2_inv_1
CL1_74 o1_74 gn1 2f
XINV1_75 o1_75 s_st75 rail1 gn1 sg13g2_inv_1
CL1_75 o1_75 gn1 2f
XINV1_76 o1_76 s_st76 rail1 gn1 sg13g2_inv_1
CL1_76 o1_76 gn1 2f
XINV1_77 o1_77 s_st77 rail1 gn1 sg13g2_inv_1
CL1_77 o1_77 gn1 2f
XINV1_78 o1_78 s_st78 rail1 gn1 sg13g2_inv_1
CL1_78 o1_78 gn1 2f
XINV1_79 o1_79 s_st79 rail1 gn1 sg13g2_inv_1
CL1_79 o1_79 gn1 2f
XINV1_80 o1_80 s_st80 rail1 gn1 sg13g2_inv_1
CL1_80 o1_80 gn1 2f
XINV1_81 o1_81 s_st81 rail1 gn1 sg13g2_inv_1
CL1_81 o1_81 gn1 2f
XINV1_82 o1_82 s_st82 rail1 gn1 sg13g2_inv_1
CL1_82 o1_82 gn1 2f
XINV1_83 o1_83 s_st83 rail1 gn1 sg13g2_inv_1
CL1_83 o1_83 gn1 2f
XINV1_84 o1_84 s_st84 rail1 gn1 sg13g2_inv_1
CL1_84 o1_84 gn1 2f
XINV1_85 o1_85 s_st85 rail1 gn1 sg13g2_inv_1
CL1_85 o1_85 gn1 2f
XINV1_86 o1_86 s_st86 rail1 gn1 sg13g2_inv_1
CL1_86 o1_86 gn1 2f
XINV1_87 o1_87 s_st87 rail1 gn1 sg13g2_inv_1
CL1_87 o1_87 gn1 2f
XINV1_88 o1_88 s_st88 rail1 gn1 sg13g2_inv_1
CL1_88 o1_88 gn1 2f
XINV1_89 o1_89 s_st89 rail1 gn1 sg13g2_inv_1
CL1_89 o1_89 gn1 2f
XINV1_90 o1_90 s_st90 rail1 gn1 sg13g2_inv_1
CL1_90 o1_90 gn1 2f
XINV1_91 o1_91 s_st91 rail1 gn1 sg13g2_inv_1
CL1_91 o1_91 gn1 2f
XINV1_92 o1_92 s_st92 rail1 gn1 sg13g2_inv_1
CL1_92 o1_92 gn1 2f
XINV1_93 o1_93 s_st93 rail1 gn1 sg13g2_inv_1
CL1_93 o1_93 gn1 2f
XINV1_94 o1_94 s_st94 rail1 gn1 sg13g2_inv_1
CL1_94 o1_94 gn1 2f
XINV1_95 o1_95 s_st95 rail1 gn1 sg13g2_inv_1
CL1_95 o1_95 gn1 2f
XINV1_96 o1_96 s_st96 rail1 gn1 sg13g2_inv_1
CL1_96 o1_96 gn1 2f
XINV1_97 o1_97 s_st97 rail1 gn1 sg13g2_inv_1
CL1_97 o1_97 gn1 2f
XINV1_98 o1_98 s_st98 rail1 gn1 sg13g2_inv_1
CL1_98 o1_98 gn1 2f
XINV1_99 o1_99 s_st99 rail1 gn1 sg13g2_inv_1
CL1_99 o1_99 gn1 2f
XINV1_100 o1_100 s_st100 rail1 gn1 sg13g2_inv_1
CL1_100 o1_100 gn1 2f
XINV1_101 o1_101 s_st101 rail1 gn1 sg13g2_inv_1
CL1_101 o1_101 gn1 2f
XINV1_102 o1_102 s_st102 rail1 gn1 sg13g2_inv_1
CL1_102 o1_102 gn1 2f
XINV1_103 o1_103 s_st103 rail1 gn1 sg13g2_inv_1
CL1_103 o1_103 gn1 2f
XINV1_104 o1_104 s_st104 rail1 gn1 sg13g2_inv_1
CL1_104 o1_104 gn1 2f
XINV1_105 o1_105 s_st105 rail1 gn1 sg13g2_inv_1
CL1_105 o1_105 gn1 2f
XINV1_106 o1_106 s_st106 rail1 gn1 sg13g2_inv_1
CL1_106 o1_106 gn1 2f
XINV1_107 o1_107 s_st107 rail1 gn1 sg13g2_inv_1
CL1_107 o1_107 gn1 2f
XINV1_108 o1_108 s_st108 rail1 gn1 sg13g2_inv_1
CL1_108 o1_108 gn1 2f
XINV1_109 o1_109 s_st109 rail1 gn1 sg13g2_inv_1
CL1_109 o1_109 gn1 2f
XINV1_110 o1_110 s_st110 rail1 gn1 sg13g2_inv_1
CL1_110 o1_110 gn1 2f
XINV1_111 o1_111 s_st111 rail1 gn1 sg13g2_inv_1
CL1_111 o1_111 gn1 2f
XINV1_112 o1_112 s_st112 rail1 gn1 sg13g2_inv_1
CL1_112 o1_112 gn1 2f
XINV1_113 o1_113 s_st113 rail1 gn1 sg13g2_inv_1
CL1_113 o1_113 gn1 2f
XINV1_114 o1_114 s_st114 rail1 gn1 sg13g2_inv_1
CL1_114 o1_114 gn1 2f
XINV1_115 o1_115 s_st115 rail1 gn1 sg13g2_inv_1
CL1_115 o1_115 gn1 2f
XINV1_116 o1_116 s_st116 rail1 gn1 sg13g2_inv_1
CL1_116 o1_116 gn1 2f
XINV1_117 o1_117 s_st117 rail1 gn1 sg13g2_inv_1
CL1_117 o1_117 gn1 2f
XINV1_118 o1_118 s_st118 rail1 gn1 sg13g2_inv_1
CL1_118 o1_118 gn1 2f
XINV1_119 o1_119 s_st119 rail1 gn1 sg13g2_inv_1
CL1_119 o1_119 gn1 2f
XINV1_120 o1_120 s_st120 rail1 gn1 sg13g2_inv_1
CL1_120 o1_120 gn1 2f
XINV1_121 o1_121 s_st121 rail1 gn1 sg13g2_inv_1
CL1_121 o1_121 gn1 2f
XINV1_122 o1_122 s_st122 rail1 gn1 sg13g2_inv_1
CL1_122 o1_122 gn1 2f
XINV1_123 o1_123 s_st123 rail1 gn1 sg13g2_inv_1
CL1_123 o1_123 gn1 2f
XINV1_124 o1_124 s_st124 rail1 gn1 sg13g2_inv_1
CL1_124 o1_124 gn1 2f
XINV1_125 o1_125 s_st125 rail1 gn1 sg13g2_inv_1
CL1_125 o1_125 gn1 2f
XINV1_126 o1_126 s_st126 rail1 gn1 sg13g2_inv_1
CL1_126 o1_126 gn1 2f
XINV1_127 o1_127 s_st127 rail1 gn1 sg13g2_inv_1
CL1_127 o1_127 gn1 2f
VMG2 gn2 0 0
XXOR22_0 o2_0 o1_0 s_rk0 rail2 gn2 sg13g2_xor2_1
CL2_0 o2_0 gn2 2f
XXOR22_1 o2_1 o1_1 s_rk1 rail2 gn2 sg13g2_xor2_1
CL2_1 o2_1 gn2 2f
XXOR22_2 o2_2 o1_2 s_rk2 rail2 gn2 sg13g2_xor2_1
CL2_2 o2_2 gn2 2f
XXOR22_3 o2_3 o1_3 s_rk3 rail2 gn2 sg13g2_xor2_1
CL2_3 o2_3 gn2 2f
XXOR22_4 o2_4 o1_4 s_rk4 rail2 gn2 sg13g2_xor2_1
CL2_4 o2_4 gn2 2f
XXOR22_5 o2_5 o1_5 s_rk5 rail2 gn2 sg13g2_xor2_1
CL2_5 o2_5 gn2 2f
XXOR22_6 o2_6 o1_6 s_rk6 rail2 gn2 sg13g2_xor2_1
CL2_6 o2_6 gn2 2f
XXOR22_7 o2_7 o1_7 s_rk7 rail2 gn2 sg13g2_xor2_1
CL2_7 o2_7 gn2 2f
XXOR22_8 o2_8 o1_8 s_rk8 rail2 gn2 sg13g2_xor2_1
CL2_8 o2_8 gn2 2f
CW2_8 o2_8 gn2 4.608000f
XXOR22_9 o2_9 o1_9 s_rk9 rail2 gn2 sg13g2_xor2_1
CL2_9 o2_9 gn2 2f
CW2_9 o2_9 gn2 4.608000f
XXOR22_10 o2_10 o1_10 s_rk10 rail2 gn2 sg13g2_xor2_1
CL2_10 o2_10 gn2 2f
CW2_10 o2_10 gn2 4.608000f
XXOR22_11 o2_11 o1_11 s_rk11 rail2 gn2 sg13g2_xor2_1
CL2_11 o2_11 gn2 2f
CW2_11 o2_11 gn2 4.608000f
XXOR22_12 o2_12 o1_12 s_rk12 rail2 gn2 sg13g2_xor2_1
CL2_12 o2_12 gn2 2f
CW2_12 o2_12 gn2 4.608000f
XXOR22_13 o2_13 o1_13 s_rk13 rail2 gn2 sg13g2_xor2_1
CL2_13 o2_13 gn2 2f
CW2_13 o2_13 gn2 4.608000f
XXOR22_14 o2_14 o1_14 s_rk14 rail2 gn2 sg13g2_xor2_1
CL2_14 o2_14 gn2 2f
CW2_14 o2_14 gn2 4.608000f
XXOR22_15 o2_15 o1_15 s_rk15 rail2 gn2 sg13g2_xor2_1
CL2_15 o2_15 gn2 2f
CW2_15 o2_15 gn2 4.608000f
XXOR22_16 o2_16 o1_16 s_rk16 rail2 gn2 sg13g2_xor2_1
CL2_16 o2_16 gn2 2f
CW2_16 o2_16 gn2 9.216000f
XXOR22_17 o2_17 o1_17 s_rk17 rail2 gn2 sg13g2_xor2_1
CL2_17 o2_17 gn2 2f
CW2_17 o2_17 gn2 9.216000f
XXOR22_18 o2_18 o1_18 s_rk18 rail2 gn2 sg13g2_xor2_1
CL2_18 o2_18 gn2 2f
CW2_18 o2_18 gn2 9.216000f
XXOR22_19 o2_19 o1_19 s_rk19 rail2 gn2 sg13g2_xor2_1
CL2_19 o2_19 gn2 2f
CW2_19 o2_19 gn2 9.216000f
XXOR22_20 o2_20 o1_20 s_rk20 rail2 gn2 sg13g2_xor2_1
CL2_20 o2_20 gn2 2f
CW2_20 o2_20 gn2 9.216000f
XXOR22_21 o2_21 o1_21 s_rk21 rail2 gn2 sg13g2_xor2_1
CL2_21 o2_21 gn2 2f
CW2_21 o2_21 gn2 9.216000f
XXOR22_22 o2_22 o1_22 s_rk22 rail2 gn2 sg13g2_xor2_1
CL2_22 o2_22 gn2 2f
CW2_22 o2_22 gn2 9.216000f
XXOR22_23 o2_23 o1_23 s_rk23 rail2 gn2 sg13g2_xor2_1
CL2_23 o2_23 gn2 2f
CW2_23 o2_23 gn2 9.216000f
XXOR22_24 o2_24 o1_24 s_rk24 rail2 gn2 sg13g2_xor2_1
CL2_24 o2_24 gn2 2f
CW2_24 o2_24 gn2 4.608000f
XXOR22_25 o2_25 o1_25 s_rk25 rail2 gn2 sg13g2_xor2_1
CL2_25 o2_25 gn2 2f
CW2_25 o2_25 gn2 4.608000f
XXOR22_26 o2_26 o1_26 s_rk26 rail2 gn2 sg13g2_xor2_1
CL2_26 o2_26 gn2 2f
CW2_26 o2_26 gn2 4.608000f
XXOR22_27 o2_27 o1_27 s_rk27 rail2 gn2 sg13g2_xor2_1
CL2_27 o2_27 gn2 2f
CW2_27 o2_27 gn2 4.608000f
XXOR22_28 o2_28 o1_28 s_rk28 rail2 gn2 sg13g2_xor2_1
CL2_28 o2_28 gn2 2f
CW2_28 o2_28 gn2 4.608000f
XXOR22_29 o2_29 o1_29 s_rk29 rail2 gn2 sg13g2_xor2_1
CL2_29 o2_29 gn2 2f
CW2_29 o2_29 gn2 4.608000f
XXOR22_30 o2_30 o1_30 s_rk30 rail2 gn2 sg13g2_xor2_1
CL2_30 o2_30 gn2 2f
CW2_30 o2_30 gn2 4.608000f
XXOR22_31 o2_31 o1_31 s_rk31 rail2 gn2 sg13g2_xor2_1
CL2_31 o2_31 gn2 2f
CW2_31 o2_31 gn2 4.608000f
XXOR22_32 o2_32 o1_32 s_rk32 rail2 gn2 sg13g2_xor2_1
CL2_32 o2_32 gn2 2f
XXOR22_33 o2_33 o1_33 s_rk33 rail2 gn2 sg13g2_xor2_1
CL2_33 o2_33 gn2 2f
XXOR22_34 o2_34 o1_34 s_rk34 rail2 gn2 sg13g2_xor2_1
CL2_34 o2_34 gn2 2f
XXOR22_35 o2_35 o1_35 s_rk35 rail2 gn2 sg13g2_xor2_1
CL2_35 o2_35 gn2 2f
XXOR22_36 o2_36 o1_36 s_rk36 rail2 gn2 sg13g2_xor2_1
CL2_36 o2_36 gn2 2f
XXOR22_37 o2_37 o1_37 s_rk37 rail2 gn2 sg13g2_xor2_1
CL2_37 o2_37 gn2 2f
XXOR22_38 o2_38 o1_38 s_rk38 rail2 gn2 sg13g2_xor2_1
CL2_38 o2_38 gn2 2f
XXOR22_39 o2_39 o1_39 s_rk39 rail2 gn2 sg13g2_xor2_1
CL2_39 o2_39 gn2 2f
XXOR22_40 o2_40 o1_40 s_rk40 rail2 gn2 sg13g2_xor2_1
CL2_40 o2_40 gn2 2f
CW2_40 o2_40 gn2 4.608000f
XXOR22_41 o2_41 o1_41 s_rk41 rail2 gn2 sg13g2_xor2_1
CL2_41 o2_41 gn2 2f
CW2_41 o2_41 gn2 4.608000f
XXOR22_42 o2_42 o1_42 s_rk42 rail2 gn2 sg13g2_xor2_1
CL2_42 o2_42 gn2 2f
CW2_42 o2_42 gn2 4.608000f
XXOR22_43 o2_43 o1_43 s_rk43 rail2 gn2 sg13g2_xor2_1
CL2_43 o2_43 gn2 2f
CW2_43 o2_43 gn2 4.608000f
XXOR22_44 o2_44 o1_44 s_rk44 rail2 gn2 sg13g2_xor2_1
CL2_44 o2_44 gn2 2f
CW2_44 o2_44 gn2 4.608000f
XXOR22_45 o2_45 o1_45 s_rk45 rail2 gn2 sg13g2_xor2_1
CL2_45 o2_45 gn2 2f
CW2_45 o2_45 gn2 4.608000f
XXOR22_46 o2_46 o1_46 s_rk46 rail2 gn2 sg13g2_xor2_1
CL2_46 o2_46 gn2 2f
CW2_46 o2_46 gn2 4.608000f
XXOR22_47 o2_47 o1_47 s_rk47 rail2 gn2 sg13g2_xor2_1
CL2_47 o2_47 gn2 2f
CW2_47 o2_47 gn2 4.608000f
XXOR22_48 o2_48 o1_48 s_rk48 rail2 gn2 sg13g2_xor2_1
CL2_48 o2_48 gn2 2f
CW2_48 o2_48 gn2 9.216000f
XXOR22_49 o2_49 o1_49 s_rk49 rail2 gn2 sg13g2_xor2_1
CL2_49 o2_49 gn2 2f
CW2_49 o2_49 gn2 9.216000f
XXOR22_50 o2_50 o1_50 s_rk50 rail2 gn2 sg13g2_xor2_1
CL2_50 o2_50 gn2 2f
CW2_50 o2_50 gn2 9.216000f
XXOR22_51 o2_51 o1_51 s_rk51 rail2 gn2 sg13g2_xor2_1
CL2_51 o2_51 gn2 2f
CW2_51 o2_51 gn2 9.216000f
XXOR22_52 o2_52 o1_52 s_rk52 rail2 gn2 sg13g2_xor2_1
CL2_52 o2_52 gn2 2f
CW2_52 o2_52 gn2 9.216000f
XXOR22_53 o2_53 o1_53 s_rk53 rail2 gn2 sg13g2_xor2_1
CL2_53 o2_53 gn2 2f
CW2_53 o2_53 gn2 9.216000f
XXOR22_54 o2_54 o1_54 s_rk54 rail2 gn2 sg13g2_xor2_1
CL2_54 o2_54 gn2 2f
CW2_54 o2_54 gn2 9.216000f
XXOR22_55 o2_55 o1_55 s_rk55 rail2 gn2 sg13g2_xor2_1
CL2_55 o2_55 gn2 2f
CW2_55 o2_55 gn2 9.216000f
XXOR22_56 o2_56 o1_56 s_rk56 rail2 gn2 sg13g2_xor2_1
CL2_56 o2_56 gn2 2f
CW2_56 o2_56 gn2 4.608000f
XXOR22_57 o2_57 o1_57 s_rk57 rail2 gn2 sg13g2_xor2_1
CL2_57 o2_57 gn2 2f
CW2_57 o2_57 gn2 4.608000f
XXOR22_58 o2_58 o1_58 s_rk58 rail2 gn2 sg13g2_xor2_1
CL2_58 o2_58 gn2 2f
CW2_58 o2_58 gn2 4.608000f
XXOR22_59 o2_59 o1_59 s_rk59 rail2 gn2 sg13g2_xor2_1
CL2_59 o2_59 gn2 2f
CW2_59 o2_59 gn2 4.608000f
XXOR22_60 o2_60 o1_60 s_rk60 rail2 gn2 sg13g2_xor2_1
CL2_60 o2_60 gn2 2f
CW2_60 o2_60 gn2 4.608000f
XXOR22_61 o2_61 o1_61 s_rk61 rail2 gn2 sg13g2_xor2_1
CL2_61 o2_61 gn2 2f
CW2_61 o2_61 gn2 4.608000f
XXOR22_62 o2_62 o1_62 s_rk62 rail2 gn2 sg13g2_xor2_1
CL2_62 o2_62 gn2 2f
CW2_62 o2_62 gn2 4.608000f
XXOR22_63 o2_63 o1_63 s_rk63 rail2 gn2 sg13g2_xor2_1
CL2_63 o2_63 gn2 2f
CW2_63 o2_63 gn2 4.608000f
XXOR22_64 o2_64 o1_64 s_rk64 rail2 gn2 sg13g2_xor2_1
CL2_64 o2_64 gn2 2f
XXOR22_65 o2_65 o1_65 s_rk65 rail2 gn2 sg13g2_xor2_1
CL2_65 o2_65 gn2 2f
XXOR22_66 o2_66 o1_66 s_rk66 rail2 gn2 sg13g2_xor2_1
CL2_66 o2_66 gn2 2f
XXOR22_67 o2_67 o1_67 s_rk67 rail2 gn2 sg13g2_xor2_1
CL2_67 o2_67 gn2 2f
XXOR22_68 o2_68 o1_68 s_rk68 rail2 gn2 sg13g2_xor2_1
CL2_68 o2_68 gn2 2f
XXOR22_69 o2_69 o1_69 s_rk69 rail2 gn2 sg13g2_xor2_1
CL2_69 o2_69 gn2 2f
XXOR22_70 o2_70 o1_70 s_rk70 rail2 gn2 sg13g2_xor2_1
CL2_70 o2_70 gn2 2f
XXOR22_71 o2_71 o1_71 s_rk71 rail2 gn2 sg13g2_xor2_1
CL2_71 o2_71 gn2 2f
XXOR22_72 o2_72 o1_72 s_rk72 rail2 gn2 sg13g2_xor2_1
CL2_72 o2_72 gn2 2f
CW2_72 o2_72 gn2 4.608000f
XXOR22_73 o2_73 o1_73 s_rk73 rail2 gn2 sg13g2_xor2_1
CL2_73 o2_73 gn2 2f
CW2_73 o2_73 gn2 4.608000f
XXOR22_74 o2_74 o1_74 s_rk74 rail2 gn2 sg13g2_xor2_1
CL2_74 o2_74 gn2 2f
CW2_74 o2_74 gn2 4.608000f
XXOR22_75 o2_75 o1_75 s_rk75 rail2 gn2 sg13g2_xor2_1
CL2_75 o2_75 gn2 2f
CW2_75 o2_75 gn2 4.608000f
XXOR22_76 o2_76 o1_76 s_rk76 rail2 gn2 sg13g2_xor2_1
CL2_76 o2_76 gn2 2f
CW2_76 o2_76 gn2 4.608000f
XXOR22_77 o2_77 o1_77 s_rk77 rail2 gn2 sg13g2_xor2_1
CL2_77 o2_77 gn2 2f
CW2_77 o2_77 gn2 4.608000f
XXOR22_78 o2_78 o1_78 s_rk78 rail2 gn2 sg13g2_xor2_1
CL2_78 o2_78 gn2 2f
CW2_78 o2_78 gn2 4.608000f
XXOR22_79 o2_79 o1_79 s_rk79 rail2 gn2 sg13g2_xor2_1
CL2_79 o2_79 gn2 2f
CW2_79 o2_79 gn2 4.608000f
XXOR22_80 o2_80 o1_80 s_rk80 rail2 gn2 sg13g2_xor2_1
CL2_80 o2_80 gn2 2f
CW2_80 o2_80 gn2 9.216000f
XXOR22_81 o2_81 o1_81 s_rk81 rail2 gn2 sg13g2_xor2_1
CL2_81 o2_81 gn2 2f
CW2_81 o2_81 gn2 9.216000f
XXOR22_82 o2_82 o1_82 s_rk82 rail2 gn2 sg13g2_xor2_1
CL2_82 o2_82 gn2 2f
CW2_82 o2_82 gn2 9.216000f
XXOR22_83 o2_83 o1_83 s_rk83 rail2 gn2 sg13g2_xor2_1
CL2_83 o2_83 gn2 2f
CW2_83 o2_83 gn2 9.216000f
XXOR22_84 o2_84 o1_84 s_rk84 rail2 gn2 sg13g2_xor2_1
CL2_84 o2_84 gn2 2f
CW2_84 o2_84 gn2 9.216000f
XXOR22_85 o2_85 o1_85 s_rk85 rail2 gn2 sg13g2_xor2_1
CL2_85 o2_85 gn2 2f
CW2_85 o2_85 gn2 9.216000f
XXOR22_86 o2_86 o1_86 s_rk86 rail2 gn2 sg13g2_xor2_1
CL2_86 o2_86 gn2 2f
CW2_86 o2_86 gn2 9.216000f
XXOR22_87 o2_87 o1_87 s_rk87 rail2 gn2 sg13g2_xor2_1
CL2_87 o2_87 gn2 2f
CW2_87 o2_87 gn2 9.216000f
XXOR22_88 o2_88 o1_88 s_rk88 rail2 gn2 sg13g2_xor2_1
CL2_88 o2_88 gn2 2f
CW2_88 o2_88 gn2 4.608000f
XXOR22_89 o2_89 o1_89 s_rk89 rail2 gn2 sg13g2_xor2_1
CL2_89 o2_89 gn2 2f
CW2_89 o2_89 gn2 4.608000f
XXOR22_90 o2_90 o1_90 s_rk90 rail2 gn2 sg13g2_xor2_1
CL2_90 o2_90 gn2 2f
CW2_90 o2_90 gn2 4.608000f
XXOR22_91 o2_91 o1_91 s_rk91 rail2 gn2 sg13g2_xor2_1
CL2_91 o2_91 gn2 2f
CW2_91 o2_91 gn2 4.608000f
XXOR22_92 o2_92 o1_92 s_rk92 rail2 gn2 sg13g2_xor2_1
CL2_92 o2_92 gn2 2f
CW2_92 o2_92 gn2 4.608000f
XXOR22_93 o2_93 o1_93 s_rk93 rail2 gn2 sg13g2_xor2_1
CL2_93 o2_93 gn2 2f
CW2_93 o2_93 gn2 4.608000f
XXOR22_94 o2_94 o1_94 s_rk94 rail2 gn2 sg13g2_xor2_1
CL2_94 o2_94 gn2 2f
CW2_94 o2_94 gn2 4.608000f
XXOR22_95 o2_95 o1_95 s_rk95 rail2 gn2 sg13g2_xor2_1
CL2_95 o2_95 gn2 2f
CW2_95 o2_95 gn2 4.608000f
XXOR22_96 o2_96 o1_96 s_rk96 rail2 gn2 sg13g2_xor2_1
CL2_96 o2_96 gn2 2f
XXOR22_97 o2_97 o1_97 s_rk97 rail2 gn2 sg13g2_xor2_1
CL2_97 o2_97 gn2 2f
XXOR22_98 o2_98 o1_98 s_rk98 rail2 gn2 sg13g2_xor2_1
CL2_98 o2_98 gn2 2f
XXOR22_99 o2_99 o1_99 s_rk99 rail2 gn2 sg13g2_xor2_1
CL2_99 o2_99 gn2 2f
XXOR22_100 o2_100 o1_100 s_rk100 rail2 gn2 sg13g2_xor2_1
CL2_100 o2_100 gn2 2f
XXOR22_101 o2_101 o1_101 s_rk101 rail2 gn2 sg13g2_xor2_1
CL2_101 o2_101 gn2 2f
XXOR22_102 o2_102 o1_102 s_rk102 rail2 gn2 sg13g2_xor2_1
CL2_102 o2_102 gn2 2f
XXOR22_103 o2_103 o1_103 s_rk103 rail2 gn2 sg13g2_xor2_1
CL2_103 o2_103 gn2 2f
XXOR22_104 o2_104 o1_104 s_rk104 rail2 gn2 sg13g2_xor2_1
CL2_104 o2_104 gn2 2f
CW2_104 o2_104 gn2 4.608000f
XXOR22_105 o2_105 o1_105 s_rk105 rail2 gn2 sg13g2_xor2_1
CL2_105 o2_105 gn2 2f
CW2_105 o2_105 gn2 4.608000f
XXOR22_106 o2_106 o1_106 s_rk106 rail2 gn2 sg13g2_xor2_1
CL2_106 o2_106 gn2 2f
CW2_106 o2_106 gn2 4.608000f
XXOR22_107 o2_107 o1_107 s_rk107 rail2 gn2 sg13g2_xor2_1
CL2_107 o2_107 gn2 2f
CW2_107 o2_107 gn2 4.608000f
XXOR22_108 o2_108 o1_108 s_rk108 rail2 gn2 sg13g2_xor2_1
CL2_108 o2_108 gn2 2f
CW2_108 o2_108 gn2 4.608000f
XXOR22_109 o2_109 o1_109 s_rk109 rail2 gn2 sg13g2_xor2_1
CL2_109 o2_109 gn2 2f
CW2_109 o2_109 gn2 4.608000f
XXOR22_110 o2_110 o1_110 s_rk110 rail2 gn2 sg13g2_xor2_1
CL2_110 o2_110 gn2 2f
CW2_110 o2_110 gn2 4.608000f
XXOR22_111 o2_111 o1_111 s_rk111 rail2 gn2 sg13g2_xor2_1
CL2_111 o2_111 gn2 2f
CW2_111 o2_111 gn2 4.608000f
XXOR22_112 o2_112 o1_112 s_rk112 rail2 gn2 sg13g2_xor2_1
CL2_112 o2_112 gn2 2f
CW2_112 o2_112 gn2 9.216000f
XXOR22_113 o2_113 o1_113 s_rk113 rail2 gn2 sg13g2_xor2_1
CL2_113 o2_113 gn2 2f
CW2_113 o2_113 gn2 9.216000f
XXOR22_114 o2_114 o1_114 s_rk114 rail2 gn2 sg13g2_xor2_1
CL2_114 o2_114 gn2 2f
CW2_114 o2_114 gn2 9.216000f
XXOR22_115 o2_115 o1_115 s_rk115 rail2 gn2 sg13g2_xor2_1
CL2_115 o2_115 gn2 2f
CW2_115 o2_115 gn2 9.216000f
XXOR22_116 o2_116 o1_116 s_rk116 rail2 gn2 sg13g2_xor2_1
CL2_116 o2_116 gn2 2f
CW2_116 o2_116 gn2 9.216000f
XXOR22_117 o2_117 o1_117 s_rk117 rail2 gn2 sg13g2_xor2_1
CL2_117 o2_117 gn2 2f
CW2_117 o2_117 gn2 9.216000f
XXOR22_118 o2_118 o1_118 s_rk118 rail2 gn2 sg13g2_xor2_1
CL2_118 o2_118 gn2 2f
CW2_118 o2_118 gn2 9.216000f
XXOR22_119 o2_119 o1_119 s_rk119 rail2 gn2 sg13g2_xor2_1
CL2_119 o2_119 gn2 2f
CW2_119 o2_119 gn2 9.216000f
XXOR22_120 o2_120 o1_120 s_rk120 rail2 gn2 sg13g2_xor2_1
CL2_120 o2_120 gn2 2f
CW2_120 o2_120 gn2 4.608000f
XXOR22_121 o2_121 o1_121 s_rk121 rail2 gn2 sg13g2_xor2_1
CL2_121 o2_121 gn2 2f
CW2_121 o2_121 gn2 4.608000f
XXOR22_122 o2_122 o1_122 s_rk122 rail2 gn2 sg13g2_xor2_1
CL2_122 o2_122 gn2 2f
CW2_122 o2_122 gn2 4.608000f
XXOR22_123 o2_123 o1_123 s_rk123 rail2 gn2 sg13g2_xor2_1
CL2_123 o2_123 gn2 2f
CW2_123 o2_123 gn2 4.608000f
XXOR22_124 o2_124 o1_124 s_rk124 rail2 gn2 sg13g2_xor2_1
CL2_124 o2_124 gn2 2f
CW2_124 o2_124 gn2 4.608000f
XXOR22_125 o2_125 o1_125 s_rk125 rail2 gn2 sg13g2_xor2_1
CL2_125 o2_125 gn2 2f
CW2_125 o2_125 gn2 4.608000f
XXOR22_126 o2_126 o1_126 s_rk126 rail2 gn2 sg13g2_xor2_1
CL2_126 o2_126 gn2 2f
CW2_126 o2_126 gn2 4.608000f
XXOR22_127 o2_127 o1_127 s_rk127 rail2 gn2 sg13g2_xor2_1
CL2_127 o2_127 gn2 2f
CW2_127 o2_127 gn2 4.608000f
VMG3 gn3 0 0
XINV3_0 o3_0 o2_0 rail3 gn3 sg13g2_inv_1
CL3_0 o3_0 gn3 2f
XINV3_1 o3_1 o2_1 rail3 gn3 sg13g2_inv_1
CL3_1 o3_1 gn3 2f
XINV3_2 o3_2 o2_2 rail3 gn3 sg13g2_inv_1
CL3_2 o3_2 gn3 2f
XINV3_3 o3_3 o2_3 rail3 gn3 sg13g2_inv_1
CL3_3 o3_3 gn3 2f
XINV3_4 o3_4 o2_4 rail3 gn3 sg13g2_inv_1
CL3_4 o3_4 gn3 2f
XINV3_5 o3_5 o2_5 rail3 gn3 sg13g2_inv_1
CL3_5 o3_5 gn3 2f
XINV3_6 o3_6 o2_6 rail3 gn3 sg13g2_inv_1
CL3_6 o3_6 gn3 2f
XINV3_7 o3_7 o2_7 rail3 gn3 sg13g2_inv_1
CL3_7 o3_7 gn3 2f
XINV3_8 o3_8 o2_40 rail3 gn3 sg13g2_inv_1
CL3_8 o3_8 gn3 2f
XINV3_9 o3_9 o2_41 rail3 gn3 sg13g2_inv_1
CL3_9 o3_9 gn3 2f
XINV3_10 o3_10 o2_42 rail3 gn3 sg13g2_inv_1
CL3_10 o3_10 gn3 2f
XINV3_11 o3_11 o2_43 rail3 gn3 sg13g2_inv_1
CL3_11 o3_11 gn3 2f
XINV3_12 o3_12 o2_44 rail3 gn3 sg13g2_inv_1
CL3_12 o3_12 gn3 2f
XINV3_13 o3_13 o2_45 rail3 gn3 sg13g2_inv_1
CL3_13 o3_13 gn3 2f
XINV3_14 o3_14 o2_46 rail3 gn3 sg13g2_inv_1
CL3_14 o3_14 gn3 2f
XINV3_15 o3_15 o2_47 rail3 gn3 sg13g2_inv_1
CL3_15 o3_15 gn3 2f
XINV3_16 o3_16 o2_80 rail3 gn3 sg13g2_inv_1
CL3_16 o3_16 gn3 2f
XINV3_17 o3_17 o2_81 rail3 gn3 sg13g2_inv_1
CL3_17 o3_17 gn3 2f
XINV3_18 o3_18 o2_82 rail3 gn3 sg13g2_inv_1
CL3_18 o3_18 gn3 2f
XINV3_19 o3_19 o2_83 rail3 gn3 sg13g2_inv_1
CL3_19 o3_19 gn3 2f
XINV3_20 o3_20 o2_84 rail3 gn3 sg13g2_inv_1
CL3_20 o3_20 gn3 2f
XINV3_21 o3_21 o2_85 rail3 gn3 sg13g2_inv_1
CL3_21 o3_21 gn3 2f
XINV3_22 o3_22 o2_86 rail3 gn3 sg13g2_inv_1
CL3_22 o3_22 gn3 2f
XINV3_23 o3_23 o2_87 rail3 gn3 sg13g2_inv_1
CL3_23 o3_23 gn3 2f
XINV3_24 o3_24 o2_120 rail3 gn3 sg13g2_inv_1
CL3_24 o3_24 gn3 2f
XINV3_25 o3_25 o2_121 rail3 gn3 sg13g2_inv_1
CL3_25 o3_25 gn3 2f
XINV3_26 o3_26 o2_122 rail3 gn3 sg13g2_inv_1
CL3_26 o3_26 gn3 2f
XINV3_27 o3_27 o2_123 rail3 gn3 sg13g2_inv_1
CL3_27 o3_27 gn3 2f
XINV3_28 o3_28 o2_124 rail3 gn3 sg13g2_inv_1
CL3_28 o3_28 gn3 2f
XINV3_29 o3_29 o2_125 rail3 gn3 sg13g2_inv_1
CL3_29 o3_29 gn3 2f
XINV3_30 o3_30 o2_126 rail3 gn3 sg13g2_inv_1
CL3_30 o3_30 gn3 2f
XINV3_31 o3_31 o2_127 rail3 gn3 sg13g2_inv_1
CL3_31 o3_31 gn3 2f
XINV3_32 o3_32 o2_32 rail3 gn3 sg13g2_inv_1
CL3_32 o3_32 gn3 2f
XINV3_33 o3_33 o2_33 rail3 gn3 sg13g2_inv_1
CL3_33 o3_33 gn3 2f
XINV3_34 o3_34 o2_34 rail3 gn3 sg13g2_inv_1
CL3_34 o3_34 gn3 2f
XINV3_35 o3_35 o2_35 rail3 gn3 sg13g2_inv_1
CL3_35 o3_35 gn3 2f
XINV3_36 o3_36 o2_36 rail3 gn3 sg13g2_inv_1
CL3_36 o3_36 gn3 2f
XINV3_37 o3_37 o2_37 rail3 gn3 sg13g2_inv_1
CL3_37 o3_37 gn3 2f
XINV3_38 o3_38 o2_38 rail3 gn3 sg13g2_inv_1
CL3_38 o3_38 gn3 2f
XINV3_39 o3_39 o2_39 rail3 gn3 sg13g2_inv_1
CL3_39 o3_39 gn3 2f
XINV3_40 o3_40 o2_72 rail3 gn3 sg13g2_inv_1
CL3_40 o3_40 gn3 2f
XINV3_41 o3_41 o2_73 rail3 gn3 sg13g2_inv_1
CL3_41 o3_41 gn3 2f
XINV3_42 o3_42 o2_74 rail3 gn3 sg13g2_inv_1
CL3_42 o3_42 gn3 2f
XINV3_43 o3_43 o2_75 rail3 gn3 sg13g2_inv_1
CL3_43 o3_43 gn3 2f
XINV3_44 o3_44 o2_76 rail3 gn3 sg13g2_inv_1
CL3_44 o3_44 gn3 2f
XINV3_45 o3_45 o2_77 rail3 gn3 sg13g2_inv_1
CL3_45 o3_45 gn3 2f
XINV3_46 o3_46 o2_78 rail3 gn3 sg13g2_inv_1
CL3_46 o3_46 gn3 2f
XINV3_47 o3_47 o2_79 rail3 gn3 sg13g2_inv_1
CL3_47 o3_47 gn3 2f
XINV3_48 o3_48 o2_112 rail3 gn3 sg13g2_inv_1
CL3_48 o3_48 gn3 2f
XINV3_49 o3_49 o2_113 rail3 gn3 sg13g2_inv_1
CL3_49 o3_49 gn3 2f
XINV3_50 o3_50 o2_114 rail3 gn3 sg13g2_inv_1
CL3_50 o3_50 gn3 2f
XINV3_51 o3_51 o2_115 rail3 gn3 sg13g2_inv_1
CL3_51 o3_51 gn3 2f
XINV3_52 o3_52 o2_116 rail3 gn3 sg13g2_inv_1
CL3_52 o3_52 gn3 2f
XINV3_53 o3_53 o2_117 rail3 gn3 sg13g2_inv_1
CL3_53 o3_53 gn3 2f
XINV3_54 o3_54 o2_118 rail3 gn3 sg13g2_inv_1
CL3_54 o3_54 gn3 2f
XINV3_55 o3_55 o2_119 rail3 gn3 sg13g2_inv_1
CL3_55 o3_55 gn3 2f
XINV3_56 o3_56 o2_24 rail3 gn3 sg13g2_inv_1
CL3_56 o3_56 gn3 2f
XINV3_57 o3_57 o2_25 rail3 gn3 sg13g2_inv_1
CL3_57 o3_57 gn3 2f
XINV3_58 o3_58 o2_26 rail3 gn3 sg13g2_inv_1
CL3_58 o3_58 gn3 2f
XINV3_59 o3_59 o2_27 rail3 gn3 sg13g2_inv_1
CL3_59 o3_59 gn3 2f
XINV3_60 o3_60 o2_28 rail3 gn3 sg13g2_inv_1
CL3_60 o3_60 gn3 2f
XINV3_61 o3_61 o2_29 rail3 gn3 sg13g2_inv_1
CL3_61 o3_61 gn3 2f
XINV3_62 o3_62 o2_30 rail3 gn3 sg13g2_inv_1
CL3_62 o3_62 gn3 2f
XINV3_63 o3_63 o2_31 rail3 gn3 sg13g2_inv_1
CL3_63 o3_63 gn3 2f
XINV3_64 o3_64 o2_64 rail3 gn3 sg13g2_inv_1
CL3_64 o3_64 gn3 2f
XINV3_65 o3_65 o2_65 rail3 gn3 sg13g2_inv_1
CL3_65 o3_65 gn3 2f
XINV3_66 o3_66 o2_66 rail3 gn3 sg13g2_inv_1
CL3_66 o3_66 gn3 2f
XINV3_67 o3_67 o2_67 rail3 gn3 sg13g2_inv_1
CL3_67 o3_67 gn3 2f
XINV3_68 o3_68 o2_68 rail3 gn3 sg13g2_inv_1
CL3_68 o3_68 gn3 2f
XINV3_69 o3_69 o2_69 rail3 gn3 sg13g2_inv_1
CL3_69 o3_69 gn3 2f
XINV3_70 o3_70 o2_70 rail3 gn3 sg13g2_inv_1
CL3_70 o3_70 gn3 2f
XINV3_71 o3_71 o2_71 rail3 gn3 sg13g2_inv_1
CL3_71 o3_71 gn3 2f
XINV3_72 o3_72 o2_104 rail3 gn3 sg13g2_inv_1
CL3_72 o3_72 gn3 2f
XINV3_73 o3_73 o2_105 rail3 gn3 sg13g2_inv_1
CL3_73 o3_73 gn3 2f
XINV3_74 o3_74 o2_106 rail3 gn3 sg13g2_inv_1
CL3_74 o3_74 gn3 2f
XINV3_75 o3_75 o2_107 rail3 gn3 sg13g2_inv_1
CL3_75 o3_75 gn3 2f
XINV3_76 o3_76 o2_108 rail3 gn3 sg13g2_inv_1
CL3_76 o3_76 gn3 2f
XINV3_77 o3_77 o2_109 rail3 gn3 sg13g2_inv_1
CL3_77 o3_77 gn3 2f
XINV3_78 o3_78 o2_110 rail3 gn3 sg13g2_inv_1
CL3_78 o3_78 gn3 2f
XINV3_79 o3_79 o2_111 rail3 gn3 sg13g2_inv_1
CL3_79 o3_79 gn3 2f
XINV3_80 o3_80 o2_16 rail3 gn3 sg13g2_inv_1
CL3_80 o3_80 gn3 2f
XINV3_81 o3_81 o2_17 rail3 gn3 sg13g2_inv_1
CL3_81 o3_81 gn3 2f
XINV3_82 o3_82 o2_18 rail3 gn3 sg13g2_inv_1
CL3_82 o3_82 gn3 2f
XINV3_83 o3_83 o2_19 rail3 gn3 sg13g2_inv_1
CL3_83 o3_83 gn3 2f
XINV3_84 o3_84 o2_20 rail3 gn3 sg13g2_inv_1
CL3_84 o3_84 gn3 2f
XINV3_85 o3_85 o2_21 rail3 gn3 sg13g2_inv_1
CL3_85 o3_85 gn3 2f
XINV3_86 o3_86 o2_22 rail3 gn3 sg13g2_inv_1
CL3_86 o3_86 gn3 2f
XINV3_87 o3_87 o2_23 rail3 gn3 sg13g2_inv_1
CL3_87 o3_87 gn3 2f
XINV3_88 o3_88 o2_56 rail3 gn3 sg13g2_inv_1
CL3_88 o3_88 gn3 2f
XINV3_89 o3_89 o2_57 rail3 gn3 sg13g2_inv_1
CL3_89 o3_89 gn3 2f
XINV3_90 o3_90 o2_58 rail3 gn3 sg13g2_inv_1
CL3_90 o3_90 gn3 2f
XINV3_91 o3_91 o2_59 rail3 gn3 sg13g2_inv_1
CL3_91 o3_91 gn3 2f
XINV3_92 o3_92 o2_60 rail3 gn3 sg13g2_inv_1
CL3_92 o3_92 gn3 2f
XINV3_93 o3_93 o2_61 rail3 gn3 sg13g2_inv_1
CL3_93 o3_93 gn3 2f
XINV3_94 o3_94 o2_62 rail3 gn3 sg13g2_inv_1
CL3_94 o3_94 gn3 2f
XINV3_95 o3_95 o2_63 rail3 gn3 sg13g2_inv_1
CL3_95 o3_95 gn3 2f
XINV3_96 o3_96 o2_96 rail3 gn3 sg13g2_inv_1
CL3_96 o3_96 gn3 2f
XINV3_97 o3_97 o2_97 rail3 gn3 sg13g2_inv_1
CL3_97 o3_97 gn3 2f
XINV3_98 o3_98 o2_98 rail3 gn3 sg13g2_inv_1
CL3_98 o3_98 gn3 2f
XINV3_99 o3_99 o2_99 rail3 gn3 sg13g2_inv_1
CL3_99 o3_99 gn3 2f
XINV3_100 o3_100 o2_100 rail3 gn3 sg13g2_inv_1
CL3_100 o3_100 gn3 2f
XINV3_101 o3_101 o2_101 rail3 gn3 sg13g2_inv_1
CL3_101 o3_101 gn3 2f
XINV3_102 o3_102 o2_102 rail3 gn3 sg13g2_inv_1
CL3_102 o3_102 gn3 2f
XINV3_103 o3_103 o2_103 rail3 gn3 sg13g2_inv_1
CL3_103 o3_103 gn3 2f
XINV3_104 o3_104 o2_8 rail3 gn3 sg13g2_inv_1
CL3_104 o3_104 gn3 2f
XINV3_105 o3_105 o2_9 rail3 gn3 sg13g2_inv_1
CL3_105 o3_105 gn3 2f
XINV3_106 o3_106 o2_10 rail3 gn3 sg13g2_inv_1
CL3_106 o3_106 gn3 2f
XINV3_107 o3_107 o2_11 rail3 gn3 sg13g2_inv_1
CL3_107 o3_107 gn3 2f
XINV3_108 o3_108 o2_12 rail3 gn3 sg13g2_inv_1
CL3_108 o3_108 gn3 2f
XINV3_109 o3_109 o2_13 rail3 gn3 sg13g2_inv_1
CL3_109 o3_109 gn3 2f
XINV3_110 o3_110 o2_14 rail3 gn3 sg13g2_inv_1
CL3_110 o3_110 gn3 2f
XINV3_111 o3_111 o2_15 rail3 gn3 sg13g2_inv_1
CL3_111 o3_111 gn3 2f
XINV3_112 o3_112 o2_48 rail3 gn3 sg13g2_inv_1
CL3_112 o3_112 gn3 2f
XINV3_113 o3_113 o2_49 rail3 gn3 sg13g2_inv_1
CL3_113 o3_113 gn3 2f
XINV3_114 o3_114 o2_50 rail3 gn3 sg13g2_inv_1
CL3_114 o3_114 gn3 2f
XINV3_115 o3_115 o2_51 rail3 gn3 sg13g2_inv_1
CL3_115 o3_115 gn3 2f
XINV3_116 o3_116 o2_52 rail3 gn3 sg13g2_inv_1
CL3_116 o3_116 gn3 2f
XINV3_117 o3_117 o2_53 rail3 gn3 sg13g2_inv_1
CL3_117 o3_117 gn3 2f
XINV3_118 o3_118 o2_54 rail3 gn3 sg13g2_inv_1
CL3_118 o3_118 gn3 2f
XINV3_119 o3_119 o2_55 rail3 gn3 sg13g2_inv_1
CL3_119 o3_119 gn3 2f
XINV3_120 o3_120 o2_88 rail3 gn3 sg13g2_inv_1
CL3_120 o3_120 gn3 2f
XINV3_121 o3_121 o2_89 rail3 gn3 sg13g2_inv_1
CL3_121 o3_121 gn3 2f
XINV3_122 o3_122 o2_90 rail3 gn3 sg13g2_inv_1
CL3_122 o3_122 gn3 2f
XINV3_123 o3_123 o2_91 rail3 gn3 sg13g2_inv_1
CL3_123 o3_123 gn3 2f
XINV3_124 o3_124 o2_92 rail3 gn3 sg13g2_inv_1
CL3_124 o3_124 gn3 2f
XINV3_125 o3_125 o2_93 rail3 gn3 sg13g2_inv_1
CL3_125 o3_125 gn3 2f
XINV3_126 o3_126 o2_94 rail3 gn3 sg13g2_inv_1
CL3_126 o3_126 gn3 2f
XINV3_127 o3_127 o2_95 rail3 gn3 sg13g2_inv_1
CL3_127 o3_127 gn3 2f
CT1 tnk1 0 5756.64f
L1 tnk1 mid1 15n
R1 mid1 sw1 10
XSWN1 sw1 gt1 rail1 0 sg13_lv_nmos w=40u l=0.13u
XSWP1 sw1 gtp1 rail1 vhi sg13_lv_pmos w=80u l=0.13u
XPK1 sw1 pk1 tnk1 tnk1 sg13_lv_nmos w=8u l=0.13u
CT2 tnk2 0 24441.4f
L2 tnk2 mid2 15n
R2 mid2 sw2 10
XSWN2 sw2 gt2 rail2 0 sg13_lv_nmos w=80u l=0.13u
XSWP2 sw2 gtp2 rail2 vhi sg13_lv_pmos w=160u l=0.13u
XPK2 sw2 pk2 tnk2 tnk2 sg13_lv_nmos w=16u l=0.13u
CT3 tnk3 0 5756.64f
L3 tnk3 mid3 15n
R3 mid3 sw3 10
XSWN3 sw3 gt3 rail3 0 sg13_lv_nmos w=40u l=0.13u
XSWP3 sw3 gtp3 rail3 vhi sg13_lv_pmos w=80u l=0.13u
XPK3 sw3 pk3 tnk3 tnk3 sg13_lv_nmos w=8u l=0.13u
VGT1 gt1 0 PWL(0 0 198p 0 200p 1.5 585.844p 1.5 587.844p 0 4798p 0 4800p 1.5 5228.44p 1.5 5230.44p 0)
VGTP1 gtp1 0 PWL(0 1.5 198p 1.5 200p 0 585.844p 0 587.844p 1.5 4798p 1.5 4800p 0 5228.44p 0 5230.44p 1.5)
VPK1 pk1 0 PWL(0 1.5 198p 1.5 200p 0 585.844p 0 587.844p 1.5 4798p 1.5 4800p 0 5228.44p 0 5230.44p 1.5)
VGT2 gt2 0 PWL(0 0 1348p 0 1350p 1.5 2018.03p 1.5 2020.03p 0 5948p 0 5950p 1.5 6682.16p 1.5 6684.16p 0)
VGTP2 gtp2 0 PWL(0 1.5 1348p 1.5 1350p 0 2018.03p 0 2020.03p 1.5 5948p 1.5 5950p 0 6682.16p 0 6684.16p 1.5)
VPK2 pk2 0 PWL(0 1.5 1348p 1.5 1350p 0 2018.03p 0 2020.03p 1.5 5948p 1.5 5950p 0 6682.16p 0 6684.16p 1.5)
VGT3 gt3 0 PWL(0 0 2498p 0 2500p 1.5 2856.03p 1.5 2858.03p 0 7098p 0 7100p 1.5 7489.45p 1.5 7491.45p 0)
VGTP3 gtp3 0 PWL(0 1.5 2498p 1.5 2500p 0 2856.03p 0 2858.03p 1.5 7098p 1.5 7100p 0 7489.45p 0 7491.45p 1.5)
VPK3 pk3 0 PWL(0 1.5 2498p 1.5 2500p 0 2856.03p 0 2858.03p 1.5 7098p 1.5 7100p 0 7489.45p 0 7491.45p 1.5)
CXqlt1 xqlt1 0 1
BXqlt1 0 xqlt1 I={ I(L1) }
RXqlt1 xqlt1 0 0.01
CXea1 xea1 0 1
BXea1 0 xea1 I={ V(tnk1)*I(L1) }
RXea1 xea1 0 0.01
CXeb1 xeb1 0 1
BXeb1 0 xeb1 I={ V(rail1)*I(L1) }
RXeb1 xeb1 0 0.01
CXesw1 xesw1 0 1
BXesw1 0 xesw1 I={ V(sw1)*I(L1) }
RXesw1 xesw1 0 0.01
CXer1 xer1 0 1
BXer1 0 xer1 I={ I(L1)*I(L1)*10 }
RXer1 xer1 0 0.01
CXqg1 xqg1 0 1
BXqg1 0 xqg1 I={ I(VMG1) }
RXqg1 xqg1 0 0.01
CXqlt2 xqlt2 0 1
BXqlt2 0 xqlt2 I={ I(L2) }
RXqlt2 xqlt2 0 0.01
CXea2 xea2 0 1
BXea2 0 xea2 I={ V(tnk2)*I(L2) }
RXea2 xea2 0 0.01
CXeb2 xeb2 0 1
BXeb2 0 xeb2 I={ V(rail2)*I(L2) }
RXeb2 xeb2 0 0.01
CXesw2 xesw2 0 1
BXesw2 0 xesw2 I={ V(sw2)*I(L2) }
RXesw2 xesw2 0 0.01
CXer2 xer2 0 1
BXer2 0 xer2 I={ I(L2)*I(L2)*10 }
RXer2 xer2 0 0.01
CXqg2 xqg2 0 1
BXqg2 0 xqg2 I={ I(VMG2) }
RXqg2 xqg2 0 0.01
CXqlt3 xqlt3 0 1
BXqlt3 0 xqlt3 I={ I(L3) }
RXqlt3 xqlt3 0 0.01
CXea3 xea3 0 1
BXea3 0 xea3 I={ V(tnk3)*I(L3) }
RXea3 xea3 0 0.01
CXeb3 xeb3 0 1
BXeb3 0 xeb3 I={ V(rail3)*I(L3) }
RXeb3 xeb3 0 0.01
CXesw3 xesw3 0 1
BXesw3 0 xesw3 I={ V(sw3)*I(L3) }
RXesw3 xesw3 0 0.01
CXer3 xer3 0 1
BXer3 0 xer3 I={ I(L3)*I(L3)*10 }
RXer3 xer3 0 0.01
CXqg3 xqg3 0 1
BXqg3 0 xqg3 I={ I(VMG3) }
RXqg3 xqg3 0 0.01
CXqi1 xqi1 0 1
BXqi1 0 xqi1 I={ -(I(VS_s_rk0)+I(VS_s_rk1)+I(VS_s_rk10)+I(VS_s_rk100)+I(VS_s_rk101)+I(VS_s_rk102)+I(VS_s_rk103)+I(VS_s_rk104)+I(VS_s_rk105)+I(VS_s_rk106)+I(VS_s_rk107)+I(VS_s_rk108)+I(VS_s_rk109)+I(VS_s_rk11)+I(VS_s_rk110)+I(VS_s_rk111)+I(VS_s_rk112)+I(VS_s_rk113)+I(VS_s_rk114)+I(VS_s_rk115)+I(VS_s_rk116)+I(VS_s_rk117)+I(VS_s_rk118)+I(VS_s_rk119)+I(VS_s_rk12)+I(VS_s_rk120)+I(VS_s_rk121)+I(VS_s_rk122)+I(VS_s_rk123)+I(VS_s_rk124)+I(VS_s_rk125)+I(VS_s_rk126)+I(VS_s_rk127)+I(VS_s_rk13)+I(VS_s_rk14)+I(VS_s_rk15)+I(VS_s_rk16)+I(VS_s_rk17)+I(VS_s_rk18)+I(VS_s_rk19)+I(VS_s_rk2)+I(VS_s_rk20)+I(VS_s_rk21)+I(VS_s_rk22)+I(VS_s_rk23)+I(VS_s_rk24)+I(VS_s_rk25)+I(VS_s_rk26)+I(VS_s_rk27)+I(VS_s_rk28)+I(VS_s_rk29)+I(VS_s_rk3)+I(VS_s_rk30)+I(VS_s_rk31)+I(VS_s_rk32)+I(VS_s_rk33)+I(VS_s_rk34)+I(VS_s_rk35)+I(VS_s_rk36)+I(VS_s_rk37)+I(VS_s_rk38)+I(VS_s_rk39)+I(VS_s_rk4)+I(VS_s_rk40)+I(VS_s_rk41)+I(VS_s_rk42)+I(VS_s_rk43)+I(VS_s_rk44)+I(VS_s_rk45)+I(VS_s_rk46)+I(VS_s_rk47)+I(VS_s_rk48)+I(VS_s_rk49)+I(VS_s_rk5)+I(VS_s_rk50)+I(VS_s_rk51)+I(VS_s_rk52)+I(VS_s_rk53)+I(VS_s_rk54)+I(VS_s_rk55)+I(VS_s_rk56)+I(VS_s_rk57)+I(VS_s_rk58)+I(VS_s_rk59)+I(VS_s_rk6)+I(VS_s_rk60)+I(VS_s_rk61)+I(VS_s_rk62)+I(VS_s_rk63)+I(VS_s_rk64)+I(VS_s_rk65)+I(VS_s_rk66)+I(VS_s_rk67)+I(VS_s_rk68)+I(VS_s_rk69)+I(VS_s_rk7)+I(VS_s_rk70)+I(VS_s_rk71)+I(VS_s_rk72)+I(VS_s_rk73)+I(VS_s_rk74)+I(VS_s_rk75)+I(VS_s_rk76)+I(VS_s_rk77)+I(VS_s_rk78)+I(VS_s_rk79)+I(VS_s_rk8)+I(VS_s_rk80)+I(VS_s_rk81)+I(VS_s_rk82)+I(VS_s_rk83)+I(VS_s_rk84)+I(VS_s_rk85)+I(VS_s_rk86)+I(VS_s_rk87)+I(VS_s_rk88)+I(VS_s_rk89)+I(VS_s_rk9)+I(VS_s_rk90)+I(VS_s_rk91)+I(VS_s_rk92)+I(VS_s_rk93)+I(VS_s_rk94)+I(VS_s_rk95)+I(VS_s_rk96)+I(VS_s_rk97)+I(VS_s_rk98)+I(VS_s_rk99)+I(VS_s_st0)+I(VS_s_st1)+I(VS_s_st10)+I(VS_s_st100)+I(VS_s_st101)+I(VS_s_st102)+I(VS_s_st103)+I(VS_s_st104)+I(VS_s_st105)+I(VS_s_st106)+I(VS_s_st107)+I(VS_s_st108)+I(VS_s_st109)+I(VS_s_st11)+I(VS_s_st110)+I(VS_s_st111)+I(VS_s_st112)+I(VS_s_st113)+I(VS_s_st114)+I(VS_s_st115)+I(VS_s_st116)+I(VS_s_st117)+I(VS_s_st118)+I(VS_s_st119)+I(VS_s_st12)+I(VS_s_st120)+I(VS_s_st121)+I(VS_s_st122)+I(VS_s_st123)+I(VS_s_st124)+I(VS_s_st125)+I(VS_s_st126)+I(VS_s_st127)+I(VS_s_st13)+I(VS_s_st14)+I(VS_s_st15)+I(VS_s_st16)+I(VS_s_st17)+I(VS_s_st18)+I(VS_s_st19)+I(VS_s_st2)+I(VS_s_st20)+I(VS_s_st21)+I(VS_s_st22)+I(VS_s_st23)+I(VS_s_st24)+I(VS_s_st25)+I(VS_s_st26)+I(VS_s_st27)+I(VS_s_st28)+I(VS_s_st29)+I(VS_s_st3)+I(VS_s_st30)+I(VS_s_st31)+I(VS_s_st32)+I(VS_s_st33)+I(VS_s_st34)+I(VS_s_st35)+I(VS_s_st36)+I(VS_s_st37)+I(VS_s_st38)+I(VS_s_st39)+I(VS_s_st4)+I(VS_s_st40)+I(VS_s_st41)+I(VS_s_st42)+I(VS_s_st43)+I(VS_s_st44)+I(VS_s_st45)+I(VS_s_st46)+I(VS_s_st47)+I(VS_s_st48)+I(VS_s_st49)+I(VS_s_st5)+I(VS_s_st50)+I(VS_s_st51)+I(VS_s_st52)+I(VS_s_st53)+I(VS_s_st54)+I(VS_s_st55)+I(VS_s_st56)+I(VS_s_st57)+I(VS_s_st58)+I(VS_s_st59)+I(VS_s_st6)+I(VS_s_st60)+I(VS_s_st61)+I(VS_s_st62)+I(VS_s_st63)+I(VS_s_st64)+I(VS_s_st65)+I(VS_s_st66)+I(VS_s_st67)+I(VS_s_st68)+I(VS_s_st69)+I(VS_s_st7)+I(VS_s_st70)+I(VS_s_st71)+I(VS_s_st72)+I(VS_s_st73)+I(VS_s_st74)+I(VS_s_st75)+I(VS_s_st76)+I(VS_s_st77)+I(VS_s_st78)+I(VS_s_st79)+I(VS_s_st8)+I(VS_s_st80)+I(VS_s_st81)+I(VS_s_st82)+I(VS_s_st83)+I(VS_s_st84)+I(VS_s_st85)+I(VS_s_st86)+I(VS_s_st87)+I(VS_s_st88)+I(VS_s_st89)+I(VS_s_st9)+I(VS_s_st90)+I(VS_s_st91)+I(VS_s_st92)+I(VS_s_st93)+I(VS_s_st94)+I(VS_s_st95)+I(VS_s_st96)+I(VS_s_st97)+I(VS_s_st98)+I(VS_s_st99)) }
RXqi1 xqi1 0 0.01
CXei1 xei1 0 1
BXei1 0 xei1 I={ -(V(s_rk0)*I(VS_s_rk0)+V(s_rk1)*I(VS_s_rk1)+V(s_rk10)*I(VS_s_rk10)+V(s_rk100)*I(VS_s_rk100)+V(s_rk101)*I(VS_s_rk101)+V(s_rk102)*I(VS_s_rk102)+V(s_rk103)*I(VS_s_rk103)+V(s_rk104)*I(VS_s_rk104)+V(s_rk105)*I(VS_s_rk105)+V(s_rk106)*I(VS_s_rk106)+V(s_rk107)*I(VS_s_rk107)+V(s_rk108)*I(VS_s_rk108)+V(s_rk109)*I(VS_s_rk109)+V(s_rk11)*I(VS_s_rk11)+V(s_rk110)*I(VS_s_rk110)+V(s_rk111)*I(VS_s_rk111)+V(s_rk112)*I(VS_s_rk112)+V(s_rk113)*I(VS_s_rk113)+V(s_rk114)*I(VS_s_rk114)+V(s_rk115)*I(VS_s_rk115)+V(s_rk116)*I(VS_s_rk116)+V(s_rk117)*I(VS_s_rk117)+V(s_rk118)*I(VS_s_rk118)+V(s_rk119)*I(VS_s_rk119)+V(s_rk12)*I(VS_s_rk12)+V(s_rk120)*I(VS_s_rk120)+V(s_rk121)*I(VS_s_rk121)+V(s_rk122)*I(VS_s_rk122)+V(s_rk123)*I(VS_s_rk123)+V(s_rk124)*I(VS_s_rk124)+V(s_rk125)*I(VS_s_rk125)+V(s_rk126)*I(VS_s_rk126)+V(s_rk127)*I(VS_s_rk127)+V(s_rk13)*I(VS_s_rk13)+V(s_rk14)*I(VS_s_rk14)+V(s_rk15)*I(VS_s_rk15)+V(s_rk16)*I(VS_s_rk16)+V(s_rk17)*I(VS_s_rk17)+V(s_rk18)*I(VS_s_rk18)+V(s_rk19)*I(VS_s_rk19)+V(s_rk2)*I(VS_s_rk2)+V(s_rk20)*I(VS_s_rk20)+V(s_rk21)*I(VS_s_rk21)+V(s_rk22)*I(VS_s_rk22)+V(s_rk23)*I(VS_s_rk23)+V(s_rk24)*I(VS_s_rk24)+V(s_rk25)*I(VS_s_rk25)+V(s_rk26)*I(VS_s_rk26)+V(s_rk27)*I(VS_s_rk27)+V(s_rk28)*I(VS_s_rk28)+V(s_rk29)*I(VS_s_rk29)+V(s_rk3)*I(VS_s_rk3)+V(s_rk30)*I(VS_s_rk30)+V(s_rk31)*I(VS_s_rk31)+V(s_rk32)*I(VS_s_rk32)+V(s_rk33)*I(VS_s_rk33)+V(s_rk34)*I(VS_s_rk34)+V(s_rk35)*I(VS_s_rk35)+V(s_rk36)*I(VS_s_rk36)+V(s_rk37)*I(VS_s_rk37)+V(s_rk38)*I(VS_s_rk38)+V(s_rk39)*I(VS_s_rk39)+V(s_rk4)*I(VS_s_rk4)+V(s_rk40)*I(VS_s_rk40)+V(s_rk41)*I(VS_s_rk41)+V(s_rk42)*I(VS_s_rk42)+V(s_rk43)*I(VS_s_rk43)+V(s_rk44)*I(VS_s_rk44)+V(s_rk45)*I(VS_s_rk45)+V(s_rk46)*I(VS_s_rk46)+V(s_rk47)*I(VS_s_rk47)+V(s_rk48)*I(VS_s_rk48)+V(s_rk49)*I(VS_s_rk49)+V(s_rk5)*I(VS_s_rk5)+V(s_rk50)*I(VS_s_rk50)+V(s_rk51)*I(VS_s_rk51)+V(s_rk52)*I(VS_s_rk52)+V(s_rk53)*I(VS_s_rk53)+V(s_rk54)*I(VS_s_rk54)+V(s_rk55)*I(VS_s_rk55)+V(s_rk56)*I(VS_s_rk56)+V(s_rk57)*I(VS_s_rk57)+V(s_rk58)*I(VS_s_rk58)+V(s_rk59)*I(VS_s_rk59)+V(s_rk6)*I(VS_s_rk6)+V(s_rk60)*I(VS_s_rk60)+V(s_rk61)*I(VS_s_rk61)+V(s_rk62)*I(VS_s_rk62)+V(s_rk63)*I(VS_s_rk63)+V(s_rk64)*I(VS_s_rk64)+V(s_rk65)*I(VS_s_rk65)+V(s_rk66)*I(VS_s_rk66)+V(s_rk67)*I(VS_s_rk67)+V(s_rk68)*I(VS_s_rk68)+V(s_rk69)*I(VS_s_rk69)+V(s_rk7)*I(VS_s_rk7)+V(s_rk70)*I(VS_s_rk70)+V(s_rk71)*I(VS_s_rk71)+V(s_rk72)*I(VS_s_rk72)+V(s_rk73)*I(VS_s_rk73)+V(s_rk74)*I(VS_s_rk74)+V(s_rk75)*I(VS_s_rk75)+V(s_rk76)*I(VS_s_rk76)+V(s_rk77)*I(VS_s_rk77)+V(s_rk78)*I(VS_s_rk78)+V(s_rk79)*I(VS_s_rk79)+V(s_rk8)*I(VS_s_rk8)+V(s_rk80)*I(VS_s_rk80)+V(s_rk81)*I(VS_s_rk81)+V(s_rk82)*I(VS_s_rk82)+V(s_rk83)*I(VS_s_rk83)+V(s_rk84)*I(VS_s_rk84)+V(s_rk85)*I(VS_s_rk85)+V(s_rk86)*I(VS_s_rk86)+V(s_rk87)*I(VS_s_rk87)+V(s_rk88)*I(VS_s_rk88)+V(s_rk89)*I(VS_s_rk89)+V(s_rk9)*I(VS_s_rk9)+V(s_rk90)*I(VS_s_rk90)+V(s_rk91)*I(VS_s_rk91)+V(s_rk92)*I(VS_s_rk92)+V(s_rk93)*I(VS_s_rk93)+V(s_rk94)*I(VS_s_rk94)+V(s_rk95)*I(VS_s_rk95)+V(s_rk96)*I(VS_s_rk96)+V(s_rk97)*I(VS_s_rk97)+V(s_rk98)*I(VS_s_rk98)+V(s_rk99)*I(VS_s_rk99)+V(s_st0)*I(VS_s_st0)+V(s_st1)*I(VS_s_st1)+V(s_st10)*I(VS_s_st10)+V(s_st100)*I(VS_s_st100)+V(s_st101)*I(VS_s_st101)+V(s_st102)*I(VS_s_st102)+V(s_st103)*I(VS_s_st103)+V(s_st104)*I(VS_s_st104)+V(s_st105)*I(VS_s_st105)+V(s_st106)*I(VS_s_st106)+V(s_st107)*I(VS_s_st107)+V(s_st108)*I(VS_s_st108)+V(s_st109)*I(VS_s_st109)+V(s_st11)*I(VS_s_st11)+V(s_st110)*I(VS_s_st110)+V(s_st111)*I(VS_s_st111)+V(s_st112)*I(VS_s_st112)+V(s_st113)*I(VS_s_st113)+V(s_st114)*I(VS_s_st114)+V(s_st115)*I(VS_s_st115)+V(s_st116)*I(VS_s_st116)+V(s_st117)*I(VS_s_st117)+V(s_st118)*I(VS_s_st118)+V(s_st119)*I(VS_s_st119)+V(s_st12)*I(VS_s_st12)+V(s_st120)*I(VS_s_st120)+V(s_st121)*I(VS_s_st121)+V(s_st122)*I(VS_s_st122)+V(s_st123)*I(VS_s_st123)+V(s_st124)*I(VS_s_st124)+V(s_st125)*I(VS_s_st125)+V(s_st126)*I(VS_s_st126)+V(s_st127)*I(VS_s_st127)+V(s_st13)*I(VS_s_st13)+V(s_st14)*I(VS_s_st14)+V(s_st15)*I(VS_s_st15)+V(s_st16)*I(VS_s_st16)+V(s_st17)*I(VS_s_st17)+V(s_st18)*I(VS_s_st18)+V(s_st19)*I(VS_s_st19)+V(s_st2)*I(VS_s_st2)+V(s_st20)*I(VS_s_st20)+V(s_st21)*I(VS_s_st21)+V(s_st22)*I(VS_s_st22)+V(s_st23)*I(VS_s_st23)+V(s_st24)*I(VS_s_st24)+V(s_st25)*I(VS_s_st25)+V(s_st26)*I(VS_s_st26)+V(s_st27)*I(VS_s_st27)+V(s_st28)*I(VS_s_st28)+V(s_st29)*I(VS_s_st29)+V(s_st3)*I(VS_s_st3)+V(s_st30)*I(VS_s_st30)+V(s_st31)*I(VS_s_st31)+V(s_st32)*I(VS_s_st32)+V(s_st33)*I(VS_s_st33)+V(s_st34)*I(VS_s_st34)+V(s_st35)*I(VS_s_st35)+V(s_st36)*I(VS_s_st36)+V(s_st37)*I(VS_s_st37)+V(s_st38)*I(VS_s_st38)+V(s_st39)*I(VS_s_st39)+V(s_st4)*I(VS_s_st4)+V(s_st40)*I(VS_s_st40)+V(s_st41)*I(VS_s_st41)+V(s_st42)*I(VS_s_st42)+V(s_st43)*I(VS_s_st43)+V(s_st44)*I(VS_s_st44)+V(s_st45)*I(VS_s_st45)+V(s_st46)*I(VS_s_st46)+V(s_st47)*I(VS_s_st47)+V(s_st48)*I(VS_s_st48)+V(s_st49)*I(VS_s_st49)+V(s_st5)*I(VS_s_st5)+V(s_st50)*I(VS_s_st50)+V(s_st51)*I(VS_s_st51)+V(s_st52)*I(VS_s_st52)+V(s_st53)*I(VS_s_st53)+V(s_st54)*I(VS_s_st54)+V(s_st55)*I(VS_s_st55)+V(s_st56)*I(VS_s_st56)+V(s_st57)*I(VS_s_st57)+V(s_st58)*I(VS_s_st58)+V(s_st59)*I(VS_s_st59)+V(s_st6)*I(VS_s_st6)+V(s_st60)*I(VS_s_st60)+V(s_st61)*I(VS_s_st61)+V(s_st62)*I(VS_s_st62)+V(s_st63)*I(VS_s_st63)+V(s_st64)*I(VS_s_st64)+V(s_st65)*I(VS_s_st65)+V(s_st66)*I(VS_s_st66)+V(s_st67)*I(VS_s_st67)+V(s_st68)*I(VS_s_st68)+V(s_st69)*I(VS_s_st69)+V(s_st7)*I(VS_s_st7)+V(s_st70)*I(VS_s_st70)+V(s_st71)*I(VS_s_st71)+V(s_st72)*I(VS_s_st72)+V(s_st73)*I(VS_s_st73)+V(s_st74)*I(VS_s_st74)+V(s_st75)*I(VS_s_st75)+V(s_st76)*I(VS_s_st76)+V(s_st77)*I(VS_s_st77)+V(s_st78)*I(VS_s_st78)+V(s_st79)*I(VS_s_st79)+V(s_st8)*I(VS_s_st8)+V(s_st80)*I(VS_s_st80)+V(s_st81)*I(VS_s_st81)+V(s_st82)*I(VS_s_st82)+V(s_st83)*I(VS_s_st83)+V(s_st84)*I(VS_s_st84)+V(s_st85)*I(VS_s_st85)+V(s_st86)*I(VS_s_st86)+V(s_st87)*I(VS_s_st87)+V(s_st88)*I(VS_s_st88)+V(s_st89)*I(VS_s_st89)+V(s_st9)*I(VS_s_st9)+V(s_st90)*I(VS_s_st90)+V(s_st91)*I(VS_s_st91)+V(s_st92)*I(VS_s_st92)+V(s_st93)*I(VS_s_st93)+V(s_st94)*I(VS_s_st94)+V(s_st95)*I(VS_s_st95)+V(s_st96)*I(VS_s_st96)+V(s_st97)*I(VS_s_st97)+V(s_st98)*I(VS_s_st98)+V(s_st99)*I(VS_s_st99)) }
RXei1 xei1 0 0.01
CXegt xegt 0 1
BXegt 0 xegt I={ -V(gt1)*I(VGT1)-V(gtp1)*I(VGTP1)-V(pk1)*I(VPK1)-V(gt2)*I(VGT2)-V(gtp2)*I(VGTP2)-V(pk2)*I(VPK2)-V(gt3)*I(VGT3)-V(gtp3)*I(VGTP3)-V(pk3)*I(VPK3) }
RXegt xegt 0 0.01
CXehi xehi 0 1
BXehi 0 xehi I={ -1.5*I(VHI) }
RXehi xehi 0 0.01
.ic V(tnk1)=0.9075 V(rail1)=0 V(sw1)=0.9075 V(tnk2)=0.9075 V(rail2)=0 V(sw2)=0.9075 V(tnk3)=0.9075 V(rail3)=0 V(sw3)=0.9075
.tran 0.1p 7989.45p 0 1p
.measure tran QLT1_Z FIND V(xqlt1) AT=1.500000p
.measure tran QLT1_O1 FIND V(xqlt1) AT=586.843911p
.measure tran QLT1_B1 FIND V(xqlt1) AT=1351.000000p
.measure tran QLT1_R1 FIND V(xqlt1) AT=4799.000000p
.measure tran QLT1_Q1 FIND V(xqlt1) AT=5229.440253p
.measure tran QLT1_D FIND V(xqlt1) AT=7985.451953p
.measure tran EA1_Z FIND V(xea1) AT=1.500000p
.measure tran EA1_O1 FIND V(xea1) AT=586.843911p
.measure tran EA1_B1 FIND V(xea1) AT=1351.000000p
.measure tran EA1_R1 FIND V(xea1) AT=4799.000000p
.measure tran EA1_Q1 FIND V(xea1) AT=5229.440253p
.measure tran EA1_D FIND V(xea1) AT=7985.451953p
.measure tran EB1_Z FIND V(xeb1) AT=1.500000p
.measure tran EB1_O1 FIND V(xeb1) AT=586.843911p
.measure tran EB1_B1 FIND V(xeb1) AT=1351.000000p
.measure tran EB1_R1 FIND V(xeb1) AT=4799.000000p
.measure tran EB1_Q1 FIND V(xeb1) AT=5229.440253p
.measure tran EB1_D FIND V(xeb1) AT=7985.451953p
.measure tran ESW1_Z FIND V(xesw1) AT=1.500000p
.measure tran ESW1_O1 FIND V(xesw1) AT=586.843911p
.measure tran ESW1_B1 FIND V(xesw1) AT=1351.000000p
.measure tran ESW1_R1 FIND V(xesw1) AT=4799.000000p
.measure tran ESW1_Q1 FIND V(xesw1) AT=5229.440253p
.measure tran ESW1_D FIND V(xesw1) AT=7985.451953p
.measure tran ER1_Z FIND V(xer1) AT=1.500000p
.measure tran ER1_O1 FIND V(xer1) AT=586.843911p
.measure tran ER1_B1 FIND V(xer1) AT=1351.000000p
.measure tran ER1_R1 FIND V(xer1) AT=4799.000000p
.measure tran ER1_Q1 FIND V(xer1) AT=5229.440253p
.measure tran ER1_D FIND V(xer1) AT=7985.451953p
.measure tran QG1_Z FIND V(xqg1) AT=1.500000p
.measure tran QG1_O1 FIND V(xqg1) AT=586.843911p
.measure tran QG1_B1 FIND V(xqg1) AT=1351.000000p
.measure tran QG1_R1 FIND V(xqg1) AT=4799.000000p
.measure tran QG1_Q1 FIND V(xqg1) AT=5229.440253p
.measure tran QG1_D FIND V(xqg1) AT=7985.451953p
.measure tran QLT2_Z FIND V(xqlt2) AT=1.500000p
.measure tran QLT2_O2 FIND V(xqlt2) AT=2019.032418p
.measure tran QLT2_B2 FIND V(xqlt2) AT=2501.000000p
.measure tran QLT2_R2 FIND V(xqlt2) AT=5949.000000p
.measure tran QLT2_Q2 FIND V(xqlt2) AT=6683.156831p
.measure tran QLT2_D FIND V(xqlt2) AT=7985.451953p
.measure tran EA2_Z FIND V(xea2) AT=1.500000p
.measure tran EA2_O2 FIND V(xea2) AT=2019.032418p
.measure tran EA2_B2 FIND V(xea2) AT=2501.000000p
.measure tran EA2_R2 FIND V(xea2) AT=5949.000000p
.measure tran EA2_Q2 FIND V(xea2) AT=6683.156831p
.measure tran EA2_D FIND V(xea2) AT=7985.451953p
.measure tran EB2_Z FIND V(xeb2) AT=1.500000p
.measure tran EB2_O2 FIND V(xeb2) AT=2019.032418p
.measure tran EB2_B2 FIND V(xeb2) AT=2501.000000p
.measure tran EB2_R2 FIND V(xeb2) AT=5949.000000p
.measure tran EB2_Q2 FIND V(xeb2) AT=6683.156831p
.measure tran EB2_D FIND V(xeb2) AT=7985.451953p
.measure tran ESW2_Z FIND V(xesw2) AT=1.500000p
.measure tran ESW2_O2 FIND V(xesw2) AT=2019.032418p
.measure tran ESW2_B2 FIND V(xesw2) AT=2501.000000p
.measure tran ESW2_R2 FIND V(xesw2) AT=5949.000000p
.measure tran ESW2_Q2 FIND V(xesw2) AT=6683.156831p
.measure tran ESW2_D FIND V(xesw2) AT=7985.451953p
.measure tran ER2_Z FIND V(xer2) AT=1.500000p
.measure tran ER2_O2 FIND V(xer2) AT=2019.032418p
.measure tran ER2_B2 FIND V(xer2) AT=2501.000000p
.measure tran ER2_R2 FIND V(xer2) AT=5949.000000p
.measure tran ER2_Q2 FIND V(xer2) AT=6683.156831p
.measure tran ER2_D FIND V(xer2) AT=7985.451953p
.measure tran QG2_Z FIND V(xqg2) AT=1.500000p
.measure tran QG2_O2 FIND V(xqg2) AT=2019.032418p
.measure tran QG2_B2 FIND V(xqg2) AT=2501.000000p
.measure tran QG2_R2 FIND V(xqg2) AT=5949.000000p
.measure tran QG2_Q2 FIND V(xqg2) AT=6683.156831p
.measure tran QG2_D FIND V(xqg2) AT=7985.451953p
.measure tran QLT3_Z FIND V(xqlt3) AT=1.500000p
.measure tran QLT3_O3 FIND V(xqlt3) AT=2857.028251p
.measure tran QLT3_B3 FIND V(xqlt3) AT=3651.000000p
.measure tran QLT3_R3 FIND V(xqlt3) AT=7099.000000p
.measure tran QLT3_Q3 FIND V(xqlt3) AT=7490.451953p
.measure tran QLT3_D FIND V(xqlt3) AT=7985.451953p
.measure tran EA3_Z FIND V(xea3) AT=1.500000p
.measure tran EA3_O3 FIND V(xea3) AT=2857.028251p
.measure tran EA3_B3 FIND V(xea3) AT=3651.000000p
.measure tran EA3_R3 FIND V(xea3) AT=7099.000000p
.measure tran EA3_Q3 FIND V(xea3) AT=7490.451953p
.measure tran EA3_D FIND V(xea3) AT=7985.451953p
.measure tran EB3_Z FIND V(xeb3) AT=1.500000p
.measure tran EB3_O3 FIND V(xeb3) AT=2857.028251p
.measure tran EB3_B3 FIND V(xeb3) AT=3651.000000p
.measure tran EB3_R3 FIND V(xeb3) AT=7099.000000p
.measure tran EB3_Q3 FIND V(xeb3) AT=7490.451953p
.measure tran EB3_D FIND V(xeb3) AT=7985.451953p
.measure tran ESW3_Z FIND V(xesw3) AT=1.500000p
.measure tran ESW3_O3 FIND V(xesw3) AT=2857.028251p
.measure tran ESW3_B3 FIND V(xesw3) AT=3651.000000p
.measure tran ESW3_R3 FIND V(xesw3) AT=7099.000000p
.measure tran ESW3_Q3 FIND V(xesw3) AT=7490.451953p
.measure tran ESW3_D FIND V(xesw3) AT=7985.451953p
.measure tran ER3_Z FIND V(xer3) AT=1.500000p
.measure tran ER3_O3 FIND V(xer3) AT=2857.028251p
.measure tran ER3_B3 FIND V(xer3) AT=3651.000000p
.measure tran ER3_R3 FIND V(xer3) AT=7099.000000p
.measure tran ER3_Q3 FIND V(xer3) AT=7490.451953p
.measure tran ER3_D FIND V(xer3) AT=7985.451953p
.measure tran QG3_Z FIND V(xqg3) AT=1.500000p
.measure tran QG3_O3 FIND V(xqg3) AT=2857.028251p
.measure tran QG3_B3 FIND V(xqg3) AT=3651.000000p
.measure tran QG3_R3 FIND V(xqg3) AT=7099.000000p
.measure tran QG3_Q3 FIND V(xqg3) AT=7490.451953p
.measure tran QG3_D FIND V(xqg3) AT=7985.451953p
.measure tran QI1_Z FIND V(xqi1) AT=1.500000p
.measure tran QI1_O1 FIND V(xqi1) AT=586.843911p
.measure tran QI1_B1 FIND V(xqi1) AT=1351.000000p
.measure tran QI1_R1 FIND V(xqi1) AT=4799.000000p
.measure tran QI1_Q1 FIND V(xqi1) AT=5229.440253p
.measure tran QI1_D FIND V(xqi1) AT=7985.451953p
.measure tran EI1_Z FIND V(xei1) AT=1.500000p
.measure tran EI1_O1 FIND V(xei1) AT=586.843911p
.measure tran EI1_B1 FIND V(xei1) AT=1351.000000p
.measure tran EI1_R1 FIND V(xei1) AT=4799.000000p
.measure tran EI1_Q1 FIND V(xei1) AT=5229.440253p
.measure tran EI1_D FIND V(xei1) AT=7985.451953p
.measure tran EGT_Z FIND V(xegt) AT=1.500000p
.measure tran EGT_O1 FIND V(xegt) AT=586.843911p
.measure tran EGT_B1 FIND V(xegt) AT=1351.000000p
.measure tran EGT_R1 FIND V(xegt) AT=4799.000000p
.measure tran EGT_Q1 FIND V(xegt) AT=5229.440253p
.measure tran EGT_O2 FIND V(xegt) AT=2019.032418p
.measure tran EGT_B2 FIND V(xegt) AT=2501.000000p
.measure tran EGT_R2 FIND V(xegt) AT=5949.000000p
.measure tran EGT_Q2 FIND V(xegt) AT=6683.156831p
.measure tran EGT_O3 FIND V(xegt) AT=2857.028251p
.measure tran EGT_B3 FIND V(xegt) AT=3651.000000p
.measure tran EGT_R3 FIND V(xegt) AT=7099.000000p
.measure tran EGT_Q3 FIND V(xegt) AT=7490.451953p
.measure tran EGT_D FIND V(xegt) AT=7985.451953p
.measure tran EHI_Z FIND V(xehi) AT=1.500000p
.measure tran EHI_O1 FIND V(xehi) AT=586.843911p
.measure tran EHI_B1 FIND V(xehi) AT=1351.000000p
.measure tran EHI_R1 FIND V(xehi) AT=4799.000000p
.measure tran EHI_Q1 FIND V(xehi) AT=5229.440253p
.measure tran EHI_O2 FIND V(xehi) AT=2019.032418p
.measure tran EHI_B2 FIND V(xehi) AT=2501.000000p
.measure tran EHI_R2 FIND V(xehi) AT=5949.000000p
.measure tran EHI_Q2 FIND V(xehi) AT=6683.156831p
.measure tran EHI_O3 FIND V(xehi) AT=2857.028251p
.measure tran EHI_B3 FIND V(xehi) AT=3651.000000p
.measure tran EHI_R3 FIND V(xehi) AT=7099.000000p
.measure tran EHI_Q3 FIND V(xehi) AT=7490.451953p
.measure tran EHI_D FIND V(xehi) AT=7985.451953p
.measure tran VR1Z FIND V(rail1) AT=1.500000p
.measure tran VT1Z FIND V(tnk1) AT=1.500000p
.measure tran VR1O1 FIND V(rail1) AT=586.843911p
.measure tran VT1O1 FIND V(tnk1) AT=586.843911p
.measure tran VR1B1 FIND V(rail1) AT=1351.000000p
.measure tran VT1B1 FIND V(tnk1) AT=1351.000000p
.measure tran VR1R1 FIND V(rail1) AT=4799.000000p
.measure tran VT1R1 FIND V(tnk1) AT=4799.000000p
.measure tran VR1Q1 FIND V(rail1) AT=5229.440253p
.measure tran VT1Q1 FIND V(tnk1) AT=5229.440253p
.measure tran VR1O2 FIND V(rail1) AT=2019.032418p
.measure tran VT1O2 FIND V(tnk1) AT=2019.032418p
.measure tran VR1B2 FIND V(rail1) AT=2501.000000p
.measure tran VT1B2 FIND V(tnk1) AT=2501.000000p
.measure tran VR1R2 FIND V(rail1) AT=5949.000000p
.measure tran VT1R2 FIND V(tnk1) AT=5949.000000p
.measure tran VR1Q2 FIND V(rail1) AT=6683.156831p
.measure tran VT1Q2 FIND V(tnk1) AT=6683.156831p
.measure tran VR1O3 FIND V(rail1) AT=2857.028251p
.measure tran VT1O3 FIND V(tnk1) AT=2857.028251p
.measure tran VR1B3 FIND V(rail1) AT=3651.000000p
.measure tran VT1B3 FIND V(tnk1) AT=3651.000000p
.measure tran VR1R3 FIND V(rail1) AT=7099.000000p
.measure tran VT1R3 FIND V(tnk1) AT=7099.000000p
.measure tran VR1Q3 FIND V(rail1) AT=7490.451953p
.measure tran VT1Q3 FIND V(tnk1) AT=7490.451953p
.measure tran VR1D FIND V(rail1) AT=7985.451953p
.measure tran VT1D FIND V(tnk1) AT=7985.451953p
.measure tran VR1PK MAX V(rail1) FROM=200p TO=7989.45p
.measure tran IZ1 FIND I(L1) AT=586.843911p
.measure tran IZQ1 FIND I(L1) AT=5229.440253p
.measure tran IPK1 MAX I(L1) FROM=200p TO=7989.45p
.measure tran O1_0B FIND V(o1_0) AT=1351.000000p
.measure tran O1_0E FIND V(o1_0) AT=7985.451953p
.measure tran O1_0O FIND V(o1_0) AT=586.843911p
.measure tran O1_0Q FIND V(o1_0) AT=5229.440253p
.measure tran O1_1B FIND V(o1_1) AT=1351.000000p
.measure tran O1_1E FIND V(o1_1) AT=7985.451953p
.measure tran O1_1O FIND V(o1_1) AT=586.843911p
.measure tran O1_1Q FIND V(o1_1) AT=5229.440253p
.measure tran O1_2B FIND V(o1_2) AT=1351.000000p
.measure tran O1_2E FIND V(o1_2) AT=7985.451953p
.measure tran O1_2O FIND V(o1_2) AT=586.843911p
.measure tran O1_2Q FIND V(o1_2) AT=5229.440253p
.measure tran O1_3B FIND V(o1_3) AT=1351.000000p
.measure tran O1_3E FIND V(o1_3) AT=7985.451953p
.measure tran O1_3O FIND V(o1_3) AT=586.843911p
.measure tran O1_3Q FIND V(o1_3) AT=5229.440253p
.measure tran O1_4B FIND V(o1_4) AT=1351.000000p
.measure tran O1_4E FIND V(o1_4) AT=7985.451953p
.measure tran O1_4O FIND V(o1_4) AT=586.843911p
.measure tran O1_4Q FIND V(o1_4) AT=5229.440253p
.measure tran O1_5B FIND V(o1_5) AT=1351.000000p
.measure tran O1_5E FIND V(o1_5) AT=7985.451953p
.measure tran O1_5O FIND V(o1_5) AT=586.843911p
.measure tran O1_5Q FIND V(o1_5) AT=5229.440253p
.measure tran O1_6B FIND V(o1_6) AT=1351.000000p
.measure tran O1_6E FIND V(o1_6) AT=7985.451953p
.measure tran O1_6O FIND V(o1_6) AT=586.843911p
.measure tran O1_6Q FIND V(o1_6) AT=5229.440253p
.measure tran O1_7B FIND V(o1_7) AT=1351.000000p
.measure tran O1_7E FIND V(o1_7) AT=7985.451953p
.measure tran O1_7O FIND V(o1_7) AT=586.843911p
.measure tran O1_7Q FIND V(o1_7) AT=5229.440253p
.measure tran O1_8B FIND V(o1_8) AT=1351.000000p
.measure tran O1_8E FIND V(o1_8) AT=7985.451953p
.measure tran O1_8O FIND V(o1_8) AT=586.843911p
.measure tran O1_8Q FIND V(o1_8) AT=5229.440253p
.measure tran O1_9B FIND V(o1_9) AT=1351.000000p
.measure tran O1_9E FIND V(o1_9) AT=7985.451953p
.measure tran O1_9O FIND V(o1_9) AT=586.843911p
.measure tran O1_9Q FIND V(o1_9) AT=5229.440253p
.measure tran O1_10B FIND V(o1_10) AT=1351.000000p
.measure tran O1_10E FIND V(o1_10) AT=7985.451953p
.measure tran O1_10O FIND V(o1_10) AT=586.843911p
.measure tran O1_10Q FIND V(o1_10) AT=5229.440253p
.measure tran O1_11B FIND V(o1_11) AT=1351.000000p
.measure tran O1_11E FIND V(o1_11) AT=7985.451953p
.measure tran O1_11O FIND V(o1_11) AT=586.843911p
.measure tran O1_11Q FIND V(o1_11) AT=5229.440253p
.measure tran O1_12B FIND V(o1_12) AT=1351.000000p
.measure tran O1_12E FIND V(o1_12) AT=7985.451953p
.measure tran O1_12O FIND V(o1_12) AT=586.843911p
.measure tran O1_12Q FIND V(o1_12) AT=5229.440253p
.measure tran O1_13B FIND V(o1_13) AT=1351.000000p
.measure tran O1_13E FIND V(o1_13) AT=7985.451953p
.measure tran O1_13O FIND V(o1_13) AT=586.843911p
.measure tran O1_13Q FIND V(o1_13) AT=5229.440253p
.measure tran O1_14B FIND V(o1_14) AT=1351.000000p
.measure tran O1_14E FIND V(o1_14) AT=7985.451953p
.measure tran O1_14O FIND V(o1_14) AT=586.843911p
.measure tran O1_14Q FIND V(o1_14) AT=5229.440253p
.measure tran O1_15B FIND V(o1_15) AT=1351.000000p
.measure tran O1_15E FIND V(o1_15) AT=7985.451953p
.measure tran O1_15O FIND V(o1_15) AT=586.843911p
.measure tran O1_15Q FIND V(o1_15) AT=5229.440253p
.measure tran O1_16B FIND V(o1_16) AT=1351.000000p
.measure tran O1_16E FIND V(o1_16) AT=7985.451953p
.measure tran O1_16O FIND V(o1_16) AT=586.843911p
.measure tran O1_16Q FIND V(o1_16) AT=5229.440253p
.measure tran O1_17B FIND V(o1_17) AT=1351.000000p
.measure tran O1_17E FIND V(o1_17) AT=7985.451953p
.measure tran O1_17O FIND V(o1_17) AT=586.843911p
.measure tran O1_17Q FIND V(o1_17) AT=5229.440253p
.measure tran O1_18B FIND V(o1_18) AT=1351.000000p
.measure tran O1_18E FIND V(o1_18) AT=7985.451953p
.measure tran O1_18O FIND V(o1_18) AT=586.843911p
.measure tran O1_18Q FIND V(o1_18) AT=5229.440253p
.measure tran O1_19B FIND V(o1_19) AT=1351.000000p
.measure tran O1_19E FIND V(o1_19) AT=7985.451953p
.measure tran O1_19O FIND V(o1_19) AT=586.843911p
.measure tran O1_19Q FIND V(o1_19) AT=5229.440253p
.measure tran O1_20B FIND V(o1_20) AT=1351.000000p
.measure tran O1_20E FIND V(o1_20) AT=7985.451953p
.measure tran O1_20O FIND V(o1_20) AT=586.843911p
.measure tran O1_20Q FIND V(o1_20) AT=5229.440253p
.measure tran O1_21B FIND V(o1_21) AT=1351.000000p
.measure tran O1_21E FIND V(o1_21) AT=7985.451953p
.measure tran O1_21O FIND V(o1_21) AT=586.843911p
.measure tran O1_21Q FIND V(o1_21) AT=5229.440253p
.measure tran O1_22B FIND V(o1_22) AT=1351.000000p
.measure tran O1_22E FIND V(o1_22) AT=7985.451953p
.measure tran O1_22O FIND V(o1_22) AT=586.843911p
.measure tran O1_22Q FIND V(o1_22) AT=5229.440253p
.measure tran O1_23B FIND V(o1_23) AT=1351.000000p
.measure tran O1_23E FIND V(o1_23) AT=7985.451953p
.measure tran O1_23O FIND V(o1_23) AT=586.843911p
.measure tran O1_23Q FIND V(o1_23) AT=5229.440253p
.measure tran O1_24B FIND V(o1_24) AT=1351.000000p
.measure tran O1_24E FIND V(o1_24) AT=7985.451953p
.measure tran O1_24O FIND V(o1_24) AT=586.843911p
.measure tran O1_24Q FIND V(o1_24) AT=5229.440253p
.measure tran O1_25B FIND V(o1_25) AT=1351.000000p
.measure tran O1_25E FIND V(o1_25) AT=7985.451953p
.measure tran O1_25O FIND V(o1_25) AT=586.843911p
.measure tran O1_25Q FIND V(o1_25) AT=5229.440253p
.measure tran O1_26B FIND V(o1_26) AT=1351.000000p
.measure tran O1_26E FIND V(o1_26) AT=7985.451953p
.measure tran O1_26O FIND V(o1_26) AT=586.843911p
.measure tran O1_26Q FIND V(o1_26) AT=5229.440253p
.measure tran O1_27B FIND V(o1_27) AT=1351.000000p
.measure tran O1_27E FIND V(o1_27) AT=7985.451953p
.measure tran O1_27O FIND V(o1_27) AT=586.843911p
.measure tran O1_27Q FIND V(o1_27) AT=5229.440253p
.measure tran O1_28B FIND V(o1_28) AT=1351.000000p
.measure tran O1_28E FIND V(o1_28) AT=7985.451953p
.measure tran O1_28O FIND V(o1_28) AT=586.843911p
.measure tran O1_28Q FIND V(o1_28) AT=5229.440253p
.measure tran O1_29B FIND V(o1_29) AT=1351.000000p
.measure tran O1_29E FIND V(o1_29) AT=7985.451953p
.measure tran O1_29O FIND V(o1_29) AT=586.843911p
.measure tran O1_29Q FIND V(o1_29) AT=5229.440253p
.measure tran O1_30B FIND V(o1_30) AT=1351.000000p
.measure tran O1_30E FIND V(o1_30) AT=7985.451953p
.measure tran O1_30O FIND V(o1_30) AT=586.843911p
.measure tran O1_30Q FIND V(o1_30) AT=5229.440253p
.measure tran O1_31B FIND V(o1_31) AT=1351.000000p
.measure tran O1_31E FIND V(o1_31) AT=7985.451953p
.measure tran O1_31O FIND V(o1_31) AT=586.843911p
.measure tran O1_31Q FIND V(o1_31) AT=5229.440253p
.measure tran O1_32B FIND V(o1_32) AT=1351.000000p
.measure tran O1_32E FIND V(o1_32) AT=7985.451953p
.measure tran O1_32O FIND V(o1_32) AT=586.843911p
.measure tran O1_32Q FIND V(o1_32) AT=5229.440253p
.measure tran O1_33B FIND V(o1_33) AT=1351.000000p
.measure tran O1_33E FIND V(o1_33) AT=7985.451953p
.measure tran O1_33O FIND V(o1_33) AT=586.843911p
.measure tran O1_33Q FIND V(o1_33) AT=5229.440253p
.measure tran O1_34B FIND V(o1_34) AT=1351.000000p
.measure tran O1_34E FIND V(o1_34) AT=7985.451953p
.measure tran O1_34O FIND V(o1_34) AT=586.843911p
.measure tran O1_34Q FIND V(o1_34) AT=5229.440253p
.measure tran O1_35B FIND V(o1_35) AT=1351.000000p
.measure tran O1_35E FIND V(o1_35) AT=7985.451953p
.measure tran O1_35O FIND V(o1_35) AT=586.843911p
.measure tran O1_35Q FIND V(o1_35) AT=5229.440253p
.measure tran O1_36B FIND V(o1_36) AT=1351.000000p
.measure tran O1_36E FIND V(o1_36) AT=7985.451953p
.measure tran O1_36O FIND V(o1_36) AT=586.843911p
.measure tran O1_36Q FIND V(o1_36) AT=5229.440253p
.measure tran O1_37B FIND V(o1_37) AT=1351.000000p
.measure tran O1_37E FIND V(o1_37) AT=7985.451953p
.measure tran O1_37O FIND V(o1_37) AT=586.843911p
.measure tran O1_37Q FIND V(o1_37) AT=5229.440253p
.measure tran O1_38B FIND V(o1_38) AT=1351.000000p
.measure tran O1_38E FIND V(o1_38) AT=7985.451953p
.measure tran O1_38O FIND V(o1_38) AT=586.843911p
.measure tran O1_38Q FIND V(o1_38) AT=5229.440253p
.measure tran O1_39B FIND V(o1_39) AT=1351.000000p
.measure tran O1_39E FIND V(o1_39) AT=7985.451953p
.measure tran O1_39O FIND V(o1_39) AT=586.843911p
.measure tran O1_39Q FIND V(o1_39) AT=5229.440253p
.measure tran O1_40B FIND V(o1_40) AT=1351.000000p
.measure tran O1_40E FIND V(o1_40) AT=7985.451953p
.measure tran O1_40O FIND V(o1_40) AT=586.843911p
.measure tran O1_40Q FIND V(o1_40) AT=5229.440253p
.measure tran O1_41B FIND V(o1_41) AT=1351.000000p
.measure tran O1_41E FIND V(o1_41) AT=7985.451953p
.measure tran O1_41O FIND V(o1_41) AT=586.843911p
.measure tran O1_41Q FIND V(o1_41) AT=5229.440253p
.measure tran O1_42B FIND V(o1_42) AT=1351.000000p
.measure tran O1_42E FIND V(o1_42) AT=7985.451953p
.measure tran O1_42O FIND V(o1_42) AT=586.843911p
.measure tran O1_42Q FIND V(o1_42) AT=5229.440253p
.measure tran O1_43B FIND V(o1_43) AT=1351.000000p
.measure tran O1_43E FIND V(o1_43) AT=7985.451953p
.measure tran O1_43O FIND V(o1_43) AT=586.843911p
.measure tran O1_43Q FIND V(o1_43) AT=5229.440253p
.measure tran O1_44B FIND V(o1_44) AT=1351.000000p
.measure tran O1_44E FIND V(o1_44) AT=7985.451953p
.measure tran O1_44O FIND V(o1_44) AT=586.843911p
.measure tran O1_44Q FIND V(o1_44) AT=5229.440253p
.measure tran O1_45B FIND V(o1_45) AT=1351.000000p
.measure tran O1_45E FIND V(o1_45) AT=7985.451953p
.measure tran O1_45O FIND V(o1_45) AT=586.843911p
.measure tran O1_45Q FIND V(o1_45) AT=5229.440253p
.measure tran O1_46B FIND V(o1_46) AT=1351.000000p
.measure tran O1_46E FIND V(o1_46) AT=7985.451953p
.measure tran O1_46O FIND V(o1_46) AT=586.843911p
.measure tran O1_46Q FIND V(o1_46) AT=5229.440253p
.measure tran O1_47B FIND V(o1_47) AT=1351.000000p
.measure tran O1_47E FIND V(o1_47) AT=7985.451953p
.measure tran O1_47O FIND V(o1_47) AT=586.843911p
.measure tran O1_47Q FIND V(o1_47) AT=5229.440253p
.measure tran O1_48B FIND V(o1_48) AT=1351.000000p
.measure tran O1_48E FIND V(o1_48) AT=7985.451953p
.measure tran O1_48O FIND V(o1_48) AT=586.843911p
.measure tran O1_48Q FIND V(o1_48) AT=5229.440253p
.measure tran O1_49B FIND V(o1_49) AT=1351.000000p
.measure tran O1_49E FIND V(o1_49) AT=7985.451953p
.measure tran O1_49O FIND V(o1_49) AT=586.843911p
.measure tran O1_49Q FIND V(o1_49) AT=5229.440253p
.measure tran O1_50B FIND V(o1_50) AT=1351.000000p
.measure tran O1_50E FIND V(o1_50) AT=7985.451953p
.measure tran O1_50O FIND V(o1_50) AT=586.843911p
.measure tran O1_50Q FIND V(o1_50) AT=5229.440253p
.measure tran O1_51B FIND V(o1_51) AT=1351.000000p
.measure tran O1_51E FIND V(o1_51) AT=7985.451953p
.measure tran O1_51O FIND V(o1_51) AT=586.843911p
.measure tran O1_51Q FIND V(o1_51) AT=5229.440253p
.measure tran O1_52B FIND V(o1_52) AT=1351.000000p
.measure tran O1_52E FIND V(o1_52) AT=7985.451953p
.measure tran O1_52O FIND V(o1_52) AT=586.843911p
.measure tran O1_52Q FIND V(o1_52) AT=5229.440253p
.measure tran O1_53B FIND V(o1_53) AT=1351.000000p
.measure tran O1_53E FIND V(o1_53) AT=7985.451953p
.measure tran O1_53O FIND V(o1_53) AT=586.843911p
.measure tran O1_53Q FIND V(o1_53) AT=5229.440253p
.measure tran O1_54B FIND V(o1_54) AT=1351.000000p
.measure tran O1_54E FIND V(o1_54) AT=7985.451953p
.measure tran O1_54O FIND V(o1_54) AT=586.843911p
.measure tran O1_54Q FIND V(o1_54) AT=5229.440253p
.measure tran O1_55B FIND V(o1_55) AT=1351.000000p
.measure tran O1_55E FIND V(o1_55) AT=7985.451953p
.measure tran O1_55O FIND V(o1_55) AT=586.843911p
.measure tran O1_55Q FIND V(o1_55) AT=5229.440253p
.measure tran O1_56B FIND V(o1_56) AT=1351.000000p
.measure tran O1_56E FIND V(o1_56) AT=7985.451953p
.measure tran O1_56O FIND V(o1_56) AT=586.843911p
.measure tran O1_56Q FIND V(o1_56) AT=5229.440253p
.measure tran O1_57B FIND V(o1_57) AT=1351.000000p
.measure tran O1_57E FIND V(o1_57) AT=7985.451953p
.measure tran O1_57O FIND V(o1_57) AT=586.843911p
.measure tran O1_57Q FIND V(o1_57) AT=5229.440253p
.measure tran O1_58B FIND V(o1_58) AT=1351.000000p
.measure tran O1_58E FIND V(o1_58) AT=7985.451953p
.measure tran O1_58O FIND V(o1_58) AT=586.843911p
.measure tran O1_58Q FIND V(o1_58) AT=5229.440253p
.measure tran O1_59B FIND V(o1_59) AT=1351.000000p
.measure tran O1_59E FIND V(o1_59) AT=7985.451953p
.measure tran O1_59O FIND V(o1_59) AT=586.843911p
.measure tran O1_59Q FIND V(o1_59) AT=5229.440253p
.measure tran O1_60B FIND V(o1_60) AT=1351.000000p
.measure tran O1_60E FIND V(o1_60) AT=7985.451953p
.measure tran O1_60O FIND V(o1_60) AT=586.843911p
.measure tran O1_60Q FIND V(o1_60) AT=5229.440253p
.measure tran O1_61B FIND V(o1_61) AT=1351.000000p
.measure tran O1_61E FIND V(o1_61) AT=7985.451953p
.measure tran O1_61O FIND V(o1_61) AT=586.843911p
.measure tran O1_61Q FIND V(o1_61) AT=5229.440253p
.measure tran O1_62B FIND V(o1_62) AT=1351.000000p
.measure tran O1_62E FIND V(o1_62) AT=7985.451953p
.measure tran O1_62O FIND V(o1_62) AT=586.843911p
.measure tran O1_62Q FIND V(o1_62) AT=5229.440253p
.measure tran O1_63B FIND V(o1_63) AT=1351.000000p
.measure tran O1_63E FIND V(o1_63) AT=7985.451953p
.measure tran O1_63O FIND V(o1_63) AT=586.843911p
.measure tran O1_63Q FIND V(o1_63) AT=5229.440253p
.measure tran O1_64B FIND V(o1_64) AT=1351.000000p
.measure tran O1_64E FIND V(o1_64) AT=7985.451953p
.measure tran O1_64O FIND V(o1_64) AT=586.843911p
.measure tran O1_64Q FIND V(o1_64) AT=5229.440253p
.measure tran O1_65B FIND V(o1_65) AT=1351.000000p
.measure tran O1_65E FIND V(o1_65) AT=7985.451953p
.measure tran O1_65O FIND V(o1_65) AT=586.843911p
.measure tran O1_65Q FIND V(o1_65) AT=5229.440253p
.measure tran O1_66B FIND V(o1_66) AT=1351.000000p
.measure tran O1_66E FIND V(o1_66) AT=7985.451953p
.measure tran O1_66O FIND V(o1_66) AT=586.843911p
.measure tran O1_66Q FIND V(o1_66) AT=5229.440253p
.measure tran O1_67B FIND V(o1_67) AT=1351.000000p
.measure tran O1_67E FIND V(o1_67) AT=7985.451953p
.measure tran O1_67O FIND V(o1_67) AT=586.843911p
.measure tran O1_67Q FIND V(o1_67) AT=5229.440253p
.measure tran O1_68B FIND V(o1_68) AT=1351.000000p
.measure tran O1_68E FIND V(o1_68) AT=7985.451953p
.measure tran O1_68O FIND V(o1_68) AT=586.843911p
.measure tran O1_68Q FIND V(o1_68) AT=5229.440253p
.measure tran O1_69B FIND V(o1_69) AT=1351.000000p
.measure tran O1_69E FIND V(o1_69) AT=7985.451953p
.measure tran O1_69O FIND V(o1_69) AT=586.843911p
.measure tran O1_69Q FIND V(o1_69) AT=5229.440253p
.measure tran O1_70B FIND V(o1_70) AT=1351.000000p
.measure tran O1_70E FIND V(o1_70) AT=7985.451953p
.measure tran O1_70O FIND V(o1_70) AT=586.843911p
.measure tran O1_70Q FIND V(o1_70) AT=5229.440253p
.measure tran O1_71B FIND V(o1_71) AT=1351.000000p
.measure tran O1_71E FIND V(o1_71) AT=7985.451953p
.measure tran O1_71O FIND V(o1_71) AT=586.843911p
.measure tran O1_71Q FIND V(o1_71) AT=5229.440253p
.measure tran O1_72B FIND V(o1_72) AT=1351.000000p
.measure tran O1_72E FIND V(o1_72) AT=7985.451953p
.measure tran O1_72O FIND V(o1_72) AT=586.843911p
.measure tran O1_72Q FIND V(o1_72) AT=5229.440253p
.measure tran O1_73B FIND V(o1_73) AT=1351.000000p
.measure tran O1_73E FIND V(o1_73) AT=7985.451953p
.measure tran O1_73O FIND V(o1_73) AT=586.843911p
.measure tran O1_73Q FIND V(o1_73) AT=5229.440253p
.measure tran O1_74B FIND V(o1_74) AT=1351.000000p
.measure tran O1_74E FIND V(o1_74) AT=7985.451953p
.measure tran O1_74O FIND V(o1_74) AT=586.843911p
.measure tran O1_74Q FIND V(o1_74) AT=5229.440253p
.measure tran O1_75B FIND V(o1_75) AT=1351.000000p
.measure tran O1_75E FIND V(o1_75) AT=7985.451953p
.measure tran O1_75O FIND V(o1_75) AT=586.843911p
.measure tran O1_75Q FIND V(o1_75) AT=5229.440253p
.measure tran O1_76B FIND V(o1_76) AT=1351.000000p
.measure tran O1_76E FIND V(o1_76) AT=7985.451953p
.measure tran O1_76O FIND V(o1_76) AT=586.843911p
.measure tran O1_76Q FIND V(o1_76) AT=5229.440253p
.measure tran O1_77B FIND V(o1_77) AT=1351.000000p
.measure tran O1_77E FIND V(o1_77) AT=7985.451953p
.measure tran O1_77O FIND V(o1_77) AT=586.843911p
.measure tran O1_77Q FIND V(o1_77) AT=5229.440253p
.measure tran O1_78B FIND V(o1_78) AT=1351.000000p
.measure tran O1_78E FIND V(o1_78) AT=7985.451953p
.measure tran O1_78O FIND V(o1_78) AT=586.843911p
.measure tran O1_78Q FIND V(o1_78) AT=5229.440253p
.measure tran O1_79B FIND V(o1_79) AT=1351.000000p
.measure tran O1_79E FIND V(o1_79) AT=7985.451953p
.measure tran O1_79O FIND V(o1_79) AT=586.843911p
.measure tran O1_79Q FIND V(o1_79) AT=5229.440253p
.measure tran O1_80B FIND V(o1_80) AT=1351.000000p
.measure tran O1_80E FIND V(o1_80) AT=7985.451953p
.measure tran O1_80O FIND V(o1_80) AT=586.843911p
.measure tran O1_80Q FIND V(o1_80) AT=5229.440253p
.measure tran O1_81B FIND V(o1_81) AT=1351.000000p
.measure tran O1_81E FIND V(o1_81) AT=7985.451953p
.measure tran O1_81O FIND V(o1_81) AT=586.843911p
.measure tran O1_81Q FIND V(o1_81) AT=5229.440253p
.measure tran O1_82B FIND V(o1_82) AT=1351.000000p
.measure tran O1_82E FIND V(o1_82) AT=7985.451953p
.measure tran O1_82O FIND V(o1_82) AT=586.843911p
.measure tran O1_82Q FIND V(o1_82) AT=5229.440253p
.measure tran O1_83B FIND V(o1_83) AT=1351.000000p
.measure tran O1_83E FIND V(o1_83) AT=7985.451953p
.measure tran O1_83O FIND V(o1_83) AT=586.843911p
.measure tran O1_83Q FIND V(o1_83) AT=5229.440253p
.measure tran O1_84B FIND V(o1_84) AT=1351.000000p
.measure tran O1_84E FIND V(o1_84) AT=7985.451953p
.measure tran O1_84O FIND V(o1_84) AT=586.843911p
.measure tran O1_84Q FIND V(o1_84) AT=5229.440253p
.measure tran O1_85B FIND V(o1_85) AT=1351.000000p
.measure tran O1_85E FIND V(o1_85) AT=7985.451953p
.measure tran O1_85O FIND V(o1_85) AT=586.843911p
.measure tran O1_85Q FIND V(o1_85) AT=5229.440253p
.measure tran O1_86B FIND V(o1_86) AT=1351.000000p
.measure tran O1_86E FIND V(o1_86) AT=7985.451953p
.measure tran O1_86O FIND V(o1_86) AT=586.843911p
.measure tran O1_86Q FIND V(o1_86) AT=5229.440253p
.measure tran O1_87B FIND V(o1_87) AT=1351.000000p
.measure tran O1_87E FIND V(o1_87) AT=7985.451953p
.measure tran O1_87O FIND V(o1_87) AT=586.843911p
.measure tran O1_87Q FIND V(o1_87) AT=5229.440253p
.measure tran O1_88B FIND V(o1_88) AT=1351.000000p
.measure tran O1_88E FIND V(o1_88) AT=7985.451953p
.measure tran O1_88O FIND V(o1_88) AT=586.843911p
.measure tran O1_88Q FIND V(o1_88) AT=5229.440253p
.measure tran O1_89B FIND V(o1_89) AT=1351.000000p
.measure tran O1_89E FIND V(o1_89) AT=7985.451953p
.measure tran O1_89O FIND V(o1_89) AT=586.843911p
.measure tran O1_89Q FIND V(o1_89) AT=5229.440253p
.measure tran O1_90B FIND V(o1_90) AT=1351.000000p
.measure tran O1_90E FIND V(o1_90) AT=7985.451953p
.measure tran O1_90O FIND V(o1_90) AT=586.843911p
.measure tran O1_90Q FIND V(o1_90) AT=5229.440253p
.measure tran O1_91B FIND V(o1_91) AT=1351.000000p
.measure tran O1_91E FIND V(o1_91) AT=7985.451953p
.measure tran O1_91O FIND V(o1_91) AT=586.843911p
.measure tran O1_91Q FIND V(o1_91) AT=5229.440253p
.measure tran O1_92B FIND V(o1_92) AT=1351.000000p
.measure tran O1_92E FIND V(o1_92) AT=7985.451953p
.measure tran O1_92O FIND V(o1_92) AT=586.843911p
.measure tran O1_92Q FIND V(o1_92) AT=5229.440253p
.measure tran O1_93B FIND V(o1_93) AT=1351.000000p
.measure tran O1_93E FIND V(o1_93) AT=7985.451953p
.measure tran O1_93O FIND V(o1_93) AT=586.843911p
.measure tran O1_93Q FIND V(o1_93) AT=5229.440253p
.measure tran O1_94B FIND V(o1_94) AT=1351.000000p
.measure tran O1_94E FIND V(o1_94) AT=7985.451953p
.measure tran O1_94O FIND V(o1_94) AT=586.843911p
.measure tran O1_94Q FIND V(o1_94) AT=5229.440253p
.measure tran O1_95B FIND V(o1_95) AT=1351.000000p
.measure tran O1_95E FIND V(o1_95) AT=7985.451953p
.measure tran O1_95O FIND V(o1_95) AT=586.843911p
.measure tran O1_95Q FIND V(o1_95) AT=5229.440253p
.measure tran O1_96B FIND V(o1_96) AT=1351.000000p
.measure tran O1_96E FIND V(o1_96) AT=7985.451953p
.measure tran O1_96O FIND V(o1_96) AT=586.843911p
.measure tran O1_96Q FIND V(o1_96) AT=5229.440253p
.measure tran O1_97B FIND V(o1_97) AT=1351.000000p
.measure tran O1_97E FIND V(o1_97) AT=7985.451953p
.measure tran O1_97O FIND V(o1_97) AT=586.843911p
.measure tran O1_97Q FIND V(o1_97) AT=5229.440253p
.measure tran O1_98B FIND V(o1_98) AT=1351.000000p
.measure tran O1_98E FIND V(o1_98) AT=7985.451953p
.measure tran O1_98O FIND V(o1_98) AT=586.843911p
.measure tran O1_98Q FIND V(o1_98) AT=5229.440253p
.measure tran O1_99B FIND V(o1_99) AT=1351.000000p
.measure tran O1_99E FIND V(o1_99) AT=7985.451953p
.measure tran O1_99O FIND V(o1_99) AT=586.843911p
.measure tran O1_99Q FIND V(o1_99) AT=5229.440253p
.measure tran O1_100B FIND V(o1_100) AT=1351.000000p
.measure tran O1_100E FIND V(o1_100) AT=7985.451953p
.measure tran O1_100O FIND V(o1_100) AT=586.843911p
.measure tran O1_100Q FIND V(o1_100) AT=5229.440253p
.measure tran O1_101B FIND V(o1_101) AT=1351.000000p
.measure tran O1_101E FIND V(o1_101) AT=7985.451953p
.measure tran O1_101O FIND V(o1_101) AT=586.843911p
.measure tran O1_101Q FIND V(o1_101) AT=5229.440253p
.measure tran O1_102B FIND V(o1_102) AT=1351.000000p
.measure tran O1_102E FIND V(o1_102) AT=7985.451953p
.measure tran O1_102O FIND V(o1_102) AT=586.843911p
.measure tran O1_102Q FIND V(o1_102) AT=5229.440253p
.measure tran O1_103B FIND V(o1_103) AT=1351.000000p
.measure tran O1_103E FIND V(o1_103) AT=7985.451953p
.measure tran O1_103O FIND V(o1_103) AT=586.843911p
.measure tran O1_103Q FIND V(o1_103) AT=5229.440253p
.measure tran O1_104B FIND V(o1_104) AT=1351.000000p
.measure tran O1_104E FIND V(o1_104) AT=7985.451953p
.measure tran O1_104O FIND V(o1_104) AT=586.843911p
.measure tran O1_104Q FIND V(o1_104) AT=5229.440253p
.measure tran O1_105B FIND V(o1_105) AT=1351.000000p
.measure tran O1_105E FIND V(o1_105) AT=7985.451953p
.measure tran O1_105O FIND V(o1_105) AT=586.843911p
.measure tran O1_105Q FIND V(o1_105) AT=5229.440253p
.measure tran O1_106B FIND V(o1_106) AT=1351.000000p
.measure tran O1_106E FIND V(o1_106) AT=7985.451953p
.measure tran O1_106O FIND V(o1_106) AT=586.843911p
.measure tran O1_106Q FIND V(o1_106) AT=5229.440253p
.measure tran O1_107B FIND V(o1_107) AT=1351.000000p
.measure tran O1_107E FIND V(o1_107) AT=7985.451953p
.measure tran O1_107O FIND V(o1_107) AT=586.843911p
.measure tran O1_107Q FIND V(o1_107) AT=5229.440253p
.measure tran O1_108B FIND V(o1_108) AT=1351.000000p
.measure tran O1_108E FIND V(o1_108) AT=7985.451953p
.measure tran O1_108O FIND V(o1_108) AT=586.843911p
.measure tran O1_108Q FIND V(o1_108) AT=5229.440253p
.measure tran O1_109B FIND V(o1_109) AT=1351.000000p
.measure tran O1_109E FIND V(o1_109) AT=7985.451953p
.measure tran O1_109O FIND V(o1_109) AT=586.843911p
.measure tran O1_109Q FIND V(o1_109) AT=5229.440253p
.measure tran O1_110B FIND V(o1_110) AT=1351.000000p
.measure tran O1_110E FIND V(o1_110) AT=7985.451953p
.measure tran O1_110O FIND V(o1_110) AT=586.843911p
.measure tran O1_110Q FIND V(o1_110) AT=5229.440253p
.measure tran O1_111B FIND V(o1_111) AT=1351.000000p
.measure tran O1_111E FIND V(o1_111) AT=7985.451953p
.measure tran O1_111O FIND V(o1_111) AT=586.843911p
.measure tran O1_111Q FIND V(o1_111) AT=5229.440253p
.measure tran O1_112B FIND V(o1_112) AT=1351.000000p
.measure tran O1_112E FIND V(o1_112) AT=7985.451953p
.measure tran O1_112O FIND V(o1_112) AT=586.843911p
.measure tran O1_112Q FIND V(o1_112) AT=5229.440253p
.measure tran O1_113B FIND V(o1_113) AT=1351.000000p
.measure tran O1_113E FIND V(o1_113) AT=7985.451953p
.measure tran O1_113O FIND V(o1_113) AT=586.843911p
.measure tran O1_113Q FIND V(o1_113) AT=5229.440253p
.measure tran O1_114B FIND V(o1_114) AT=1351.000000p
.measure tran O1_114E FIND V(o1_114) AT=7985.451953p
.measure tran O1_114O FIND V(o1_114) AT=586.843911p
.measure tran O1_114Q FIND V(o1_114) AT=5229.440253p
.measure tran O1_115B FIND V(o1_115) AT=1351.000000p
.measure tran O1_115E FIND V(o1_115) AT=7985.451953p
.measure tran O1_115O FIND V(o1_115) AT=586.843911p
.measure tran O1_115Q FIND V(o1_115) AT=5229.440253p
.measure tran O1_116B FIND V(o1_116) AT=1351.000000p
.measure tran O1_116E FIND V(o1_116) AT=7985.451953p
.measure tran O1_116O FIND V(o1_116) AT=586.843911p
.measure tran O1_116Q FIND V(o1_116) AT=5229.440253p
.measure tran O1_117B FIND V(o1_117) AT=1351.000000p
.measure tran O1_117E FIND V(o1_117) AT=7985.451953p
.measure tran O1_117O FIND V(o1_117) AT=586.843911p
.measure tran O1_117Q FIND V(o1_117) AT=5229.440253p
.measure tran O1_118B FIND V(o1_118) AT=1351.000000p
.measure tran O1_118E FIND V(o1_118) AT=7985.451953p
.measure tran O1_118O FIND V(o1_118) AT=586.843911p
.measure tran O1_118Q FIND V(o1_118) AT=5229.440253p
.measure tran O1_119B FIND V(o1_119) AT=1351.000000p
.measure tran O1_119E FIND V(o1_119) AT=7985.451953p
.measure tran O1_119O FIND V(o1_119) AT=586.843911p
.measure tran O1_119Q FIND V(o1_119) AT=5229.440253p
.measure tran O1_120B FIND V(o1_120) AT=1351.000000p
.measure tran O1_120E FIND V(o1_120) AT=7985.451953p
.measure tran O1_120O FIND V(o1_120) AT=586.843911p
.measure tran O1_120Q FIND V(o1_120) AT=5229.440253p
.measure tran O1_121B FIND V(o1_121) AT=1351.000000p
.measure tran O1_121E FIND V(o1_121) AT=7985.451953p
.measure tran O1_121O FIND V(o1_121) AT=586.843911p
.measure tran O1_121Q FIND V(o1_121) AT=5229.440253p
.measure tran O1_122B FIND V(o1_122) AT=1351.000000p
.measure tran O1_122E FIND V(o1_122) AT=7985.451953p
.measure tran O1_122O FIND V(o1_122) AT=586.843911p
.measure tran O1_122Q FIND V(o1_122) AT=5229.440253p
.measure tran O1_123B FIND V(o1_123) AT=1351.000000p
.measure tran O1_123E FIND V(o1_123) AT=7985.451953p
.measure tran O1_123O FIND V(o1_123) AT=586.843911p
.measure tran O1_123Q FIND V(o1_123) AT=5229.440253p
.measure tran O1_124B FIND V(o1_124) AT=1351.000000p
.measure tran O1_124E FIND V(o1_124) AT=7985.451953p
.measure tran O1_124O FIND V(o1_124) AT=586.843911p
.measure tran O1_124Q FIND V(o1_124) AT=5229.440253p
.measure tran O1_125B FIND V(o1_125) AT=1351.000000p
.measure tran O1_125E FIND V(o1_125) AT=7985.451953p
.measure tran O1_125O FIND V(o1_125) AT=586.843911p
.measure tran O1_125Q FIND V(o1_125) AT=5229.440253p
.measure tran O1_126B FIND V(o1_126) AT=1351.000000p
.measure tran O1_126E FIND V(o1_126) AT=7985.451953p
.measure tran O1_126O FIND V(o1_126) AT=586.843911p
.measure tran O1_126Q FIND V(o1_126) AT=5229.440253p
.measure tran O1_127B FIND V(o1_127) AT=1351.000000p
.measure tran O1_127E FIND V(o1_127) AT=7985.451953p
.measure tran O1_127O FIND V(o1_127) AT=586.843911p
.measure tran O1_127Q FIND V(o1_127) AT=5229.440253p
.measure tran VR2Z FIND V(rail2) AT=1.500000p
.measure tran VT2Z FIND V(tnk2) AT=1.500000p
.measure tran VR2O1 FIND V(rail2) AT=586.843911p
.measure tran VT2O1 FIND V(tnk2) AT=586.843911p
.measure tran VR2B1 FIND V(rail2) AT=1351.000000p
.measure tran VT2B1 FIND V(tnk2) AT=1351.000000p
.measure tran VR2R1 FIND V(rail2) AT=4799.000000p
.measure tran VT2R1 FIND V(tnk2) AT=4799.000000p
.measure tran VR2Q1 FIND V(rail2) AT=5229.440253p
.measure tran VT2Q1 FIND V(tnk2) AT=5229.440253p
.measure tran VR2O2 FIND V(rail2) AT=2019.032418p
.measure tran VT2O2 FIND V(tnk2) AT=2019.032418p
.measure tran VR2B2 FIND V(rail2) AT=2501.000000p
.measure tran VT2B2 FIND V(tnk2) AT=2501.000000p
.measure tran VR2R2 FIND V(rail2) AT=5949.000000p
.measure tran VT2R2 FIND V(tnk2) AT=5949.000000p
.measure tran VR2Q2 FIND V(rail2) AT=6683.156831p
.measure tran VT2Q2 FIND V(tnk2) AT=6683.156831p
.measure tran VR2O3 FIND V(rail2) AT=2857.028251p
.measure tran VT2O3 FIND V(tnk2) AT=2857.028251p
.measure tran VR2B3 FIND V(rail2) AT=3651.000000p
.measure tran VT2B3 FIND V(tnk2) AT=3651.000000p
.measure tran VR2R3 FIND V(rail2) AT=7099.000000p
.measure tran VT2R3 FIND V(tnk2) AT=7099.000000p
.measure tran VR2Q3 FIND V(rail2) AT=7490.451953p
.measure tran VT2Q3 FIND V(tnk2) AT=7490.451953p
.measure tran VR2D FIND V(rail2) AT=7985.451953p
.measure tran VT2D FIND V(tnk2) AT=7985.451953p
.measure tran VR2PK MAX V(rail2) FROM=1350p TO=7989.45p
.measure tran IZ2 FIND I(L2) AT=2019.032418p
.measure tran IZQ2 FIND I(L2) AT=6683.156831p
.measure tran IPK2 MAX I(L2) FROM=1350p TO=7989.45p
.measure tran O2_0B FIND V(o2_0) AT=2501.000000p
.measure tran O2_0E FIND V(o2_0) AT=7985.451953p
.measure tran O2_0O FIND V(o2_0) AT=2019.032418p
.measure tran O2_0Q FIND V(o2_0) AT=6683.156831p
.measure tran O2_1B FIND V(o2_1) AT=2501.000000p
.measure tran O2_1E FIND V(o2_1) AT=7985.451953p
.measure tran O2_1O FIND V(o2_1) AT=2019.032418p
.measure tran O2_1Q FIND V(o2_1) AT=6683.156831p
.measure tran O2_2B FIND V(o2_2) AT=2501.000000p
.measure tran O2_2E FIND V(o2_2) AT=7985.451953p
.measure tran O2_2O FIND V(o2_2) AT=2019.032418p
.measure tran O2_2Q FIND V(o2_2) AT=6683.156831p
.measure tran O2_3B FIND V(o2_3) AT=2501.000000p
.measure tran O2_3E FIND V(o2_3) AT=7985.451953p
.measure tran O2_3O FIND V(o2_3) AT=2019.032418p
.measure tran O2_3Q FIND V(o2_3) AT=6683.156831p
.measure tran O2_4B FIND V(o2_4) AT=2501.000000p
.measure tran O2_4E FIND V(o2_4) AT=7985.451953p
.measure tran O2_4O FIND V(o2_4) AT=2019.032418p
.measure tran O2_4Q FIND V(o2_4) AT=6683.156831p
.measure tran O2_5B FIND V(o2_5) AT=2501.000000p
.measure tran O2_5E FIND V(o2_5) AT=7985.451953p
.measure tran O2_5O FIND V(o2_5) AT=2019.032418p
.measure tran O2_5Q FIND V(o2_5) AT=6683.156831p
.measure tran O2_6B FIND V(o2_6) AT=2501.000000p
.measure tran O2_6E FIND V(o2_6) AT=7985.451953p
.measure tran O2_6O FIND V(o2_6) AT=2019.032418p
.measure tran O2_6Q FIND V(o2_6) AT=6683.156831p
.measure tran O2_7B FIND V(o2_7) AT=2501.000000p
.measure tran O2_7E FIND V(o2_7) AT=7985.451953p
.measure tran O2_7O FIND V(o2_7) AT=2019.032418p
.measure tran O2_7Q FIND V(o2_7) AT=6683.156831p
.measure tran O2_8B FIND V(o2_8) AT=2501.000000p
.measure tran O2_8E FIND V(o2_8) AT=7985.451953p
.measure tran O2_8O FIND V(o2_8) AT=2019.032418p
.measure tran O2_8Q FIND V(o2_8) AT=6683.156831p
.measure tran O2_9B FIND V(o2_9) AT=2501.000000p
.measure tran O2_9E FIND V(o2_9) AT=7985.451953p
.measure tran O2_9O FIND V(o2_9) AT=2019.032418p
.measure tran O2_9Q FIND V(o2_9) AT=6683.156831p
.measure tran O2_10B FIND V(o2_10) AT=2501.000000p
.measure tran O2_10E FIND V(o2_10) AT=7985.451953p
.measure tran O2_10O FIND V(o2_10) AT=2019.032418p
.measure tran O2_10Q FIND V(o2_10) AT=6683.156831p
.measure tran O2_11B FIND V(o2_11) AT=2501.000000p
.measure tran O2_11E FIND V(o2_11) AT=7985.451953p
.measure tran O2_11O FIND V(o2_11) AT=2019.032418p
.measure tran O2_11Q FIND V(o2_11) AT=6683.156831p
.measure tran O2_12B FIND V(o2_12) AT=2501.000000p
.measure tran O2_12E FIND V(o2_12) AT=7985.451953p
.measure tran O2_12O FIND V(o2_12) AT=2019.032418p
.measure tran O2_12Q FIND V(o2_12) AT=6683.156831p
.measure tran O2_13B FIND V(o2_13) AT=2501.000000p
.measure tran O2_13E FIND V(o2_13) AT=7985.451953p
.measure tran O2_13O FIND V(o2_13) AT=2019.032418p
.measure tran O2_13Q FIND V(o2_13) AT=6683.156831p
.measure tran O2_14B FIND V(o2_14) AT=2501.000000p
.measure tran O2_14E FIND V(o2_14) AT=7985.451953p
.measure tran O2_14O FIND V(o2_14) AT=2019.032418p
.measure tran O2_14Q FIND V(o2_14) AT=6683.156831p
.measure tran O2_15B FIND V(o2_15) AT=2501.000000p
.measure tran O2_15E FIND V(o2_15) AT=7985.451953p
.measure tran O2_15O FIND V(o2_15) AT=2019.032418p
.measure tran O2_15Q FIND V(o2_15) AT=6683.156831p
.measure tran O2_16B FIND V(o2_16) AT=2501.000000p
.measure tran O2_16E FIND V(o2_16) AT=7985.451953p
.measure tran O2_16O FIND V(o2_16) AT=2019.032418p
.measure tran O2_16Q FIND V(o2_16) AT=6683.156831p
.measure tran O2_17B FIND V(o2_17) AT=2501.000000p
.measure tran O2_17E FIND V(o2_17) AT=7985.451953p
.measure tran O2_17O FIND V(o2_17) AT=2019.032418p
.measure tran O2_17Q FIND V(o2_17) AT=6683.156831p
.measure tran O2_18B FIND V(o2_18) AT=2501.000000p
.measure tran O2_18E FIND V(o2_18) AT=7985.451953p
.measure tran O2_18O FIND V(o2_18) AT=2019.032418p
.measure tran O2_18Q FIND V(o2_18) AT=6683.156831p
.measure tran O2_19B FIND V(o2_19) AT=2501.000000p
.measure tran O2_19E FIND V(o2_19) AT=7985.451953p
.measure tran O2_19O FIND V(o2_19) AT=2019.032418p
.measure tran O2_19Q FIND V(o2_19) AT=6683.156831p
.measure tran O2_20B FIND V(o2_20) AT=2501.000000p
.measure tran O2_20E FIND V(o2_20) AT=7985.451953p
.measure tran O2_20O FIND V(o2_20) AT=2019.032418p
.measure tran O2_20Q FIND V(o2_20) AT=6683.156831p
.measure tran O2_21B FIND V(o2_21) AT=2501.000000p
.measure tran O2_21E FIND V(o2_21) AT=7985.451953p
.measure tran O2_21O FIND V(o2_21) AT=2019.032418p
.measure tran O2_21Q FIND V(o2_21) AT=6683.156831p
.measure tran O2_22B FIND V(o2_22) AT=2501.000000p
.measure tran O2_22E FIND V(o2_22) AT=7985.451953p
.measure tran O2_22O FIND V(o2_22) AT=2019.032418p
.measure tran O2_22Q FIND V(o2_22) AT=6683.156831p
.measure tran O2_23B FIND V(o2_23) AT=2501.000000p
.measure tran O2_23E FIND V(o2_23) AT=7985.451953p
.measure tran O2_23O FIND V(o2_23) AT=2019.032418p
.measure tran O2_23Q FIND V(o2_23) AT=6683.156831p
.measure tran O2_24B FIND V(o2_24) AT=2501.000000p
.measure tran O2_24E FIND V(o2_24) AT=7985.451953p
.measure tran O2_24O FIND V(o2_24) AT=2019.032418p
.measure tran O2_24Q FIND V(o2_24) AT=6683.156831p
.measure tran O2_25B FIND V(o2_25) AT=2501.000000p
.measure tran O2_25E FIND V(o2_25) AT=7985.451953p
.measure tran O2_25O FIND V(o2_25) AT=2019.032418p
.measure tran O2_25Q FIND V(o2_25) AT=6683.156831p
.measure tran O2_26B FIND V(o2_26) AT=2501.000000p
.measure tran O2_26E FIND V(o2_26) AT=7985.451953p
.measure tran O2_26O FIND V(o2_26) AT=2019.032418p
.measure tran O2_26Q FIND V(o2_26) AT=6683.156831p
.measure tran O2_27B FIND V(o2_27) AT=2501.000000p
.measure tran O2_27E FIND V(o2_27) AT=7985.451953p
.measure tran O2_27O FIND V(o2_27) AT=2019.032418p
.measure tran O2_27Q FIND V(o2_27) AT=6683.156831p
.measure tran O2_28B FIND V(o2_28) AT=2501.000000p
.measure tran O2_28E FIND V(o2_28) AT=7985.451953p
.measure tran O2_28O FIND V(o2_28) AT=2019.032418p
.measure tran O2_28Q FIND V(o2_28) AT=6683.156831p
.measure tran O2_29B FIND V(o2_29) AT=2501.000000p
.measure tran O2_29E FIND V(o2_29) AT=7985.451953p
.measure tran O2_29O FIND V(o2_29) AT=2019.032418p
.measure tran O2_29Q FIND V(o2_29) AT=6683.156831p
.measure tran O2_30B FIND V(o2_30) AT=2501.000000p
.measure tran O2_30E FIND V(o2_30) AT=7985.451953p
.measure tran O2_30O FIND V(o2_30) AT=2019.032418p
.measure tran O2_30Q FIND V(o2_30) AT=6683.156831p
.measure tran O2_31B FIND V(o2_31) AT=2501.000000p
.measure tran O2_31E FIND V(o2_31) AT=7985.451953p
.measure tran O2_31O FIND V(o2_31) AT=2019.032418p
.measure tran O2_31Q FIND V(o2_31) AT=6683.156831p
.measure tran O2_32B FIND V(o2_32) AT=2501.000000p
.measure tran O2_32E FIND V(o2_32) AT=7985.451953p
.measure tran O2_32O FIND V(o2_32) AT=2019.032418p
.measure tran O2_32Q FIND V(o2_32) AT=6683.156831p
.measure tran O2_33B FIND V(o2_33) AT=2501.000000p
.measure tran O2_33E FIND V(o2_33) AT=7985.451953p
.measure tran O2_33O FIND V(o2_33) AT=2019.032418p
.measure tran O2_33Q FIND V(o2_33) AT=6683.156831p
.measure tran O2_34B FIND V(o2_34) AT=2501.000000p
.measure tran O2_34E FIND V(o2_34) AT=7985.451953p
.measure tran O2_34O FIND V(o2_34) AT=2019.032418p
.measure tran O2_34Q FIND V(o2_34) AT=6683.156831p
.measure tran O2_35B FIND V(o2_35) AT=2501.000000p
.measure tran O2_35E FIND V(o2_35) AT=7985.451953p
.measure tran O2_35O FIND V(o2_35) AT=2019.032418p
.measure tran O2_35Q FIND V(o2_35) AT=6683.156831p
.measure tran O2_36B FIND V(o2_36) AT=2501.000000p
.measure tran O2_36E FIND V(o2_36) AT=7985.451953p
.measure tran O2_36O FIND V(o2_36) AT=2019.032418p
.measure tran O2_36Q FIND V(o2_36) AT=6683.156831p
.measure tran O2_37B FIND V(o2_37) AT=2501.000000p
.measure tran O2_37E FIND V(o2_37) AT=7985.451953p
.measure tran O2_37O FIND V(o2_37) AT=2019.032418p
.measure tran O2_37Q FIND V(o2_37) AT=6683.156831p
.measure tran O2_38B FIND V(o2_38) AT=2501.000000p
.measure tran O2_38E FIND V(o2_38) AT=7985.451953p
.measure tran O2_38O FIND V(o2_38) AT=2019.032418p
.measure tran O2_38Q FIND V(o2_38) AT=6683.156831p
.measure tran O2_39B FIND V(o2_39) AT=2501.000000p
.measure tran O2_39E FIND V(o2_39) AT=7985.451953p
.measure tran O2_39O FIND V(o2_39) AT=2019.032418p
.measure tran O2_39Q FIND V(o2_39) AT=6683.156831p
.measure tran O2_40B FIND V(o2_40) AT=2501.000000p
.measure tran O2_40E FIND V(o2_40) AT=7985.451953p
.measure tran O2_40O FIND V(o2_40) AT=2019.032418p
.measure tran O2_40Q FIND V(o2_40) AT=6683.156831p
.measure tran O2_41B FIND V(o2_41) AT=2501.000000p
.measure tran O2_41E FIND V(o2_41) AT=7985.451953p
.measure tran O2_41O FIND V(o2_41) AT=2019.032418p
.measure tran O2_41Q FIND V(o2_41) AT=6683.156831p
.measure tran O2_42B FIND V(o2_42) AT=2501.000000p
.measure tran O2_42E FIND V(o2_42) AT=7985.451953p
.measure tran O2_42O FIND V(o2_42) AT=2019.032418p
.measure tran O2_42Q FIND V(o2_42) AT=6683.156831p
.measure tran O2_43B FIND V(o2_43) AT=2501.000000p
.measure tran O2_43E FIND V(o2_43) AT=7985.451953p
.measure tran O2_43O FIND V(o2_43) AT=2019.032418p
.measure tran O2_43Q FIND V(o2_43) AT=6683.156831p
.measure tran O2_44B FIND V(o2_44) AT=2501.000000p
.measure tran O2_44E FIND V(o2_44) AT=7985.451953p
.measure tran O2_44O FIND V(o2_44) AT=2019.032418p
.measure tran O2_44Q FIND V(o2_44) AT=6683.156831p
.measure tran O2_45B FIND V(o2_45) AT=2501.000000p
.measure tran O2_45E FIND V(o2_45) AT=7985.451953p
.measure tran O2_45O FIND V(o2_45) AT=2019.032418p
.measure tran O2_45Q FIND V(o2_45) AT=6683.156831p
.measure tran O2_46B FIND V(o2_46) AT=2501.000000p
.measure tran O2_46E FIND V(o2_46) AT=7985.451953p
.measure tran O2_46O FIND V(o2_46) AT=2019.032418p
.measure tran O2_46Q FIND V(o2_46) AT=6683.156831p
.measure tran O2_47B FIND V(o2_47) AT=2501.000000p
.measure tran O2_47E FIND V(o2_47) AT=7985.451953p
.measure tran O2_47O FIND V(o2_47) AT=2019.032418p
.measure tran O2_47Q FIND V(o2_47) AT=6683.156831p
.measure tran O2_48B FIND V(o2_48) AT=2501.000000p
.measure tran O2_48E FIND V(o2_48) AT=7985.451953p
.measure tran O2_48O FIND V(o2_48) AT=2019.032418p
.measure tran O2_48Q FIND V(o2_48) AT=6683.156831p
.measure tran O2_49B FIND V(o2_49) AT=2501.000000p
.measure tran O2_49E FIND V(o2_49) AT=7985.451953p
.measure tran O2_49O FIND V(o2_49) AT=2019.032418p
.measure tran O2_49Q FIND V(o2_49) AT=6683.156831p
.measure tran O2_50B FIND V(o2_50) AT=2501.000000p
.measure tran O2_50E FIND V(o2_50) AT=7985.451953p
.measure tran O2_50O FIND V(o2_50) AT=2019.032418p
.measure tran O2_50Q FIND V(o2_50) AT=6683.156831p
.measure tran O2_51B FIND V(o2_51) AT=2501.000000p
.measure tran O2_51E FIND V(o2_51) AT=7985.451953p
.measure tran O2_51O FIND V(o2_51) AT=2019.032418p
.measure tran O2_51Q FIND V(o2_51) AT=6683.156831p
.measure tran O2_52B FIND V(o2_52) AT=2501.000000p
.measure tran O2_52E FIND V(o2_52) AT=7985.451953p
.measure tran O2_52O FIND V(o2_52) AT=2019.032418p
.measure tran O2_52Q FIND V(o2_52) AT=6683.156831p
.measure tran O2_53B FIND V(o2_53) AT=2501.000000p
.measure tran O2_53E FIND V(o2_53) AT=7985.451953p
.measure tran O2_53O FIND V(o2_53) AT=2019.032418p
.measure tran O2_53Q FIND V(o2_53) AT=6683.156831p
.measure tran O2_54B FIND V(o2_54) AT=2501.000000p
.measure tran O2_54E FIND V(o2_54) AT=7985.451953p
.measure tran O2_54O FIND V(o2_54) AT=2019.032418p
.measure tran O2_54Q FIND V(o2_54) AT=6683.156831p
.measure tran O2_55B FIND V(o2_55) AT=2501.000000p
.measure tran O2_55E FIND V(o2_55) AT=7985.451953p
.measure tran O2_55O FIND V(o2_55) AT=2019.032418p
.measure tran O2_55Q FIND V(o2_55) AT=6683.156831p
.measure tran O2_56B FIND V(o2_56) AT=2501.000000p
.measure tran O2_56E FIND V(o2_56) AT=7985.451953p
.measure tran O2_56O FIND V(o2_56) AT=2019.032418p
.measure tran O2_56Q FIND V(o2_56) AT=6683.156831p
.measure tran O2_57B FIND V(o2_57) AT=2501.000000p
.measure tran O2_57E FIND V(o2_57) AT=7985.451953p
.measure tran O2_57O FIND V(o2_57) AT=2019.032418p
.measure tran O2_57Q FIND V(o2_57) AT=6683.156831p
.measure tran O2_58B FIND V(o2_58) AT=2501.000000p
.measure tran O2_58E FIND V(o2_58) AT=7985.451953p
.measure tran O2_58O FIND V(o2_58) AT=2019.032418p
.measure tran O2_58Q FIND V(o2_58) AT=6683.156831p
.measure tran O2_59B FIND V(o2_59) AT=2501.000000p
.measure tran O2_59E FIND V(o2_59) AT=7985.451953p
.measure tran O2_59O FIND V(o2_59) AT=2019.032418p
.measure tran O2_59Q FIND V(o2_59) AT=6683.156831p
.measure tran O2_60B FIND V(o2_60) AT=2501.000000p
.measure tran O2_60E FIND V(o2_60) AT=7985.451953p
.measure tran O2_60O FIND V(o2_60) AT=2019.032418p
.measure tran O2_60Q FIND V(o2_60) AT=6683.156831p
.measure tran O2_61B FIND V(o2_61) AT=2501.000000p
.measure tran O2_61E FIND V(o2_61) AT=7985.451953p
.measure tran O2_61O FIND V(o2_61) AT=2019.032418p
.measure tran O2_61Q FIND V(o2_61) AT=6683.156831p
.measure tran O2_62B FIND V(o2_62) AT=2501.000000p
.measure tran O2_62E FIND V(o2_62) AT=7985.451953p
.measure tran O2_62O FIND V(o2_62) AT=2019.032418p
.measure tran O2_62Q FIND V(o2_62) AT=6683.156831p
.measure tran O2_63B FIND V(o2_63) AT=2501.000000p
.measure tran O2_63E FIND V(o2_63) AT=7985.451953p
.measure tran O2_63O FIND V(o2_63) AT=2019.032418p
.measure tran O2_63Q FIND V(o2_63) AT=6683.156831p
.measure tran O2_64B FIND V(o2_64) AT=2501.000000p
.measure tran O2_64E FIND V(o2_64) AT=7985.451953p
.measure tran O2_64O FIND V(o2_64) AT=2019.032418p
.measure tran O2_64Q FIND V(o2_64) AT=6683.156831p
.measure tran O2_65B FIND V(o2_65) AT=2501.000000p
.measure tran O2_65E FIND V(o2_65) AT=7985.451953p
.measure tran O2_65O FIND V(o2_65) AT=2019.032418p
.measure tran O2_65Q FIND V(o2_65) AT=6683.156831p
.measure tran O2_66B FIND V(o2_66) AT=2501.000000p
.measure tran O2_66E FIND V(o2_66) AT=7985.451953p
.measure tran O2_66O FIND V(o2_66) AT=2019.032418p
.measure tran O2_66Q FIND V(o2_66) AT=6683.156831p
.measure tran O2_67B FIND V(o2_67) AT=2501.000000p
.measure tran O2_67E FIND V(o2_67) AT=7985.451953p
.measure tran O2_67O FIND V(o2_67) AT=2019.032418p
.measure tran O2_67Q FIND V(o2_67) AT=6683.156831p
.measure tran O2_68B FIND V(o2_68) AT=2501.000000p
.measure tran O2_68E FIND V(o2_68) AT=7985.451953p
.measure tran O2_68O FIND V(o2_68) AT=2019.032418p
.measure tran O2_68Q FIND V(o2_68) AT=6683.156831p
.measure tran O2_69B FIND V(o2_69) AT=2501.000000p
.measure tran O2_69E FIND V(o2_69) AT=7985.451953p
.measure tran O2_69O FIND V(o2_69) AT=2019.032418p
.measure tran O2_69Q FIND V(o2_69) AT=6683.156831p
.measure tran O2_70B FIND V(o2_70) AT=2501.000000p
.measure tran O2_70E FIND V(o2_70) AT=7985.451953p
.measure tran O2_70O FIND V(o2_70) AT=2019.032418p
.measure tran O2_70Q FIND V(o2_70) AT=6683.156831p
.measure tran O2_71B FIND V(o2_71) AT=2501.000000p
.measure tran O2_71E FIND V(o2_71) AT=7985.451953p
.measure tran O2_71O FIND V(o2_71) AT=2019.032418p
.measure tran O2_71Q FIND V(o2_71) AT=6683.156831p
.measure tran O2_72B FIND V(o2_72) AT=2501.000000p
.measure tran O2_72E FIND V(o2_72) AT=7985.451953p
.measure tran O2_72O FIND V(o2_72) AT=2019.032418p
.measure tran O2_72Q FIND V(o2_72) AT=6683.156831p
.measure tran O2_73B FIND V(o2_73) AT=2501.000000p
.measure tran O2_73E FIND V(o2_73) AT=7985.451953p
.measure tran O2_73O FIND V(o2_73) AT=2019.032418p
.measure tran O2_73Q FIND V(o2_73) AT=6683.156831p
.measure tran O2_74B FIND V(o2_74) AT=2501.000000p
.measure tran O2_74E FIND V(o2_74) AT=7985.451953p
.measure tran O2_74O FIND V(o2_74) AT=2019.032418p
.measure tran O2_74Q FIND V(o2_74) AT=6683.156831p
.measure tran O2_75B FIND V(o2_75) AT=2501.000000p
.measure tran O2_75E FIND V(o2_75) AT=7985.451953p
.measure tran O2_75O FIND V(o2_75) AT=2019.032418p
.measure tran O2_75Q FIND V(o2_75) AT=6683.156831p
.measure tran O2_76B FIND V(o2_76) AT=2501.000000p
.measure tran O2_76E FIND V(o2_76) AT=7985.451953p
.measure tran O2_76O FIND V(o2_76) AT=2019.032418p
.measure tran O2_76Q FIND V(o2_76) AT=6683.156831p
.measure tran O2_77B FIND V(o2_77) AT=2501.000000p
.measure tran O2_77E FIND V(o2_77) AT=7985.451953p
.measure tran O2_77O FIND V(o2_77) AT=2019.032418p
.measure tran O2_77Q FIND V(o2_77) AT=6683.156831p
.measure tran O2_78B FIND V(o2_78) AT=2501.000000p
.measure tran O2_78E FIND V(o2_78) AT=7985.451953p
.measure tran O2_78O FIND V(o2_78) AT=2019.032418p
.measure tran O2_78Q FIND V(o2_78) AT=6683.156831p
.measure tran O2_79B FIND V(o2_79) AT=2501.000000p
.measure tran O2_79E FIND V(o2_79) AT=7985.451953p
.measure tran O2_79O FIND V(o2_79) AT=2019.032418p
.measure tran O2_79Q FIND V(o2_79) AT=6683.156831p
.measure tran O2_80B FIND V(o2_80) AT=2501.000000p
.measure tran O2_80E FIND V(o2_80) AT=7985.451953p
.measure tran O2_80O FIND V(o2_80) AT=2019.032418p
.measure tran O2_80Q FIND V(o2_80) AT=6683.156831p
.measure tran O2_81B FIND V(o2_81) AT=2501.000000p
.measure tran O2_81E FIND V(o2_81) AT=7985.451953p
.measure tran O2_81O FIND V(o2_81) AT=2019.032418p
.measure tran O2_81Q FIND V(o2_81) AT=6683.156831p
.measure tran O2_82B FIND V(o2_82) AT=2501.000000p
.measure tran O2_82E FIND V(o2_82) AT=7985.451953p
.measure tran O2_82O FIND V(o2_82) AT=2019.032418p
.measure tran O2_82Q FIND V(o2_82) AT=6683.156831p
.measure tran O2_83B FIND V(o2_83) AT=2501.000000p
.measure tran O2_83E FIND V(o2_83) AT=7985.451953p
.measure tran O2_83O FIND V(o2_83) AT=2019.032418p
.measure tran O2_83Q FIND V(o2_83) AT=6683.156831p
.measure tran O2_84B FIND V(o2_84) AT=2501.000000p
.measure tran O2_84E FIND V(o2_84) AT=7985.451953p
.measure tran O2_84O FIND V(o2_84) AT=2019.032418p
.measure tran O2_84Q FIND V(o2_84) AT=6683.156831p
.measure tran O2_85B FIND V(o2_85) AT=2501.000000p
.measure tran O2_85E FIND V(o2_85) AT=7985.451953p
.measure tran O2_85O FIND V(o2_85) AT=2019.032418p
.measure tran O2_85Q FIND V(o2_85) AT=6683.156831p
.measure tran O2_86B FIND V(o2_86) AT=2501.000000p
.measure tran O2_86E FIND V(o2_86) AT=7985.451953p
.measure tran O2_86O FIND V(o2_86) AT=2019.032418p
.measure tran O2_86Q FIND V(o2_86) AT=6683.156831p
.measure tran O2_87B FIND V(o2_87) AT=2501.000000p
.measure tran O2_87E FIND V(o2_87) AT=7985.451953p
.measure tran O2_87O FIND V(o2_87) AT=2019.032418p
.measure tran O2_87Q FIND V(o2_87) AT=6683.156831p
.measure tran O2_88B FIND V(o2_88) AT=2501.000000p
.measure tran O2_88E FIND V(o2_88) AT=7985.451953p
.measure tran O2_88O FIND V(o2_88) AT=2019.032418p
.measure tran O2_88Q FIND V(o2_88) AT=6683.156831p
.measure tran O2_89B FIND V(o2_89) AT=2501.000000p
.measure tran O2_89E FIND V(o2_89) AT=7985.451953p
.measure tran O2_89O FIND V(o2_89) AT=2019.032418p
.measure tran O2_89Q FIND V(o2_89) AT=6683.156831p
.measure tran O2_90B FIND V(o2_90) AT=2501.000000p
.measure tran O2_90E FIND V(o2_90) AT=7985.451953p
.measure tran O2_90O FIND V(o2_90) AT=2019.032418p
.measure tran O2_90Q FIND V(o2_90) AT=6683.156831p
.measure tran O2_91B FIND V(o2_91) AT=2501.000000p
.measure tran O2_91E FIND V(o2_91) AT=7985.451953p
.measure tran O2_91O FIND V(o2_91) AT=2019.032418p
.measure tran O2_91Q FIND V(o2_91) AT=6683.156831p
.measure tran O2_92B FIND V(o2_92) AT=2501.000000p
.measure tran O2_92E FIND V(o2_92) AT=7985.451953p
.measure tran O2_92O FIND V(o2_92) AT=2019.032418p
.measure tran O2_92Q FIND V(o2_92) AT=6683.156831p
.measure tran O2_93B FIND V(o2_93) AT=2501.000000p
.measure tran O2_93E FIND V(o2_93) AT=7985.451953p
.measure tran O2_93O FIND V(o2_93) AT=2019.032418p
.measure tran O2_93Q FIND V(o2_93) AT=6683.156831p
.measure tran O2_94B FIND V(o2_94) AT=2501.000000p
.measure tran O2_94E FIND V(o2_94) AT=7985.451953p
.measure tran O2_94O FIND V(o2_94) AT=2019.032418p
.measure tran O2_94Q FIND V(o2_94) AT=6683.156831p
.measure tran O2_95B FIND V(o2_95) AT=2501.000000p
.measure tran O2_95E FIND V(o2_95) AT=7985.451953p
.measure tran O2_95O FIND V(o2_95) AT=2019.032418p
.measure tran O2_95Q FIND V(o2_95) AT=6683.156831p
.measure tran O2_96B FIND V(o2_96) AT=2501.000000p
.measure tran O2_96E FIND V(o2_96) AT=7985.451953p
.measure tran O2_96O FIND V(o2_96) AT=2019.032418p
.measure tran O2_96Q FIND V(o2_96) AT=6683.156831p
.measure tran O2_97B FIND V(o2_97) AT=2501.000000p
.measure tran O2_97E FIND V(o2_97) AT=7985.451953p
.measure tran O2_97O FIND V(o2_97) AT=2019.032418p
.measure tran O2_97Q FIND V(o2_97) AT=6683.156831p
.measure tran O2_98B FIND V(o2_98) AT=2501.000000p
.measure tran O2_98E FIND V(o2_98) AT=7985.451953p
.measure tran O2_98O FIND V(o2_98) AT=2019.032418p
.measure tran O2_98Q FIND V(o2_98) AT=6683.156831p
.measure tran O2_99B FIND V(o2_99) AT=2501.000000p
.measure tran O2_99E FIND V(o2_99) AT=7985.451953p
.measure tran O2_99O FIND V(o2_99) AT=2019.032418p
.measure tran O2_99Q FIND V(o2_99) AT=6683.156831p
.measure tran O2_100B FIND V(o2_100) AT=2501.000000p
.measure tran O2_100E FIND V(o2_100) AT=7985.451953p
.measure tran O2_100O FIND V(o2_100) AT=2019.032418p
.measure tran O2_100Q FIND V(o2_100) AT=6683.156831p
.measure tran O2_101B FIND V(o2_101) AT=2501.000000p
.measure tran O2_101E FIND V(o2_101) AT=7985.451953p
.measure tran O2_101O FIND V(o2_101) AT=2019.032418p
.measure tran O2_101Q FIND V(o2_101) AT=6683.156831p
.measure tran O2_102B FIND V(o2_102) AT=2501.000000p
.measure tran O2_102E FIND V(o2_102) AT=7985.451953p
.measure tran O2_102O FIND V(o2_102) AT=2019.032418p
.measure tran O2_102Q FIND V(o2_102) AT=6683.156831p
.measure tran O2_103B FIND V(o2_103) AT=2501.000000p
.measure tran O2_103E FIND V(o2_103) AT=7985.451953p
.measure tran O2_103O FIND V(o2_103) AT=2019.032418p
.measure tran O2_103Q FIND V(o2_103) AT=6683.156831p
.measure tran O2_104B FIND V(o2_104) AT=2501.000000p
.measure tran O2_104E FIND V(o2_104) AT=7985.451953p
.measure tran O2_104O FIND V(o2_104) AT=2019.032418p
.measure tran O2_104Q FIND V(o2_104) AT=6683.156831p
.measure tran O2_105B FIND V(o2_105) AT=2501.000000p
.measure tran O2_105E FIND V(o2_105) AT=7985.451953p
.measure tran O2_105O FIND V(o2_105) AT=2019.032418p
.measure tran O2_105Q FIND V(o2_105) AT=6683.156831p
.measure tran O2_106B FIND V(o2_106) AT=2501.000000p
.measure tran O2_106E FIND V(o2_106) AT=7985.451953p
.measure tran O2_106O FIND V(o2_106) AT=2019.032418p
.measure tran O2_106Q FIND V(o2_106) AT=6683.156831p
.measure tran O2_107B FIND V(o2_107) AT=2501.000000p
.measure tran O2_107E FIND V(o2_107) AT=7985.451953p
.measure tran O2_107O FIND V(o2_107) AT=2019.032418p
.measure tran O2_107Q FIND V(o2_107) AT=6683.156831p
.measure tran O2_108B FIND V(o2_108) AT=2501.000000p
.measure tran O2_108E FIND V(o2_108) AT=7985.451953p
.measure tran O2_108O FIND V(o2_108) AT=2019.032418p
.measure tran O2_108Q FIND V(o2_108) AT=6683.156831p
.measure tran O2_109B FIND V(o2_109) AT=2501.000000p
.measure tran O2_109E FIND V(o2_109) AT=7985.451953p
.measure tran O2_109O FIND V(o2_109) AT=2019.032418p
.measure tran O2_109Q FIND V(o2_109) AT=6683.156831p
.measure tran O2_110B FIND V(o2_110) AT=2501.000000p
.measure tran O2_110E FIND V(o2_110) AT=7985.451953p
.measure tran O2_110O FIND V(o2_110) AT=2019.032418p
.measure tran O2_110Q FIND V(o2_110) AT=6683.156831p
.measure tran O2_111B FIND V(o2_111) AT=2501.000000p
.measure tran O2_111E FIND V(o2_111) AT=7985.451953p
.measure tran O2_111O FIND V(o2_111) AT=2019.032418p
.measure tran O2_111Q FIND V(o2_111) AT=6683.156831p
.measure tran O2_112B FIND V(o2_112) AT=2501.000000p
.measure tran O2_112E FIND V(o2_112) AT=7985.451953p
.measure tran O2_112O FIND V(o2_112) AT=2019.032418p
.measure tran O2_112Q FIND V(o2_112) AT=6683.156831p
.measure tran O2_113B FIND V(o2_113) AT=2501.000000p
.measure tran O2_113E FIND V(o2_113) AT=7985.451953p
.measure tran O2_113O FIND V(o2_113) AT=2019.032418p
.measure tran O2_113Q FIND V(o2_113) AT=6683.156831p
.measure tran O2_114B FIND V(o2_114) AT=2501.000000p
.measure tran O2_114E FIND V(o2_114) AT=7985.451953p
.measure tran O2_114O FIND V(o2_114) AT=2019.032418p
.measure tran O2_114Q FIND V(o2_114) AT=6683.156831p
.measure tran O2_115B FIND V(o2_115) AT=2501.000000p
.measure tran O2_115E FIND V(o2_115) AT=7985.451953p
.measure tran O2_115O FIND V(o2_115) AT=2019.032418p
.measure tran O2_115Q FIND V(o2_115) AT=6683.156831p
.measure tran O2_116B FIND V(o2_116) AT=2501.000000p
.measure tran O2_116E FIND V(o2_116) AT=7985.451953p
.measure tran O2_116O FIND V(o2_116) AT=2019.032418p
.measure tran O2_116Q FIND V(o2_116) AT=6683.156831p
.measure tran O2_117B FIND V(o2_117) AT=2501.000000p
.measure tran O2_117E FIND V(o2_117) AT=7985.451953p
.measure tran O2_117O FIND V(o2_117) AT=2019.032418p
.measure tran O2_117Q FIND V(o2_117) AT=6683.156831p
.measure tran O2_118B FIND V(o2_118) AT=2501.000000p
.measure tran O2_118E FIND V(o2_118) AT=7985.451953p
.measure tran O2_118O FIND V(o2_118) AT=2019.032418p
.measure tran O2_118Q FIND V(o2_118) AT=6683.156831p
.measure tran O2_119B FIND V(o2_119) AT=2501.000000p
.measure tran O2_119E FIND V(o2_119) AT=7985.451953p
.measure tran O2_119O FIND V(o2_119) AT=2019.032418p
.measure tran O2_119Q FIND V(o2_119) AT=6683.156831p
.measure tran O2_120B FIND V(o2_120) AT=2501.000000p
.measure tran O2_120E FIND V(o2_120) AT=7985.451953p
.measure tran O2_120O FIND V(o2_120) AT=2019.032418p
.measure tran O2_120Q FIND V(o2_120) AT=6683.156831p
.measure tran O2_121B FIND V(o2_121) AT=2501.000000p
.measure tran O2_121E FIND V(o2_121) AT=7985.451953p
.measure tran O2_121O FIND V(o2_121) AT=2019.032418p
.measure tran O2_121Q FIND V(o2_121) AT=6683.156831p
.measure tran O2_122B FIND V(o2_122) AT=2501.000000p
.measure tran O2_122E FIND V(o2_122) AT=7985.451953p
.measure tran O2_122O FIND V(o2_122) AT=2019.032418p
.measure tran O2_122Q FIND V(o2_122) AT=6683.156831p
.measure tran O2_123B FIND V(o2_123) AT=2501.000000p
.measure tran O2_123E FIND V(o2_123) AT=7985.451953p
.measure tran O2_123O FIND V(o2_123) AT=2019.032418p
.measure tran O2_123Q FIND V(o2_123) AT=6683.156831p
.measure tran O2_124B FIND V(o2_124) AT=2501.000000p
.measure tran O2_124E FIND V(o2_124) AT=7985.451953p
.measure tran O2_124O FIND V(o2_124) AT=2019.032418p
.measure tran O2_124Q FIND V(o2_124) AT=6683.156831p
.measure tran O2_125B FIND V(o2_125) AT=2501.000000p
.measure tran O2_125E FIND V(o2_125) AT=7985.451953p
.measure tran O2_125O FIND V(o2_125) AT=2019.032418p
.measure tran O2_125Q FIND V(o2_125) AT=6683.156831p
.measure tran O2_126B FIND V(o2_126) AT=2501.000000p
.measure tran O2_126E FIND V(o2_126) AT=7985.451953p
.measure tran O2_126O FIND V(o2_126) AT=2019.032418p
.measure tran O2_126Q FIND V(o2_126) AT=6683.156831p
.measure tran O2_127B FIND V(o2_127) AT=2501.000000p
.measure tran O2_127E FIND V(o2_127) AT=7985.451953p
.measure tran O2_127O FIND V(o2_127) AT=2019.032418p
.measure tran O2_127Q FIND V(o2_127) AT=6683.156831p
.measure tran VR3Z FIND V(rail3) AT=1.500000p
.measure tran VT3Z FIND V(tnk3) AT=1.500000p
.measure tran VR3O1 FIND V(rail3) AT=586.843911p
.measure tran VT3O1 FIND V(tnk3) AT=586.843911p
.measure tran VR3B1 FIND V(rail3) AT=1351.000000p
.measure tran VT3B1 FIND V(tnk3) AT=1351.000000p
.measure tran VR3R1 FIND V(rail3) AT=4799.000000p
.measure tran VT3R1 FIND V(tnk3) AT=4799.000000p
.measure tran VR3Q1 FIND V(rail3) AT=5229.440253p
.measure tran VT3Q1 FIND V(tnk3) AT=5229.440253p
.measure tran VR3O2 FIND V(rail3) AT=2019.032418p
.measure tran VT3O2 FIND V(tnk3) AT=2019.032418p
.measure tran VR3B2 FIND V(rail3) AT=2501.000000p
.measure tran VT3B2 FIND V(tnk3) AT=2501.000000p
.measure tran VR3R2 FIND V(rail3) AT=5949.000000p
.measure tran VT3R2 FIND V(tnk3) AT=5949.000000p
.measure tran VR3Q2 FIND V(rail3) AT=6683.156831p
.measure tran VT3Q2 FIND V(tnk3) AT=6683.156831p
.measure tran VR3O3 FIND V(rail3) AT=2857.028251p
.measure tran VT3O3 FIND V(tnk3) AT=2857.028251p
.measure tran VR3B3 FIND V(rail3) AT=3651.000000p
.measure tran VT3B3 FIND V(tnk3) AT=3651.000000p
.measure tran VR3R3 FIND V(rail3) AT=7099.000000p
.measure tran VT3R3 FIND V(tnk3) AT=7099.000000p
.measure tran VR3Q3 FIND V(rail3) AT=7490.451953p
.measure tran VT3Q3 FIND V(tnk3) AT=7490.451953p
.measure tran VR3D FIND V(rail3) AT=7985.451953p
.measure tran VT3D FIND V(tnk3) AT=7985.451953p
.measure tran VR3PK MAX V(rail3) FROM=2500p TO=7989.45p
.measure tran IZ3 FIND I(L3) AT=2857.028251p
.measure tran IZQ3 FIND I(L3) AT=7490.451953p
.measure tran IPK3 MAX I(L3) FROM=2500p TO=7989.45p
.measure tran O3_0B FIND V(o3_0) AT=3651.000000p
.measure tran O3_0E FIND V(o3_0) AT=7985.451953p
.measure tran O3_0O FIND V(o3_0) AT=2857.028251p
.measure tran O3_0Q FIND V(o3_0) AT=7490.451953p
.measure tran O3_1B FIND V(o3_1) AT=3651.000000p
.measure tran O3_1E FIND V(o3_1) AT=7985.451953p
.measure tran O3_1O FIND V(o3_1) AT=2857.028251p
.measure tran O3_1Q FIND V(o3_1) AT=7490.451953p
.measure tran O3_2B FIND V(o3_2) AT=3651.000000p
.measure tran O3_2E FIND V(o3_2) AT=7985.451953p
.measure tran O3_2O FIND V(o3_2) AT=2857.028251p
.measure tran O3_2Q FIND V(o3_2) AT=7490.451953p
.measure tran O3_3B FIND V(o3_3) AT=3651.000000p
.measure tran O3_3E FIND V(o3_3) AT=7985.451953p
.measure tran O3_3O FIND V(o3_3) AT=2857.028251p
.measure tran O3_3Q FIND V(o3_3) AT=7490.451953p
.measure tran O3_4B FIND V(o3_4) AT=3651.000000p
.measure tran O3_4E FIND V(o3_4) AT=7985.451953p
.measure tran O3_4O FIND V(o3_4) AT=2857.028251p
.measure tran O3_4Q FIND V(o3_4) AT=7490.451953p
.measure tran O3_5B FIND V(o3_5) AT=3651.000000p
.measure tran O3_5E FIND V(o3_5) AT=7985.451953p
.measure tran O3_5O FIND V(o3_5) AT=2857.028251p
.measure tran O3_5Q FIND V(o3_5) AT=7490.451953p
.measure tran O3_6B FIND V(o3_6) AT=3651.000000p
.measure tran O3_6E FIND V(o3_6) AT=7985.451953p
.measure tran O3_6O FIND V(o3_6) AT=2857.028251p
.measure tran O3_6Q FIND V(o3_6) AT=7490.451953p
.measure tran O3_7B FIND V(o3_7) AT=3651.000000p
.measure tran O3_7E FIND V(o3_7) AT=7985.451953p
.measure tran O3_7O FIND V(o3_7) AT=2857.028251p
.measure tran O3_7Q FIND V(o3_7) AT=7490.451953p
.measure tran O3_8B FIND V(o3_8) AT=3651.000000p
.measure tran O3_8E FIND V(o3_8) AT=7985.451953p
.measure tran O3_8O FIND V(o3_8) AT=2857.028251p
.measure tran O3_8Q FIND V(o3_8) AT=7490.451953p
.measure tran O3_9B FIND V(o3_9) AT=3651.000000p
.measure tran O3_9E FIND V(o3_9) AT=7985.451953p
.measure tran O3_9O FIND V(o3_9) AT=2857.028251p
.measure tran O3_9Q FIND V(o3_9) AT=7490.451953p
.measure tran O3_10B FIND V(o3_10) AT=3651.000000p
.measure tran O3_10E FIND V(o3_10) AT=7985.451953p
.measure tran O3_10O FIND V(o3_10) AT=2857.028251p
.measure tran O3_10Q FIND V(o3_10) AT=7490.451953p
.measure tran O3_11B FIND V(o3_11) AT=3651.000000p
.measure tran O3_11E FIND V(o3_11) AT=7985.451953p
.measure tran O3_11O FIND V(o3_11) AT=2857.028251p
.measure tran O3_11Q FIND V(o3_11) AT=7490.451953p
.measure tran O3_12B FIND V(o3_12) AT=3651.000000p
.measure tran O3_12E FIND V(o3_12) AT=7985.451953p
.measure tran O3_12O FIND V(o3_12) AT=2857.028251p
.measure tran O3_12Q FIND V(o3_12) AT=7490.451953p
.measure tran O3_13B FIND V(o3_13) AT=3651.000000p
.measure tran O3_13E FIND V(o3_13) AT=7985.451953p
.measure tran O3_13O FIND V(o3_13) AT=2857.028251p
.measure tran O3_13Q FIND V(o3_13) AT=7490.451953p
.measure tran O3_14B FIND V(o3_14) AT=3651.000000p
.measure tran O3_14E FIND V(o3_14) AT=7985.451953p
.measure tran O3_14O FIND V(o3_14) AT=2857.028251p
.measure tran O3_14Q FIND V(o3_14) AT=7490.451953p
.measure tran O3_15B FIND V(o3_15) AT=3651.000000p
.measure tran O3_15E FIND V(o3_15) AT=7985.451953p
.measure tran O3_15O FIND V(o3_15) AT=2857.028251p
.measure tran O3_15Q FIND V(o3_15) AT=7490.451953p
.measure tran O3_16B FIND V(o3_16) AT=3651.000000p
.measure tran O3_16E FIND V(o3_16) AT=7985.451953p
.measure tran O3_16O FIND V(o3_16) AT=2857.028251p
.measure tran O3_16Q FIND V(o3_16) AT=7490.451953p
.measure tran O3_17B FIND V(o3_17) AT=3651.000000p
.measure tran O3_17E FIND V(o3_17) AT=7985.451953p
.measure tran O3_17O FIND V(o3_17) AT=2857.028251p
.measure tran O3_17Q FIND V(o3_17) AT=7490.451953p
.measure tran O3_18B FIND V(o3_18) AT=3651.000000p
.measure tran O3_18E FIND V(o3_18) AT=7985.451953p
.measure tran O3_18O FIND V(o3_18) AT=2857.028251p
.measure tran O3_18Q FIND V(o3_18) AT=7490.451953p
.measure tran O3_19B FIND V(o3_19) AT=3651.000000p
.measure tran O3_19E FIND V(o3_19) AT=7985.451953p
.measure tran O3_19O FIND V(o3_19) AT=2857.028251p
.measure tran O3_19Q FIND V(o3_19) AT=7490.451953p
.measure tran O3_20B FIND V(o3_20) AT=3651.000000p
.measure tran O3_20E FIND V(o3_20) AT=7985.451953p
.measure tran O3_20O FIND V(o3_20) AT=2857.028251p
.measure tran O3_20Q FIND V(o3_20) AT=7490.451953p
.measure tran O3_21B FIND V(o3_21) AT=3651.000000p
.measure tran O3_21E FIND V(o3_21) AT=7985.451953p
.measure tran O3_21O FIND V(o3_21) AT=2857.028251p
.measure tran O3_21Q FIND V(o3_21) AT=7490.451953p
.measure tran O3_22B FIND V(o3_22) AT=3651.000000p
.measure tran O3_22E FIND V(o3_22) AT=7985.451953p
.measure tran O3_22O FIND V(o3_22) AT=2857.028251p
.measure tran O3_22Q FIND V(o3_22) AT=7490.451953p
.measure tran O3_23B FIND V(o3_23) AT=3651.000000p
.measure tran O3_23E FIND V(o3_23) AT=7985.451953p
.measure tran O3_23O FIND V(o3_23) AT=2857.028251p
.measure tran O3_23Q FIND V(o3_23) AT=7490.451953p
.measure tran O3_24B FIND V(o3_24) AT=3651.000000p
.measure tran O3_24E FIND V(o3_24) AT=7985.451953p
.measure tran O3_24O FIND V(o3_24) AT=2857.028251p
.measure tran O3_24Q FIND V(o3_24) AT=7490.451953p
.measure tran O3_25B FIND V(o3_25) AT=3651.000000p
.measure tran O3_25E FIND V(o3_25) AT=7985.451953p
.measure tran O3_25O FIND V(o3_25) AT=2857.028251p
.measure tran O3_25Q FIND V(o3_25) AT=7490.451953p
.measure tran O3_26B FIND V(o3_26) AT=3651.000000p
.measure tran O3_26E FIND V(o3_26) AT=7985.451953p
.measure tran O3_26O FIND V(o3_26) AT=2857.028251p
.measure tran O3_26Q FIND V(o3_26) AT=7490.451953p
.measure tran O3_27B FIND V(o3_27) AT=3651.000000p
.measure tran O3_27E FIND V(o3_27) AT=7985.451953p
.measure tran O3_27O FIND V(o3_27) AT=2857.028251p
.measure tran O3_27Q FIND V(o3_27) AT=7490.451953p
.measure tran O3_28B FIND V(o3_28) AT=3651.000000p
.measure tran O3_28E FIND V(o3_28) AT=7985.451953p
.measure tran O3_28O FIND V(o3_28) AT=2857.028251p
.measure tran O3_28Q FIND V(o3_28) AT=7490.451953p
.measure tran O3_29B FIND V(o3_29) AT=3651.000000p
.measure tran O3_29E FIND V(o3_29) AT=7985.451953p
.measure tran O3_29O FIND V(o3_29) AT=2857.028251p
.measure tran O3_29Q FIND V(o3_29) AT=7490.451953p
.measure tran O3_30B FIND V(o3_30) AT=3651.000000p
.measure tran O3_30E FIND V(o3_30) AT=7985.451953p
.measure tran O3_30O FIND V(o3_30) AT=2857.028251p
.measure tran O3_30Q FIND V(o3_30) AT=7490.451953p
.measure tran O3_31B FIND V(o3_31) AT=3651.000000p
.measure tran O3_31E FIND V(o3_31) AT=7985.451953p
.measure tran O3_31O FIND V(o3_31) AT=2857.028251p
.measure tran O3_31Q FIND V(o3_31) AT=7490.451953p
.measure tran O3_32B FIND V(o3_32) AT=3651.000000p
.measure tran O3_32E FIND V(o3_32) AT=7985.451953p
.measure tran O3_32O FIND V(o3_32) AT=2857.028251p
.measure tran O3_32Q FIND V(o3_32) AT=7490.451953p
.measure tran O3_33B FIND V(o3_33) AT=3651.000000p
.measure tran O3_33E FIND V(o3_33) AT=7985.451953p
.measure tran O3_33O FIND V(o3_33) AT=2857.028251p
.measure tran O3_33Q FIND V(o3_33) AT=7490.451953p
.measure tran O3_34B FIND V(o3_34) AT=3651.000000p
.measure tran O3_34E FIND V(o3_34) AT=7985.451953p
.measure tran O3_34O FIND V(o3_34) AT=2857.028251p
.measure tran O3_34Q FIND V(o3_34) AT=7490.451953p
.measure tran O3_35B FIND V(o3_35) AT=3651.000000p
.measure tran O3_35E FIND V(o3_35) AT=7985.451953p
.measure tran O3_35O FIND V(o3_35) AT=2857.028251p
.measure tran O3_35Q FIND V(o3_35) AT=7490.451953p
.measure tran O3_36B FIND V(o3_36) AT=3651.000000p
.measure tran O3_36E FIND V(o3_36) AT=7985.451953p
.measure tran O3_36O FIND V(o3_36) AT=2857.028251p
.measure tran O3_36Q FIND V(o3_36) AT=7490.451953p
.measure tran O3_37B FIND V(o3_37) AT=3651.000000p
.measure tran O3_37E FIND V(o3_37) AT=7985.451953p
.measure tran O3_37O FIND V(o3_37) AT=2857.028251p
.measure tran O3_37Q FIND V(o3_37) AT=7490.451953p
.measure tran O3_38B FIND V(o3_38) AT=3651.000000p
.measure tran O3_38E FIND V(o3_38) AT=7985.451953p
.measure tran O3_38O FIND V(o3_38) AT=2857.028251p
.measure tran O3_38Q FIND V(o3_38) AT=7490.451953p
.measure tran O3_39B FIND V(o3_39) AT=3651.000000p
.measure tran O3_39E FIND V(o3_39) AT=7985.451953p
.measure tran O3_39O FIND V(o3_39) AT=2857.028251p
.measure tran O3_39Q FIND V(o3_39) AT=7490.451953p
.measure tran O3_40B FIND V(o3_40) AT=3651.000000p
.measure tran O3_40E FIND V(o3_40) AT=7985.451953p
.measure tran O3_40O FIND V(o3_40) AT=2857.028251p
.measure tran O3_40Q FIND V(o3_40) AT=7490.451953p
.measure tran O3_41B FIND V(o3_41) AT=3651.000000p
.measure tran O3_41E FIND V(o3_41) AT=7985.451953p
.measure tran O3_41O FIND V(o3_41) AT=2857.028251p
.measure tran O3_41Q FIND V(o3_41) AT=7490.451953p
.measure tran O3_42B FIND V(o3_42) AT=3651.000000p
.measure tran O3_42E FIND V(o3_42) AT=7985.451953p
.measure tran O3_42O FIND V(o3_42) AT=2857.028251p
.measure tran O3_42Q FIND V(o3_42) AT=7490.451953p
.measure tran O3_43B FIND V(o3_43) AT=3651.000000p
.measure tran O3_43E FIND V(o3_43) AT=7985.451953p
.measure tran O3_43O FIND V(o3_43) AT=2857.028251p
.measure tran O3_43Q FIND V(o3_43) AT=7490.451953p
.measure tran O3_44B FIND V(o3_44) AT=3651.000000p
.measure tran O3_44E FIND V(o3_44) AT=7985.451953p
.measure tran O3_44O FIND V(o3_44) AT=2857.028251p
.measure tran O3_44Q FIND V(o3_44) AT=7490.451953p
.measure tran O3_45B FIND V(o3_45) AT=3651.000000p
.measure tran O3_45E FIND V(o3_45) AT=7985.451953p
.measure tran O3_45O FIND V(o3_45) AT=2857.028251p
.measure tran O3_45Q FIND V(o3_45) AT=7490.451953p
.measure tran O3_46B FIND V(o3_46) AT=3651.000000p
.measure tran O3_46E FIND V(o3_46) AT=7985.451953p
.measure tran O3_46O FIND V(o3_46) AT=2857.028251p
.measure tran O3_46Q FIND V(o3_46) AT=7490.451953p
.measure tran O3_47B FIND V(o3_47) AT=3651.000000p
.measure tran O3_47E FIND V(o3_47) AT=7985.451953p
.measure tran O3_47O FIND V(o3_47) AT=2857.028251p
.measure tran O3_47Q FIND V(o3_47) AT=7490.451953p
.measure tran O3_48B FIND V(o3_48) AT=3651.000000p
.measure tran O3_48E FIND V(o3_48) AT=7985.451953p
.measure tran O3_48O FIND V(o3_48) AT=2857.028251p
.measure tran O3_48Q FIND V(o3_48) AT=7490.451953p
.measure tran O3_49B FIND V(o3_49) AT=3651.000000p
.measure tran O3_49E FIND V(o3_49) AT=7985.451953p
.measure tran O3_49O FIND V(o3_49) AT=2857.028251p
.measure tran O3_49Q FIND V(o3_49) AT=7490.451953p
.measure tran O3_50B FIND V(o3_50) AT=3651.000000p
.measure tran O3_50E FIND V(o3_50) AT=7985.451953p
.measure tran O3_50O FIND V(o3_50) AT=2857.028251p
.measure tran O3_50Q FIND V(o3_50) AT=7490.451953p
.measure tran O3_51B FIND V(o3_51) AT=3651.000000p
.measure tran O3_51E FIND V(o3_51) AT=7985.451953p
.measure tran O3_51O FIND V(o3_51) AT=2857.028251p
.measure tran O3_51Q FIND V(o3_51) AT=7490.451953p
.measure tran O3_52B FIND V(o3_52) AT=3651.000000p
.measure tran O3_52E FIND V(o3_52) AT=7985.451953p
.measure tran O3_52O FIND V(o3_52) AT=2857.028251p
.measure tran O3_52Q FIND V(o3_52) AT=7490.451953p
.measure tran O3_53B FIND V(o3_53) AT=3651.000000p
.measure tran O3_53E FIND V(o3_53) AT=7985.451953p
.measure tran O3_53O FIND V(o3_53) AT=2857.028251p
.measure tran O3_53Q FIND V(o3_53) AT=7490.451953p
.measure tran O3_54B FIND V(o3_54) AT=3651.000000p
.measure tran O3_54E FIND V(o3_54) AT=7985.451953p
.measure tran O3_54O FIND V(o3_54) AT=2857.028251p
.measure tran O3_54Q FIND V(o3_54) AT=7490.451953p
.measure tran O3_55B FIND V(o3_55) AT=3651.000000p
.measure tran O3_55E FIND V(o3_55) AT=7985.451953p
.measure tran O3_55O FIND V(o3_55) AT=2857.028251p
.measure tran O3_55Q FIND V(o3_55) AT=7490.451953p
.measure tran O3_56B FIND V(o3_56) AT=3651.000000p
.measure tran O3_56E FIND V(o3_56) AT=7985.451953p
.measure tran O3_56O FIND V(o3_56) AT=2857.028251p
.measure tran O3_56Q FIND V(o3_56) AT=7490.451953p
.measure tran O3_57B FIND V(o3_57) AT=3651.000000p
.measure tran O3_57E FIND V(o3_57) AT=7985.451953p
.measure tran O3_57O FIND V(o3_57) AT=2857.028251p
.measure tran O3_57Q FIND V(o3_57) AT=7490.451953p
.measure tran O3_58B FIND V(o3_58) AT=3651.000000p
.measure tran O3_58E FIND V(o3_58) AT=7985.451953p
.measure tran O3_58O FIND V(o3_58) AT=2857.028251p
.measure tran O3_58Q FIND V(o3_58) AT=7490.451953p
.measure tran O3_59B FIND V(o3_59) AT=3651.000000p
.measure tran O3_59E FIND V(o3_59) AT=7985.451953p
.measure tran O3_59O FIND V(o3_59) AT=2857.028251p
.measure tran O3_59Q FIND V(o3_59) AT=7490.451953p
.measure tran O3_60B FIND V(o3_60) AT=3651.000000p
.measure tran O3_60E FIND V(o3_60) AT=7985.451953p
.measure tran O3_60O FIND V(o3_60) AT=2857.028251p
.measure tran O3_60Q FIND V(o3_60) AT=7490.451953p
.measure tran O3_61B FIND V(o3_61) AT=3651.000000p
.measure tran O3_61E FIND V(o3_61) AT=7985.451953p
.measure tran O3_61O FIND V(o3_61) AT=2857.028251p
.measure tran O3_61Q FIND V(o3_61) AT=7490.451953p
.measure tran O3_62B FIND V(o3_62) AT=3651.000000p
.measure tran O3_62E FIND V(o3_62) AT=7985.451953p
.measure tran O3_62O FIND V(o3_62) AT=2857.028251p
.measure tran O3_62Q FIND V(o3_62) AT=7490.451953p
.measure tran O3_63B FIND V(o3_63) AT=3651.000000p
.measure tran O3_63E FIND V(o3_63) AT=7985.451953p
.measure tran O3_63O FIND V(o3_63) AT=2857.028251p
.measure tran O3_63Q FIND V(o3_63) AT=7490.451953p
.measure tran O3_64B FIND V(o3_64) AT=3651.000000p
.measure tran O3_64E FIND V(o3_64) AT=7985.451953p
.measure tran O3_64O FIND V(o3_64) AT=2857.028251p
.measure tran O3_64Q FIND V(o3_64) AT=7490.451953p
.measure tran O3_65B FIND V(o3_65) AT=3651.000000p
.measure tran O3_65E FIND V(o3_65) AT=7985.451953p
.measure tran O3_65O FIND V(o3_65) AT=2857.028251p
.measure tran O3_65Q FIND V(o3_65) AT=7490.451953p
.measure tran O3_66B FIND V(o3_66) AT=3651.000000p
.measure tran O3_66E FIND V(o3_66) AT=7985.451953p
.measure tran O3_66O FIND V(o3_66) AT=2857.028251p
.measure tran O3_66Q FIND V(o3_66) AT=7490.451953p
.measure tran O3_67B FIND V(o3_67) AT=3651.000000p
.measure tran O3_67E FIND V(o3_67) AT=7985.451953p
.measure tran O3_67O FIND V(o3_67) AT=2857.028251p
.measure tran O3_67Q FIND V(o3_67) AT=7490.451953p
.measure tran O3_68B FIND V(o3_68) AT=3651.000000p
.measure tran O3_68E FIND V(o3_68) AT=7985.451953p
.measure tran O3_68O FIND V(o3_68) AT=2857.028251p
.measure tran O3_68Q FIND V(o3_68) AT=7490.451953p
.measure tran O3_69B FIND V(o3_69) AT=3651.000000p
.measure tran O3_69E FIND V(o3_69) AT=7985.451953p
.measure tran O3_69O FIND V(o3_69) AT=2857.028251p
.measure tran O3_69Q FIND V(o3_69) AT=7490.451953p
.measure tran O3_70B FIND V(o3_70) AT=3651.000000p
.measure tran O3_70E FIND V(o3_70) AT=7985.451953p
.measure tran O3_70O FIND V(o3_70) AT=2857.028251p
.measure tran O3_70Q FIND V(o3_70) AT=7490.451953p
.measure tran O3_71B FIND V(o3_71) AT=3651.000000p
.measure tran O3_71E FIND V(o3_71) AT=7985.451953p
.measure tran O3_71O FIND V(o3_71) AT=2857.028251p
.measure tran O3_71Q FIND V(o3_71) AT=7490.451953p
.measure tran O3_72B FIND V(o3_72) AT=3651.000000p
.measure tran O3_72E FIND V(o3_72) AT=7985.451953p
.measure tran O3_72O FIND V(o3_72) AT=2857.028251p
.measure tran O3_72Q FIND V(o3_72) AT=7490.451953p
.measure tran O3_73B FIND V(o3_73) AT=3651.000000p
.measure tran O3_73E FIND V(o3_73) AT=7985.451953p
.measure tran O3_73O FIND V(o3_73) AT=2857.028251p
.measure tran O3_73Q FIND V(o3_73) AT=7490.451953p
.measure tran O3_74B FIND V(o3_74) AT=3651.000000p
.measure tran O3_74E FIND V(o3_74) AT=7985.451953p
.measure tran O3_74O FIND V(o3_74) AT=2857.028251p
.measure tran O3_74Q FIND V(o3_74) AT=7490.451953p
.measure tran O3_75B FIND V(o3_75) AT=3651.000000p
.measure tran O3_75E FIND V(o3_75) AT=7985.451953p
.measure tran O3_75O FIND V(o3_75) AT=2857.028251p
.measure tran O3_75Q FIND V(o3_75) AT=7490.451953p
.measure tran O3_76B FIND V(o3_76) AT=3651.000000p
.measure tran O3_76E FIND V(o3_76) AT=7985.451953p
.measure tran O3_76O FIND V(o3_76) AT=2857.028251p
.measure tran O3_76Q FIND V(o3_76) AT=7490.451953p
.measure tran O3_77B FIND V(o3_77) AT=3651.000000p
.measure tran O3_77E FIND V(o3_77) AT=7985.451953p
.measure tran O3_77O FIND V(o3_77) AT=2857.028251p
.measure tran O3_77Q FIND V(o3_77) AT=7490.451953p
.measure tran O3_78B FIND V(o3_78) AT=3651.000000p
.measure tran O3_78E FIND V(o3_78) AT=7985.451953p
.measure tran O3_78O FIND V(o3_78) AT=2857.028251p
.measure tran O3_78Q FIND V(o3_78) AT=7490.451953p
.measure tran O3_79B FIND V(o3_79) AT=3651.000000p
.measure tran O3_79E FIND V(o3_79) AT=7985.451953p
.measure tran O3_79O FIND V(o3_79) AT=2857.028251p
.measure tran O3_79Q FIND V(o3_79) AT=7490.451953p
.measure tran O3_80B FIND V(o3_80) AT=3651.000000p
.measure tran O3_80E FIND V(o3_80) AT=7985.451953p
.measure tran O3_80O FIND V(o3_80) AT=2857.028251p
.measure tran O3_80Q FIND V(o3_80) AT=7490.451953p
.measure tran O3_81B FIND V(o3_81) AT=3651.000000p
.measure tran O3_81E FIND V(o3_81) AT=7985.451953p
.measure tran O3_81O FIND V(o3_81) AT=2857.028251p
.measure tran O3_81Q FIND V(o3_81) AT=7490.451953p
.measure tran O3_82B FIND V(o3_82) AT=3651.000000p
.measure tran O3_82E FIND V(o3_82) AT=7985.451953p
.measure tran O3_82O FIND V(o3_82) AT=2857.028251p
.measure tran O3_82Q FIND V(o3_82) AT=7490.451953p
.measure tran O3_83B FIND V(o3_83) AT=3651.000000p
.measure tran O3_83E FIND V(o3_83) AT=7985.451953p
.measure tran O3_83O FIND V(o3_83) AT=2857.028251p
.measure tran O3_83Q FIND V(o3_83) AT=7490.451953p
.measure tran O3_84B FIND V(o3_84) AT=3651.000000p
.measure tran O3_84E FIND V(o3_84) AT=7985.451953p
.measure tran O3_84O FIND V(o3_84) AT=2857.028251p
.measure tran O3_84Q FIND V(o3_84) AT=7490.451953p
.measure tran O3_85B FIND V(o3_85) AT=3651.000000p
.measure tran O3_85E FIND V(o3_85) AT=7985.451953p
.measure tran O3_85O FIND V(o3_85) AT=2857.028251p
.measure tran O3_85Q FIND V(o3_85) AT=7490.451953p
.measure tran O3_86B FIND V(o3_86) AT=3651.000000p
.measure tran O3_86E FIND V(o3_86) AT=7985.451953p
.measure tran O3_86O FIND V(o3_86) AT=2857.028251p
.measure tran O3_86Q FIND V(o3_86) AT=7490.451953p
.measure tran O3_87B FIND V(o3_87) AT=3651.000000p
.measure tran O3_87E FIND V(o3_87) AT=7985.451953p
.measure tran O3_87O FIND V(o3_87) AT=2857.028251p
.measure tran O3_87Q FIND V(o3_87) AT=7490.451953p
.measure tran O3_88B FIND V(o3_88) AT=3651.000000p
.measure tran O3_88E FIND V(o3_88) AT=7985.451953p
.measure tran O3_88O FIND V(o3_88) AT=2857.028251p
.measure tran O3_88Q FIND V(o3_88) AT=7490.451953p
.measure tran O3_89B FIND V(o3_89) AT=3651.000000p
.measure tran O3_89E FIND V(o3_89) AT=7985.451953p
.measure tran O3_89O FIND V(o3_89) AT=2857.028251p
.measure tran O3_89Q FIND V(o3_89) AT=7490.451953p
.measure tran O3_90B FIND V(o3_90) AT=3651.000000p
.measure tran O3_90E FIND V(o3_90) AT=7985.451953p
.measure tran O3_90O FIND V(o3_90) AT=2857.028251p
.measure tran O3_90Q FIND V(o3_90) AT=7490.451953p
.measure tran O3_91B FIND V(o3_91) AT=3651.000000p
.measure tran O3_91E FIND V(o3_91) AT=7985.451953p
.measure tran O3_91O FIND V(o3_91) AT=2857.028251p
.measure tran O3_91Q FIND V(o3_91) AT=7490.451953p
.measure tran O3_92B FIND V(o3_92) AT=3651.000000p
.measure tran O3_92E FIND V(o3_92) AT=7985.451953p
.measure tran O3_92O FIND V(o3_92) AT=2857.028251p
.measure tran O3_92Q FIND V(o3_92) AT=7490.451953p
.measure tran O3_93B FIND V(o3_93) AT=3651.000000p
.measure tran O3_93E FIND V(o3_93) AT=7985.451953p
.measure tran O3_93O FIND V(o3_93) AT=2857.028251p
.measure tran O3_93Q FIND V(o3_93) AT=7490.451953p
.measure tran O3_94B FIND V(o3_94) AT=3651.000000p
.measure tran O3_94E FIND V(o3_94) AT=7985.451953p
.measure tran O3_94O FIND V(o3_94) AT=2857.028251p
.measure tran O3_94Q FIND V(o3_94) AT=7490.451953p
.measure tran O3_95B FIND V(o3_95) AT=3651.000000p
.measure tran O3_95E FIND V(o3_95) AT=7985.451953p
.measure tran O3_95O FIND V(o3_95) AT=2857.028251p
.measure tran O3_95Q FIND V(o3_95) AT=7490.451953p
.measure tran O3_96B FIND V(o3_96) AT=3651.000000p
.measure tran O3_96E FIND V(o3_96) AT=7985.451953p
.measure tran O3_96O FIND V(o3_96) AT=2857.028251p
.measure tran O3_96Q FIND V(o3_96) AT=7490.451953p
.measure tran O3_97B FIND V(o3_97) AT=3651.000000p
.measure tran O3_97E FIND V(o3_97) AT=7985.451953p
.measure tran O3_97O FIND V(o3_97) AT=2857.028251p
.measure tran O3_97Q FIND V(o3_97) AT=7490.451953p
.measure tran O3_98B FIND V(o3_98) AT=3651.000000p
.measure tran O3_98E FIND V(o3_98) AT=7985.451953p
.measure tran O3_98O FIND V(o3_98) AT=2857.028251p
.measure tran O3_98Q FIND V(o3_98) AT=7490.451953p
.measure tran O3_99B FIND V(o3_99) AT=3651.000000p
.measure tran O3_99E FIND V(o3_99) AT=7985.451953p
.measure tran O3_99O FIND V(o3_99) AT=2857.028251p
.measure tran O3_99Q FIND V(o3_99) AT=7490.451953p
.measure tran O3_100B FIND V(o3_100) AT=3651.000000p
.measure tran O3_100E FIND V(o3_100) AT=7985.451953p
.measure tran O3_100O FIND V(o3_100) AT=2857.028251p
.measure tran O3_100Q FIND V(o3_100) AT=7490.451953p
.measure tran O3_101B FIND V(o3_101) AT=3651.000000p
.measure tran O3_101E FIND V(o3_101) AT=7985.451953p
.measure tran O3_101O FIND V(o3_101) AT=2857.028251p
.measure tran O3_101Q FIND V(o3_101) AT=7490.451953p
.measure tran O3_102B FIND V(o3_102) AT=3651.000000p
.measure tran O3_102E FIND V(o3_102) AT=7985.451953p
.measure tran O3_102O FIND V(o3_102) AT=2857.028251p
.measure tran O3_102Q FIND V(o3_102) AT=7490.451953p
.measure tran O3_103B FIND V(o3_103) AT=3651.000000p
.measure tran O3_103E FIND V(o3_103) AT=7985.451953p
.measure tran O3_103O FIND V(o3_103) AT=2857.028251p
.measure tran O3_103Q FIND V(o3_103) AT=7490.451953p
.measure tran O3_104B FIND V(o3_104) AT=3651.000000p
.measure tran O3_104E FIND V(o3_104) AT=7985.451953p
.measure tran O3_104O FIND V(o3_104) AT=2857.028251p
.measure tran O3_104Q FIND V(o3_104) AT=7490.451953p
.measure tran O3_105B FIND V(o3_105) AT=3651.000000p
.measure tran O3_105E FIND V(o3_105) AT=7985.451953p
.measure tran O3_105O FIND V(o3_105) AT=2857.028251p
.measure tran O3_105Q FIND V(o3_105) AT=7490.451953p
.measure tran O3_106B FIND V(o3_106) AT=3651.000000p
.measure tran O3_106E FIND V(o3_106) AT=7985.451953p
.measure tran O3_106O FIND V(o3_106) AT=2857.028251p
.measure tran O3_106Q FIND V(o3_106) AT=7490.451953p
.measure tran O3_107B FIND V(o3_107) AT=3651.000000p
.measure tran O3_107E FIND V(o3_107) AT=7985.451953p
.measure tran O3_107O FIND V(o3_107) AT=2857.028251p
.measure tran O3_107Q FIND V(o3_107) AT=7490.451953p
.measure tran O3_108B FIND V(o3_108) AT=3651.000000p
.measure tran O3_108E FIND V(o3_108) AT=7985.451953p
.measure tran O3_108O FIND V(o3_108) AT=2857.028251p
.measure tran O3_108Q FIND V(o3_108) AT=7490.451953p
.measure tran O3_109B FIND V(o3_109) AT=3651.000000p
.measure tran O3_109E FIND V(o3_109) AT=7985.451953p
.measure tran O3_109O FIND V(o3_109) AT=2857.028251p
.measure tran O3_109Q FIND V(o3_109) AT=7490.451953p
.measure tran O3_110B FIND V(o3_110) AT=3651.000000p
.measure tran O3_110E FIND V(o3_110) AT=7985.451953p
.measure tran O3_110O FIND V(o3_110) AT=2857.028251p
.measure tran O3_110Q FIND V(o3_110) AT=7490.451953p
.measure tran O3_111B FIND V(o3_111) AT=3651.000000p
.measure tran O3_111E FIND V(o3_111) AT=7985.451953p
.measure tran O3_111O FIND V(o3_111) AT=2857.028251p
.measure tran O3_111Q FIND V(o3_111) AT=7490.451953p
.measure tran O3_112B FIND V(o3_112) AT=3651.000000p
.measure tran O3_112E FIND V(o3_112) AT=7985.451953p
.measure tran O3_112O FIND V(o3_112) AT=2857.028251p
.measure tran O3_112Q FIND V(o3_112) AT=7490.451953p
.measure tran O3_113B FIND V(o3_113) AT=3651.000000p
.measure tran O3_113E FIND V(o3_113) AT=7985.451953p
.measure tran O3_113O FIND V(o3_113) AT=2857.028251p
.measure tran O3_113Q FIND V(o3_113) AT=7490.451953p
.measure tran O3_114B FIND V(o3_114) AT=3651.000000p
.measure tran O3_114E FIND V(o3_114) AT=7985.451953p
.measure tran O3_114O FIND V(o3_114) AT=2857.028251p
.measure tran O3_114Q FIND V(o3_114) AT=7490.451953p
.measure tran O3_115B FIND V(o3_115) AT=3651.000000p
.measure tran O3_115E FIND V(o3_115) AT=7985.451953p
.measure tran O3_115O FIND V(o3_115) AT=2857.028251p
.measure tran O3_115Q FIND V(o3_115) AT=7490.451953p
.measure tran O3_116B FIND V(o3_116) AT=3651.000000p
.measure tran O3_116E FIND V(o3_116) AT=7985.451953p
.measure tran O3_116O FIND V(o3_116) AT=2857.028251p
.measure tran O3_116Q FIND V(o3_116) AT=7490.451953p
.measure tran O3_117B FIND V(o3_117) AT=3651.000000p
.measure tran O3_117E FIND V(o3_117) AT=7985.451953p
.measure tran O3_117O FIND V(o3_117) AT=2857.028251p
.measure tran O3_117Q FIND V(o3_117) AT=7490.451953p
.measure tran O3_118B FIND V(o3_118) AT=3651.000000p
.measure tran O3_118E FIND V(o3_118) AT=7985.451953p
.measure tran O3_118O FIND V(o3_118) AT=2857.028251p
.measure tran O3_118Q FIND V(o3_118) AT=7490.451953p
.measure tran O3_119B FIND V(o3_119) AT=3651.000000p
.measure tran O3_119E FIND V(o3_119) AT=7985.451953p
.measure tran O3_119O FIND V(o3_119) AT=2857.028251p
.measure tran O3_119Q FIND V(o3_119) AT=7490.451953p
.measure tran O3_120B FIND V(o3_120) AT=3651.000000p
.measure tran O3_120E FIND V(o3_120) AT=7985.451953p
.measure tran O3_120O FIND V(o3_120) AT=2857.028251p
.measure tran O3_120Q FIND V(o3_120) AT=7490.451953p
.measure tran O3_121B FIND V(o3_121) AT=3651.000000p
.measure tran O3_121E FIND V(o3_121) AT=7985.451953p
.measure tran O3_121O FIND V(o3_121) AT=2857.028251p
.measure tran O3_121Q FIND V(o3_121) AT=7490.451953p
.measure tran O3_122B FIND V(o3_122) AT=3651.000000p
.measure tran O3_122E FIND V(o3_122) AT=7985.451953p
.measure tran O3_122O FIND V(o3_122) AT=2857.028251p
.measure tran O3_122Q FIND V(o3_122) AT=7490.451953p
.measure tran O3_123B FIND V(o3_123) AT=3651.000000p
.measure tran O3_123E FIND V(o3_123) AT=7985.451953p
.measure tran O3_123O FIND V(o3_123) AT=2857.028251p
.measure tran O3_123Q FIND V(o3_123) AT=7490.451953p
.measure tran O3_124B FIND V(o3_124) AT=3651.000000p
.measure tran O3_124E FIND V(o3_124) AT=7985.451953p
.measure tran O3_124O FIND V(o3_124) AT=2857.028251p
.measure tran O3_124Q FIND V(o3_124) AT=7490.451953p
.measure tran O3_125B FIND V(o3_125) AT=3651.000000p
.measure tran O3_125E FIND V(o3_125) AT=7985.451953p
.measure tran O3_125O FIND V(o3_125) AT=2857.028251p
.measure tran O3_125Q FIND V(o3_125) AT=7490.451953p
.measure tran O3_126B FIND V(o3_126) AT=3651.000000p
.measure tran O3_126E FIND V(o3_126) AT=7985.451953p
.measure tran O3_126O FIND V(o3_126) AT=2857.028251p
.measure tran O3_126Q FIND V(o3_126) AT=7490.451953p
.measure tran O3_127B FIND V(o3_127) AT=3651.000000p
.measure tran O3_127E FIND V(o3_127) AT=7985.451953p
.measure tran O3_127O FIND V(o3_127) AT=2857.028251p
.measure tran O3_127Q FIND V(o3_127) AT=7490.451953p
.print tran V(rail1) V(rail2) V(rail3) V(tnk1) V(tnk2) V(tnk3) I(L1) I(L2) I(L3) V(sw1) V(sw2) V(sw3) V(o1_0) V(o1_1) V(o1_2) V(o1_3) V(o1_4) V(o1_5) V(o1_6) V(o1_7) V(o1_8) V(o1_9) V(o1_10) V(o1_11) V(o1_12) V(o1_13) V(o1_14) V(o1_15) V(o1_16) V(o1_17) V(o1_18) V(o1_19) V(o1_20) V(o1_21) V(o1_22) V(o1_23) V(o1_24) V(o1_25) V(o1_26) V(o1_27) V(o1_28) V(o1_29) V(o1_30) V(o1_31) V(o1_32) V(o1_33) V(o1_34) V(o1_35) V(o1_36) V(o1_37) V(o1_38) V(o1_39) V(o1_40) V(o1_41) V(o1_42) V(o1_43) V(o1_44) V(o1_45) V(o1_46) V(o1_47) V(o1_48) V(o1_49) V(o1_50) V(o1_51) V(o1_52) V(o1_53) V(o1_54) V(o1_55) V(o1_56) V(o1_57) V(o1_58) V(o1_59) V(o1_60) V(o1_61) V(o1_62) V(o1_63) V(o1_64) V(o1_65) V(o1_66) V(o1_67) V(o1_68) V(o1_69) V(o1_70) V(o1_71) V(o1_72) V(o1_73) V(o1_74) V(o1_75) V(o1_76) V(o1_77) V(o1_78) V(o1_79) V(o1_80) V(o1_81) V(o1_82) V(o1_83) V(o1_84) V(o1_85) V(o1_86) V(o1_87) V(o1_88) V(o1_89) V(o1_90) V(o1_91) V(o1_92) V(o1_93) V(o1_94) V(o1_95) V(o1_96) V(o1_97) V(o1_98) V(o1_99) V(o1_100) V(o1_101) V(o1_102) V(o1_103) V(o1_104) V(o1_105) V(o1_106) V(o1_107) V(o1_108) V(o1_109) V(o1_110) V(o1_111) V(o1_112) V(o1_113) V(o1_114) V(o1_115) V(o1_116) V(o1_117) V(o1_118) V(o1_119) V(o1_120) V(o1_121) V(o1_122) V(o1_123) V(o1_124) V(o1_125) V(o1_126) V(o1_127) V(o2_0) V(o2_1) V(o2_2) V(o2_3) V(o2_4) V(o2_5) V(o2_6) V(o2_7) V(o2_8) V(o2_9) V(o2_10) V(o2_11) V(o2_12) V(o2_13) V(o2_14) V(o2_15) V(o2_16) V(o2_17) V(o2_18) V(o2_19) V(o2_20) V(o2_21) V(o2_22) V(o2_23) V(o2_24) V(o2_25) V(o2_26) V(o2_27) V(o2_28) V(o2_29) V(o2_30) V(o2_31) V(o2_32) V(o2_33) V(o2_34) V(o2_35) V(o2_36) V(o2_37) V(o2_38) V(o2_39) V(o2_40) V(o2_41) V(o2_42) V(o2_43) V(o2_44) V(o2_45) V(o2_46) V(o2_47) V(o2_48) V(o2_49) V(o2_50) V(o2_51) V(o2_52) V(o2_53) V(o2_54) V(o2_55) V(o2_56) V(o2_57) V(o2_58) V(o2_59) V(o2_60) V(o2_61) V(o2_62) V(o2_63) V(o2_64) V(o2_65) V(o2_66) V(o2_67) V(o2_68) V(o2_69) V(o2_70) V(o2_71) V(o2_72) V(o2_73) V(o2_74) V(o2_75) V(o2_76) V(o2_77) V(o2_78) V(o2_79) V(o2_80) V(o2_81) V(o2_82) V(o2_83) V(o2_84) V(o2_85) V(o2_86) V(o2_87) V(o2_88) V(o2_89) V(o2_90) V(o2_91) V(o2_92) V(o2_93) V(o2_94) V(o2_95) V(o2_96) V(o2_97) V(o2_98) V(o2_99) V(o2_100) V(o2_101) V(o2_102) V(o2_103) V(o2_104) V(o2_105) V(o2_106) V(o2_107) V(o2_108) V(o2_109) V(o2_110) V(o2_111) V(o2_112) V(o2_113) V(o2_114) V(o2_115) V(o2_116) V(o2_117) V(o2_118) V(o2_119) V(o2_120) V(o2_121) V(o2_122) V(o2_123) V(o2_124) V(o2_125) V(o2_126) V(o2_127) V(o3_0) V(o3_1) V(o3_2) V(o3_3) V(o3_4) V(o3_5) V(o3_6) V(o3_7) V(o3_8) V(o3_9) V(o3_10) V(o3_11) V(o3_12) V(o3_13) V(o3_14) V(o3_15) V(o3_16) V(o3_17) V(o3_18) V(o3_19) V(o3_20) V(o3_21) V(o3_22) V(o3_23) V(o3_24) V(o3_25) V(o3_26) V(o3_27) V(o3_28) V(o3_29) V(o3_30) V(o3_31) V(o3_32) V(o3_33) V(o3_34) V(o3_35) V(o3_36) V(o3_37) V(o3_38) V(o3_39) V(o3_40) V(o3_41) V(o3_42) V(o3_43) V(o3_44) V(o3_45) V(o3_46) V(o3_47) V(o3_48) V(o3_49) V(o3_50) V(o3_51) V(o3_52) V(o3_53) V(o3_54) V(o3_55) V(o3_56) V(o3_57) V(o3_58) V(o3_59) V(o3_60) V(o3_61) V(o3_62) V(o3_63) V(o3_64) V(o3_65) V(o3_66) V(o3_67) V(o3_68) V(o3_69) V(o3_70) V(o3_71) V(o3_72) V(o3_73) V(o3_74) V(o3_75) V(o3_76) V(o3_77) V(o3_78) V(o3_79) V(o3_80) V(o3_81) V(o3_82) V(o3_83) V(o3_84) V(o3_85) V(o3_86) V(o3_87) V(o3_88) V(o3_89) V(o3_90) V(o3_91) V(o3_92) V(o3_93) V(o3_94) V(o3_95) V(o3_96) V(o3_97) V(o3_98) V(o3_99) V(o3_100) V(o3_101) V(o3_102) V(o3_103) V(o3_104) V(o3_105) V(o3_106) V(o3_107) V(o3_108) V(o3_109) V(o3_110) V(o3_111) V(o3_112) V(o3_113) V(o3_114) V(o3_115) V(o3_116) V(o3_117) V(o3_118) V(o3_119) V(o3_120) V(o3_121) V(o3_122) V(o3_123) V(o3_124) V(o3_125) V(o3_126) V(o3_127)
.end
