.hdl "/usr/local/share/xyce/verilog-a/psp103/psp103.va"
.include "/usr/local/src/kestrel/sim/models/sg13g2_psp103_tt.lib"
.include "/usr/local/src/stat-sim/qal/sg13lv_compat.sp"
.OPTIONS TIMEINT METHOD=GEAR RELTOL=1e-6 ABSTOL=1e-15 CHGTOL=1e-17
.include "/usr/local/src/IHP-Open-PDK/ihp-sg13g2/libs.ref/sg13g2_stdcell/spice/sg13g2_stdcell.spice"
VHI vhi 0 1.5
VMG1 gn1 0 0
VS_s_a0 s_a0 0 1.65
VS_s_a1 s_a1 0 1.65
VS_s_a10 s_a10 0 0
VS_s_a11 s_a11 0 1.65
VS_s_a12 s_a12 0 0
VS_s_a13 s_a13 0 0
VS_s_a14 s_a14 0 0
VS_s_a15 s_a15 0 0
VS_s_a16 s_a16 0 1.65
VS_s_a17 s_a17 0 1.65
VS_s_a18 s_a18 0 0
VS_s_a19 s_a19 0 0
VS_s_a2 s_a2 0 0
VS_s_a20 s_a20 0 0
VS_s_a21 s_a21 0 1.65
VS_s_a22 s_a22 0 0
VS_s_a23 s_a23 0 1.65
VS_s_a24 s_a24 0 1.65
VS_s_a25 s_a25 0 0
VS_s_a26 s_a26 0 1.65
VS_s_a27 s_a27 0 0
VS_s_a28 s_a28 0 0
VS_s_a29 s_a29 0 0
VS_s_a3 s_a3 0 0
VS_s_a30 s_a30 0 0
VS_s_a31 s_a31 0 1.65
VS_s_a4 s_a4 0 1.65
VS_s_a5 s_a5 0 0
VS_s_a6 s_a6 0 1.65
VS_s_a7 s_a7 0 1.65
VS_s_a8 s_a8 0 0
VS_s_a9 s_a9 0 0
VS_s_d0 s_d0 0 1.65
VS_s_d1 s_d1 0 1.65
VS_s_d10 s_d10 0 1.65
VS_s_d11 s_d11 0 0
VS_s_d12 s_d12 0 1.65
VS_s_d13 s_d13 0 0
VS_s_d14 s_d14 0 0
VS_s_d15 s_d15 0 1.65
VS_s_d16 s_d16 0 0
VS_s_d17 s_d17 0 0
VS_s_d18 s_d18 0 0
VS_s_d19 s_d19 0 0
VS_s_d2 s_d2 0 1.65
VS_s_d20 s_d20 0 0
VS_s_d21 s_d21 0 0
VS_s_d22 s_d22 0 1.65
VS_s_d23 s_d23 0 1.65
VS_s_d24 s_d24 0 1.65
VS_s_d25 s_d25 0 1.65
VS_s_d26 s_d26 0 0
VS_s_d27 s_d27 0 1.65
VS_s_d28 s_d28 0 1.65
VS_s_d29 s_d29 0 0
VS_s_d3 s_d3 0 0
VS_s_d30 s_d30 0 1.65
VS_s_d31 s_d31 0 1.65
VS_s_d4 s_d4 0 1.65
VS_s_d5 s_d5 0 1.65
VS_s_d6 s_d6 0 1.65
VS_s_d7 s_d7 0 0
VS_s_d8 s_d8 0 1.65
VS_s_d9 s_d9 0 0
XINV1_0 o1_0 s_d0 rail1 gn1 sg13g2_inv_1
CL1_0 o1_0 gn1 2f
XINV1_1 o1_1 s_d1 rail1 gn1 sg13g2_inv_1
CL1_1 o1_1 gn1 2f
XINV1_2 o1_2 s_d2 rail1 gn1 sg13g2_inv_1
CL1_2 o1_2 gn1 2f
XINV1_3 o1_3 s_d3 rail1 gn1 sg13g2_inv_1
CL1_3 o1_3 gn1 2f
XINV1_4 o1_4 s_d4 rail1 gn1 sg13g2_inv_1
CL1_4 o1_4 gn1 2f
XINV1_5 o1_5 s_d5 rail1 gn1 sg13g2_inv_1
CL1_5 o1_5 gn1 2f
XINV1_6 o1_6 s_d6 rail1 gn1 sg13g2_inv_1
CL1_6 o1_6 gn1 2f
XINV1_7 o1_7 s_d7 rail1 gn1 sg13g2_inv_1
CL1_7 o1_7 gn1 2f
XINV1_8 o1_8 s_d8 rail1 gn1 sg13g2_inv_1
CL1_8 o1_8 gn1 2f
XINV1_9 o1_9 s_d9 rail1 gn1 sg13g2_inv_1
CL1_9 o1_9 gn1 2f
XINV1_10 o1_10 s_d10 rail1 gn1 sg13g2_inv_1
CL1_10 o1_10 gn1 2f
XINV1_11 o1_11 s_d11 rail1 gn1 sg13g2_inv_1
CL1_11 o1_11 gn1 2f
XINV1_12 o1_12 s_d12 rail1 gn1 sg13g2_inv_1
CL1_12 o1_12 gn1 2f
XINV1_13 o1_13 s_d13 rail1 gn1 sg13g2_inv_1
CL1_13 o1_13 gn1 2f
XINV1_14 o1_14 s_d14 rail1 gn1 sg13g2_inv_1
CL1_14 o1_14 gn1 2f
XINV1_15 o1_15 s_d15 rail1 gn1 sg13g2_inv_1
CL1_15 o1_15 gn1 2f
XINV1_16 o1_16 s_d16 rail1 gn1 sg13g2_inv_1
CL1_16 o1_16 gn1 2f
XINV1_17 o1_17 s_d17 rail1 gn1 sg13g2_inv_1
CL1_17 o1_17 gn1 2f
XINV1_18 o1_18 s_d18 rail1 gn1 sg13g2_inv_1
CL1_18 o1_18 gn1 2f
XINV1_19 o1_19 s_d19 rail1 gn1 sg13g2_inv_1
CL1_19 o1_19 gn1 2f
XINV1_20 o1_20 s_d20 rail1 gn1 sg13g2_inv_1
CL1_20 o1_20 gn1 2f
XINV1_21 o1_21 s_d21 rail1 gn1 sg13g2_inv_1
CL1_21 o1_21 gn1 2f
XINV1_22 o1_22 s_d22 rail1 gn1 sg13g2_inv_1
CL1_22 o1_22 gn1 2f
XINV1_23 o1_23 s_d23 rail1 gn1 sg13g2_inv_1
CL1_23 o1_23 gn1 2f
XINV1_24 o1_24 s_d24 rail1 gn1 sg13g2_inv_1
CL1_24 o1_24 gn1 2f
XINV1_25 o1_25 s_d25 rail1 gn1 sg13g2_inv_1
CL1_25 o1_25 gn1 2f
XINV1_26 o1_26 s_d26 rail1 gn1 sg13g2_inv_1
CL1_26 o1_26 gn1 2f
XINV1_27 o1_27 s_d27 rail1 gn1 sg13g2_inv_1
CL1_27 o1_27 gn1 2f
XINV1_28 o1_28 s_d28 rail1 gn1 sg13g2_inv_1
CL1_28 o1_28 gn1 2f
XINV1_29 o1_29 s_d29 rail1 gn1 sg13g2_inv_1
CL1_29 o1_29 gn1 2f
XINV1_30 o1_30 s_d30 rail1 gn1 sg13g2_inv_1
CL1_30 o1_30 gn1 2f
XINV1_31 o1_31 s_d31 rail1 gn1 sg13g2_inv_1
CL1_31 o1_31 gn1 2f
VMG2 gn2 0 0
XXOR22_0 o2_0 o1_0 s_a0 rail2 gn2 sg13g2_xor2_1
CL2_0 o2_0 gn2 2f
CW2_0 o2_0 gn2 7.767000f
XXOR22_1 o2_1 o1_1 s_a1 rail2 gn2 sg13g2_xor2_1
CL2_1 o2_1 gn2 2f
CW2_1 o2_1 gn2 7.767000f
XXOR22_2 o2_2 o1_2 s_a2 rail2 gn2 sg13g2_xor2_1
CL2_2 o2_2 gn2 2f
CW2_2 o2_2 gn2 7.767000f
XXOR22_3 o2_3 o1_3 s_a3 rail2 gn2 sg13g2_xor2_1
CL2_3 o2_3 gn2 2f
CW2_3 o2_3 gn2 7.767000f
XXOR22_4 o2_4 o1_4 s_a4 rail2 gn2 sg13g2_xor2_1
CL2_4 o2_4 gn2 2f
CW2_4 o2_4 gn2 7.767000f
XXOR22_5 o2_5 o1_5 s_a5 rail2 gn2 sg13g2_xor2_1
CL2_5 o2_5 gn2 2f
CW2_5 o2_5 gn2 7.767000f
XXOR22_6 o2_6 o1_6 s_a6 rail2 gn2 sg13g2_xor2_1
CL2_6 o2_6 gn2 2f
CW2_6 o2_6 gn2 7.767000f
XXOR22_7 o2_7 o1_7 s_a7 rail2 gn2 sg13g2_xor2_1
CL2_7 o2_7 gn2 2f
CW2_7 o2_7 gn2 7.767000f
XXOR22_8 o2_8 o1_8 s_a8 rail2 gn2 sg13g2_xor2_1
CL2_8 o2_8 gn2 2f
CW2_8 o2_8 gn2 7.767000f
XXOR22_9 o2_9 o1_9 s_a9 rail2 gn2 sg13g2_xor2_1
CL2_9 o2_9 gn2 2f
CW2_9 o2_9 gn2 7.767000f
XXOR22_10 o2_10 o1_10 s_a10 rail2 gn2 sg13g2_xor2_1
CL2_10 o2_10 gn2 2f
CW2_10 o2_10 gn2 7.767000f
XXOR22_11 o2_11 o1_11 s_a11 rail2 gn2 sg13g2_xor2_1
CL2_11 o2_11 gn2 2f
CW2_11 o2_11 gn2 7.767000f
XXOR22_12 o2_12 o1_12 s_a12 rail2 gn2 sg13g2_xor2_1
CL2_12 o2_12 gn2 2f
CW2_12 o2_12 gn2 7.767000f
XXOR22_13 o2_13 o1_13 s_a13 rail2 gn2 sg13g2_xor2_1
CL2_13 o2_13 gn2 2f
CW2_13 o2_13 gn2 7.767000f
XXOR22_14 o2_14 o1_14 s_a14 rail2 gn2 sg13g2_xor2_1
CL2_14 o2_14 gn2 2f
CW2_14 o2_14 gn2 7.767000f
XXOR22_15 o2_15 o1_15 s_a15 rail2 gn2 sg13g2_xor2_1
CL2_15 o2_15 gn2 2f
CW2_15 o2_15 gn2 7.767000f
XXOR22_16 o2_16 o1_16 s_a16 rail2 gn2 sg13g2_xor2_1
CL2_16 o2_16 gn2 2f
CW2_16 o2_16 gn2 7.767000f
XXOR22_17 o2_17 o1_17 s_a17 rail2 gn2 sg13g2_xor2_1
CL2_17 o2_17 gn2 2f
CW2_17 o2_17 gn2 7.767000f
XXOR22_18 o2_18 o1_18 s_a18 rail2 gn2 sg13g2_xor2_1
CL2_18 o2_18 gn2 2f
CW2_18 o2_18 gn2 7.767000f
XXOR22_19 o2_19 o1_19 s_a19 rail2 gn2 sg13g2_xor2_1
CL2_19 o2_19 gn2 2f
CW2_19 o2_19 gn2 7.767000f
XXOR22_20 o2_20 o1_20 s_a20 rail2 gn2 sg13g2_xor2_1
CL2_20 o2_20 gn2 2f
CW2_20 o2_20 gn2 7.767000f
XXOR22_21 o2_21 o1_21 s_a21 rail2 gn2 sg13g2_xor2_1
CL2_21 o2_21 gn2 2f
CW2_21 o2_21 gn2 7.767000f
XXOR22_22 o2_22 o1_22 s_a22 rail2 gn2 sg13g2_xor2_1
CL2_22 o2_22 gn2 2f
CW2_22 o2_22 gn2 7.767000f
XXOR22_23 o2_23 o1_23 s_a23 rail2 gn2 sg13g2_xor2_1
CL2_23 o2_23 gn2 2f
CW2_23 o2_23 gn2 7.767000f
XXOR22_24 o2_24 o1_24 s_a24 rail2 gn2 sg13g2_xor2_1
CL2_24 o2_24 gn2 2f
CW2_24 o2_24 gn2 7.767000f
XXOR22_25 o2_25 o1_25 s_a25 rail2 gn2 sg13g2_xor2_1
CL2_25 o2_25 gn2 2f
CW2_25 o2_25 gn2 7.767000f
XXOR22_26 o2_26 o1_26 s_a26 rail2 gn2 sg13g2_xor2_1
CL2_26 o2_26 gn2 2f
CW2_26 o2_26 gn2 7.767000f
XXOR22_27 o2_27 o1_27 s_a27 rail2 gn2 sg13g2_xor2_1
CL2_27 o2_27 gn2 2f
CW2_27 o2_27 gn2 7.767000f
XXOR22_28 o2_28 o1_28 s_a28 rail2 gn2 sg13g2_xor2_1
CL2_28 o2_28 gn2 2f
CW2_28 o2_28 gn2 7.767000f
XXOR22_29 o2_29 o1_29 s_a29 rail2 gn2 sg13g2_xor2_1
CL2_29 o2_29 gn2 2f
CW2_29 o2_29 gn2 7.767000f
XXOR22_30 o2_30 o1_30 s_a30 rail2 gn2 sg13g2_xor2_1
CL2_30 o2_30 gn2 2f
CW2_30 o2_30 gn2 7.767000f
XXOR22_31 o2_31 o1_31 s_a31 rail2 gn2 sg13g2_xor2_1
CL2_31 o2_31 gn2 2f
CW2_31 o2_31 gn2 7.767000f
VMG3 gn3 0 0
XINV3_0 o3_0 o2_16 rail3 gn3 sg13g2_inv_1
CL3_0 o3_0 gn3 2f
XINV3_1 o3_1 o2_17 rail3 gn3 sg13g2_inv_1
CL3_1 o3_1 gn3 2f
XINV3_2 o3_2 o2_18 rail3 gn3 sg13g2_inv_1
CL3_2 o3_2 gn3 2f
XINV3_3 o3_3 o2_19 rail3 gn3 sg13g2_inv_1
CL3_3 o3_3 gn3 2f
XINV3_4 o3_4 o2_20 rail3 gn3 sg13g2_inv_1
CL3_4 o3_4 gn3 2f
XINV3_5 o3_5 o2_21 rail3 gn3 sg13g2_inv_1
CL3_5 o3_5 gn3 2f
XINV3_6 o3_6 o2_22 rail3 gn3 sg13g2_inv_1
CL3_6 o3_6 gn3 2f
XINV3_7 o3_7 o2_23 rail3 gn3 sg13g2_inv_1
CL3_7 o3_7 gn3 2f
XINV3_8 o3_8 o2_24 rail3 gn3 sg13g2_inv_1
CL3_8 o3_8 gn3 2f
XINV3_9 o3_9 o2_25 rail3 gn3 sg13g2_inv_1
CL3_9 o3_9 gn3 2f
XINV3_10 o3_10 o2_26 rail3 gn3 sg13g2_inv_1
CL3_10 o3_10 gn3 2f
XINV3_11 o3_11 o2_27 rail3 gn3 sg13g2_inv_1
CL3_11 o3_11 gn3 2f
XINV3_12 o3_12 o2_28 rail3 gn3 sg13g2_inv_1
CL3_12 o3_12 gn3 2f
XINV3_13 o3_13 o2_29 rail3 gn3 sg13g2_inv_1
CL3_13 o3_13 gn3 2f
XINV3_14 o3_14 o2_30 rail3 gn3 sg13g2_inv_1
CL3_14 o3_14 gn3 2f
XINV3_15 o3_15 o2_31 rail3 gn3 sg13g2_inv_1
CL3_15 o3_15 gn3 2f
XINV3_16 o3_16 o2_0 rail3 gn3 sg13g2_inv_1
CL3_16 o3_16 gn3 2f
XINV3_17 o3_17 o2_1 rail3 gn3 sg13g2_inv_1
CL3_17 o3_17 gn3 2f
XINV3_18 o3_18 o2_2 rail3 gn3 sg13g2_inv_1
CL3_18 o3_18 gn3 2f
XINV3_19 o3_19 o2_3 rail3 gn3 sg13g2_inv_1
CL3_19 o3_19 gn3 2f
XINV3_20 o3_20 o2_4 rail3 gn3 sg13g2_inv_1
CL3_20 o3_20 gn3 2f
XINV3_21 o3_21 o2_5 rail3 gn3 sg13g2_inv_1
CL3_21 o3_21 gn3 2f
XINV3_22 o3_22 o2_6 rail3 gn3 sg13g2_inv_1
CL3_22 o3_22 gn3 2f
XINV3_23 o3_23 o2_7 rail3 gn3 sg13g2_inv_1
CL3_23 o3_23 gn3 2f
XINV3_24 o3_24 o2_8 rail3 gn3 sg13g2_inv_1
CL3_24 o3_24 gn3 2f
XINV3_25 o3_25 o2_9 rail3 gn3 sg13g2_inv_1
CL3_25 o3_25 gn3 2f
XINV3_26 o3_26 o2_10 rail3 gn3 sg13g2_inv_1
CL3_26 o3_26 gn3 2f
XINV3_27 o3_27 o2_11 rail3 gn3 sg13g2_inv_1
CL3_27 o3_27 gn3 2f
XINV3_28 o3_28 o2_12 rail3 gn3 sg13g2_inv_1
CL3_28 o3_28 gn3 2f
XINV3_29 o3_29 o2_13 rail3 gn3 sg13g2_inv_1
CL3_29 o3_29 gn3 2f
XINV3_30 o3_30 o2_14 rail3 gn3 sg13g2_inv_1
CL3_30 o3_30 gn3 2f
XINV3_31 o3_31 o2_15 rail3 gn3 sg13g2_inv_1
CL3_31 o3_31 gn3 2f
CT1 tnk1 0 1439.16f
L1 tnk1 mid1 15n
R1 mid1 sw1 10
XSWN1 sw1 gt1 rail1 0 sg13_lv_nmos w=20u l=0.13u
XSWP1 sw1 gtp1 rail1 vhi sg13_lv_pmos w=40u l=0.13u
XPK1 sw1 pk1 tnk1 tnk1 sg13_lv_nmos w=4u l=0.13u
CT2 tnk2 0 7121.24f
L2 tnk2 mid2 15n
R2 mid2 sw2 10
XSWN2 sw2 gt2 rail2 0 sg13_lv_nmos w=40u l=0.13u
XSWP2 sw2 gtp2 rail2 vhi sg13_lv_pmos w=80u l=0.13u
XPK2 sw2 pk2 tnk2 tnk2 sg13_lv_nmos w=8u l=0.13u
CT3 tnk3 0 1439.16f
L3 tnk3 mid3 15n
R3 mid3 sw3 10
XSWN3 sw3 gt3 rail3 0 sg13_lv_nmos w=20u l=0.13u
XSWP3 sw3 gtp3 rail3 vhi sg13_lv_pmos w=40u l=0.13u
XPK3 sw3 pk3 tnk3 tnk3 sg13_lv_nmos w=4u l=0.13u
VGT1 gt1 0 PWL(0 0 198p 0 200p 1.5 18662p 1.5)
VGTP1 gtp1 0 PWL(0 1.5 198p 1.5 200p 0 18662p 0)
VPK1 pk1 0 PWL(0 1.5 198p 1.5 200p 0 18662p 0)
VGT2 gt2 0 0
VGTP2 gtp2 0 1.5
VPK2 pk2 0 1.5
VGT3 gt3 0 0
VGTP3 gtp3 0 1.5
VPK3 pk3 0 1.5
.ic V(tnk1)=0.9075 V(rail1)=0 V(sw1)=0.9075 V(tnk2)=0.9075 V(rail2)=0 V(sw2)=0.9075 V(tnk3)=0.9075 V(rail3)=0 V(sw3)=0.9075
.tran 0.1p 671.564p 0 0.25p
.print tran I(L1) I(L2) I(L3) V(rail1) V(rail2) V(rail3) V(tnk1) V(tnk2) V(tnk3)
.end
