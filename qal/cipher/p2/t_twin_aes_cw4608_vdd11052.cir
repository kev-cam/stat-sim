.hdl "/usr/local/share/xyce/verilog-a/psp103/psp103.va"
.include "/usr/local/src/kestrel/sim/models/sg13g2_psp103_tt.lib"
.include "/usr/local/src/stat-sim/qal/sg13lv_compat.sp"
.OPTIONS TIMEINT METHOD=GEAR RELTOL=1e-6 ABSTOL=1e-15 CHGTOL=1e-17
.include "/usr/local/src/IHP-Open-PDK/ihp-sg13g2/libs.ref/sg13g2_stdcell/spice/sg13g2_stdcell.spice"
VDD vdd 0 1.10522
VGNDM gnm 0 0
VS_rk0 s_rk0 0 PWL(0 0 200p 0 202p 1.65 1700p 1.65 1702p 0)
VS_rk1 s_rk1 0 PWL(0 1.65 200p 1.65 202p 0 1700p 0 1702p 1.65)
VS_rk10 s_rk10 0 PWL(0 0 200p 0 202p 1.65 1700p 1.65 1702p 0)
VS_rk100 s_rk100 0 PWL(0 1.65 200p 1.65 202p 0 1700p 0 1702p 1.65)
VS_rk101 s_rk101 0 PWL(0 0 200p 0 202p 1.65 1700p 1.65 1702p 0)
VS_rk102 s_rk102 0 PWL(0 1.65 200p 1.65 202p 0 1700p 0 1702p 1.65)
VS_rk103 s_rk103 0 PWL(0 0 200p 0 202p 1.65 1700p 1.65 1702p 0)
VS_rk104 s_rk104 0 PWL(0 1.65 200p 1.65 202p 0 1700p 0 1702p 1.65)
VS_rk105 s_rk105 0 PWL(0 1.65 200p 1.65 202p 0 1700p 0 1702p 1.65)
VS_rk106 s_rk106 0 PWL(0 1.65 200p 1.65 202p 0 1700p 0 1702p 1.65)
VS_rk107 s_rk107 0 PWL(0 0 200p 0 202p 1.65 1700p 1.65 1702p 0)
VS_rk108 s_rk108 0 PWL(0 1.65 200p 1.65 202p 0 1700p 0 1702p 1.65)
VS_rk109 s_rk109 0 PWL(0 1.65 200p 1.65 202p 0 1700p 0 1702p 1.65)
VS_rk11 s_rk11 0 PWL(0 0 200p 0 202p 1.65 1700p 1.65 1702p 0)
VS_rk110 s_rk110 0 PWL(0 1.65 200p 1.65 202p 0 1700p 0 1702p 1.65)
VS_rk111 s_rk111 0 PWL(0 0 200p 0 202p 1.65 1700p 1.65 1702p 0)
VS_rk112 s_rk112 0 PWL(0 0 200p 0 202p 1.65 1700p 1.65 1702p 0)
VS_rk113 s_rk113 0 PWL(0 0 200p 0 202p 1.65 1700p 1.65 1702p 0)
VS_rk114 s_rk114 0 PWL(0 0 200p 0 202p 1.65 1700p 1.65 1702p 0)
VS_rk115 s_rk115 0 PWL(0 1.65 200p 1.65 202p 0 1700p 0 1702p 1.65)
VS_rk116 s_rk116 0 PWL(0 1.65 200p 1.65 202p 0 1700p 0 1702p 1.65)
VS_rk117 s_rk117 0 PWL(0 0 200p 0 202p 1.65 1700p 1.65 1702p 0)
VS_rk118 s_rk118 0 PWL(0 0 200p 0 202p 1.65 1700p 1.65 1702p 0)
VS_rk119 s_rk119 0 PWL(0 1.65 200p 1.65 202p 0 1700p 0 1702p 1.65)
VS_rk12 s_rk12 0 PWL(0 1.65 200p 1.65 202p 0 1700p 0 1702p 1.65)
VS_rk120 s_rk120 0 PWL(0 1.65 200p 1.65 202p 0 1700p 0 1702p 1.65)
VS_rk121 s_rk121 0 PWL(0 0 200p 0 202p 1.65 1700p 1.65 1702p 0)
VS_rk122 s_rk122 0 PWL(0 1.65 200p 1.65 202p 0 1700p 0 1702p 1.65)
VS_rk123 s_rk123 0 PWL(0 1.65 200p 1.65 202p 0 1700p 0 1702p 1.65)
VS_rk124 s_rk124 0 PWL(0 1.65 200p 1.65 202p 0 1700p 0 1702p 1.65)
VS_rk125 s_rk125 0 PWL(0 1.65 200p 1.65 202p 0 1700p 0 1702p 1.65)
VS_rk126 s_rk126 0 PWL(0 0 200p 0 202p 1.65 1700p 1.65 1702p 0)
VS_rk127 s_rk127 0 PWL(0 1.65 200p 1.65 202p 0 1700p 0 1702p 1.65)
VS_rk13 s_rk13 0 PWL(0 0 200p 0 202p 1.65 1700p 1.65 1702p 0)
VS_rk14 s_rk14 0 PWL(0 0 200p 0 202p 1.65 1700p 1.65 1702p 0)
VS_rk15 s_rk15 0 PWL(0 0 200p 0 202p 1.65 1700p 1.65 1702p 0)
VS_rk16 s_rk16 0 PWL(0 0 200p 0 202p 1.65 1700p 1.65 1702p 0)
VS_rk17 s_rk17 0 PWL(0 0 200p 0 202p 1.65 1700p 1.65 1702p 0)
VS_rk18 s_rk18 0 PWL(0 1.65 200p 1.65 202p 0 1700p 0 1702p 1.65)
VS_rk19 s_rk19 0 PWL(0 0 200p 0 202p 1.65 1700p 1.65 1702p 0)
VS_rk2 s_rk2 0 PWL(0 1.65 200p 1.65 202p 0 1700p 0 1702p 1.65)
VS_rk20 s_rk20 0 PWL(0 1.65 200p 1.65 202p 0 1700p 0 1702p 1.65)
VS_rk21 s_rk21 0 PWL(0 1.65 200p 1.65 202p 0 1700p 0 1702p 1.65)
VS_rk22 s_rk22 0 PWL(0 0 200p 0 202p 1.65 1700p 1.65 1702p 0)
VS_rk23 s_rk23 0 PWL(0 0 200p 0 202p 1.65 1700p 1.65 1702p 0)
VS_rk24 s_rk24 0 PWL(0 1.65 200p 1.65 202p 0 1700p 0 1702p 1.65)
VS_rk25 s_rk25 0 PWL(0 0 200p 0 202p 1.65 1700p 1.65 1702p 0)
VS_rk26 s_rk26 0 PWL(0 0 200p 0 202p 1.65 1700p 1.65 1702p 0)
VS_rk27 s_rk27 0 PWL(0 1.65 200p 1.65 202p 0 1700p 0 1702p 1.65)
VS_rk28 s_rk28 0 PWL(0 1.65 200p 1.65 202p 0 1700p 0 1702p 1.65)
VS_rk29 s_rk29 0 PWL(0 0 200p 0 202p 1.65 1700p 1.65 1702p 0)
VS_rk3 s_rk3 0 PWL(0 1.65 200p 1.65 202p 0 1700p 0 1702p 1.65)
VS_rk30 s_rk30 0 PWL(0 1.65 200p 1.65 202p 0 1700p 0 1702p 1.65)
VS_rk31 s_rk31 0 PWL(0 0 200p 0 202p 1.65 1700p 1.65 1702p 0)
VS_rk32 s_rk32 0 PWL(0 0 200p 0 202p 1.65 1700p 1.65 1702p 0)
VS_rk33 s_rk33 0 PWL(0 1.65 200p 1.65 202p 0 1700p 0 1702p 1.65)
VS_rk34 s_rk34 0 PWL(0 0 200p 0 202p 1.65 1700p 1.65 1702p 0)
VS_rk35 s_rk35 0 PWL(0 1.65 200p 1.65 202p 0 1700p 0 1702p 1.65)
VS_rk36 s_rk36 0 PWL(0 1.65 200p 1.65 202p 0 1700p 0 1702p 1.65)
VS_rk37 s_rk37 0 PWL(0 1.65 200p 1.65 202p 0 1700p 0 1702p 1.65)
VS_rk38 s_rk38 0 PWL(0 1.65 200p 1.65 202p 0 1700p 0 1702p 1.65)
VS_rk39 s_rk39 0 PWL(0 0 200p 0 202p 1.65 1700p 1.65 1702p 0)
VS_rk4 s_rk4 0 PWL(0 0 200p 0 202p 1.65 1700p 1.65 1702p 0)
VS_rk40 s_rk40 0 PWL(0 1.65 200p 1.65 202p 0 1700p 0 1702p 1.65)
VS_rk41 s_rk41 0 PWL(0 1.65 200p 1.65 202p 0 1700p 0 1702p 1.65)
VS_rk42 s_rk42 0 PWL(0 1.65 200p 1.65 202p 0 1700p 0 1702p 1.65)
VS_rk43 s_rk43 0 PWL(0 1.65 200p 1.65 202p 0 1700p 0 1702p 1.65)
VS_rk44 s_rk44 0 PWL(0 1.65 200p 1.65 202p 0 1700p 0 1702p 1.65)
VS_rk45 s_rk45 0 PWL(0 0 200p 0 202p 1.65 1700p 1.65 1702p 0)
VS_rk46 s_rk46 0 PWL(0 0 200p 0 202p 1.65 1700p 1.65 1702p 0)
VS_rk47 s_rk47 0 PWL(0 1.65 200p 1.65 202p 0 1700p 0 1702p 1.65)
VS_rk48 s_rk48 0 PWL(0 0 200p 0 202p 1.65 1700p 1.65 1702p 0)
VS_rk49 s_rk49 0 PWL(0 0 200p 0 202p 1.65 1700p 1.65 1702p 0)
VS_rk5 s_rk5 0 PWL(0 0 200p 0 202p 1.65 1700p 1.65 1702p 0)
VS_rk50 s_rk50 0 PWL(0 0 200p 0 202p 1.65 1700p 1.65 1702p 0)
VS_rk51 s_rk51 0 PWL(0 0 200p 0 202p 1.65 1700p 1.65 1702p 0)
VS_rk52 s_rk52 0 PWL(0 0 200p 0 202p 1.65 1700p 1.65 1702p 0)
VS_rk53 s_rk53 0 PWL(0 1.65 200p 1.65 202p 0 1700p 0 1702p 1.65)
VS_rk54 s_rk54 0 PWL(0 0 200p 0 202p 1.65 1700p 1.65 1702p 0)
VS_rk55 s_rk55 0 PWL(0 1.65 200p 1.65 202p 0 1700p 0 1702p 1.65)
VS_rk56 s_rk56 0 PWL(0 1.65 200p 1.65 202p 0 1700p 0 1702p 1.65)
VS_rk57 s_rk57 0 PWL(0 0 200p 0 202p 1.65 1700p 1.65 1702p 0)
VS_rk58 s_rk58 0 PWL(0 1.65 200p 1.65 202p 0 1700p 0 1702p 1.65)
VS_rk59 s_rk59 0 PWL(0 0 200p 0 202p 1.65 1700p 1.65 1702p 0)
VS_rk6 s_rk6 0 PWL(0 0 200p 0 202p 1.65 1700p 1.65 1702p 0)
VS_rk60 s_rk60 0 PWL(0 0 200p 0 202p 1.65 1700p 1.65 1702p 0)
VS_rk61 s_rk61 0 PWL(0 0 200p 0 202p 1.65 1700p 1.65 1702p 0)
VS_rk62 s_rk62 0 PWL(0 1.65 200p 1.65 202p 0 1700p 0 1702p 1.65)
VS_rk63 s_rk63 0 PWL(0 1.65 200p 1.65 202p 0 1700p 0 1702p 1.65)
VS_rk64 s_rk64 0 PWL(0 0 200p 0 202p 1.65 1700p 1.65 1702p 0)
VS_rk65 s_rk65 0 PWL(0 1.65 200p 1.65 202p 0 1700p 0 1702p 1.65)
VS_rk66 s_rk66 0 PWL(0 1.65 200p 1.65 202p 0 1700p 0 1702p 1.65)
VS_rk67 s_rk67 0 PWL(0 0 200p 0 202p 1.65 1700p 1.65 1702p 0)
VS_rk68 s_rk68 0 PWL(0 0 200p 0 202p 1.65 1700p 1.65 1702p 0)
VS_rk69 s_rk69 0 PWL(0 1.65 200p 1.65 202p 0 1700p 0 1702p 1.65)
VS_rk7 s_rk7 0 PWL(0 0 200p 0 202p 1.65 1700p 1.65 1702p 0)
VS_rk70 s_rk70 0 PWL(0 1.65 200p 1.65 202p 0 1700p 0 1702p 1.65)
VS_rk71 s_rk71 0 PWL(0 1.65 200p 1.65 202p 0 1700p 0 1702p 1.65)
VS_rk72 s_rk72 0 PWL(0 1.65 200p 1.65 202p 0 1700p 0 1702p 1.65)
VS_rk73 s_rk73 0 PWL(0 1.65 200p 1.65 202p 0 1700p 0 1702p 1.65)
VS_rk74 s_rk74 0 PWL(0 0 200p 0 202p 1.65 1700p 1.65 1702p 0)
VS_rk75 s_rk75 0 PWL(0 1.65 200p 1.65 202p 0 1700p 0 1702p 1.65)
VS_rk76 s_rk76 0 PWL(0 0 200p 0 202p 1.65 1700p 1.65 1702p 0)
VS_rk77 s_rk77 0 PWL(0 0 200p 0 202p 1.65 1700p 1.65 1702p 0)
VS_rk78 s_rk78 0 PWL(0 0 200p 0 202p 1.65 1700p 1.65 1702p 0)
VS_rk79 s_rk79 0 PWL(0 0 200p 0 202p 1.65 1700p 1.65 1702p 0)
VS_rk8 s_rk8 0 PWL(0 1.65 200p 1.65 202p 0 1700p 0 1702p 1.65)
VS_rk80 s_rk80 0 PWL(0 0 200p 0 202p 1.65 1700p 1.65 1702p 0)
VS_rk81 s_rk81 0 PWL(0 0 200p 0 202p 1.65 1700p 1.65 1702p 0)
VS_rk82 s_rk82 0 PWL(0 1.65 200p 1.65 202p 0 1700p 0 1702p 1.65)
VS_rk83 s_rk83 0 PWL(0 1.65 200p 1.65 202p 0 1700p 0 1702p 1.65)
VS_rk84 s_rk84 0 PWL(0 0 200p 0 202p 1.65 1700p 1.65 1702p 0)
VS_rk85 s_rk85 0 PWL(0 1.65 200p 1.65 202p 0 1700p 0 1702p 1.65)
VS_rk86 s_rk86 0 PWL(0 0 200p 0 202p 1.65 1700p 1.65 1702p 0)
VS_rk87 s_rk87 0 PWL(0 0 200p 0 202p 1.65 1700p 1.65 1702p 0)
VS_rk88 s_rk88 0 PWL(0 1.65 200p 1.65 202p 0 1700p 0 1702p 1.65)
VS_rk89 s_rk89 0 PWL(0 0 200p 0 202p 1.65 1700p 1.65 1702p 0)
VS_rk9 s_rk9 0 PWL(0 1.65 200p 1.65 202p 0 1700p 0 1702p 1.65)
VS_rk90 s_rk90 0 PWL(0 0 200p 0 202p 1.65 1700p 1.65 1702p 0)
VS_rk91 s_rk91 0 PWL(0 0 200p 0 202p 1.65 1700p 1.65 1702p 0)
VS_rk92 s_rk92 0 PWL(0 1.65 200p 1.65 202p 0 1700p 0 1702p 1.65)
VS_rk93 s_rk93 0 PWL(0 1.65 200p 1.65 202p 0 1700p 0 1702p 1.65)
VS_rk94 s_rk94 0 PWL(0 0 200p 0 202p 1.65 1700p 1.65 1702p 0)
VS_rk95 s_rk95 0 PWL(0 0 200p 0 202p 1.65 1700p 1.65 1702p 0)
VS_rk96 s_rk96 0 PWL(0 0 200p 0 202p 1.65 1700p 1.65 1702p 0)
VS_rk97 s_rk97 0 PWL(0 1.65 200p 1.65 202p 0 1700p 0 1702p 1.65)
VS_rk98 s_rk98 0 PWL(0 0 200p 0 202p 1.65 1700p 1.65 1702p 0)
VS_rk99 s_rk99 0 PWL(0 0 200p 0 202p 1.65 1700p 1.65 1702p 0)
VS_st0 s_st0 0 0
VS_st1 s_st1 0 1.65
VS_st10 s_st10 0 0
VS_st100 s_st100 0 1.65
VS_st101 s_st101 0 0
VS_st102 s_st102 0 1.65
VS_st103 s_st103 0 1.65
VS_st104 s_st104 0 0
VS_st105 s_st105 0 1.65
VS_st106 s_st106 0 0
VS_st107 s_st107 0 1.65
VS_st108 s_st108 0 1.65
VS_st109 s_st109 0 1.65
VS_st11 s_st11 0 1.65
VS_st110 s_st110 0 1.65
VS_st111 s_st111 0 1.65
VS_st112 s_st112 0 0
VS_st113 s_st113 0 1.65
VS_st114 s_st114 0 0
VS_st115 s_st115 0 1.65
VS_st116 s_st116 0 1.65
VS_st117 s_st117 0 0
VS_st118 s_st118 0 0
VS_st119 s_st119 0 0
VS_st12 s_st12 0 1.65
VS_st120 s_st120 0 0
VS_st121 s_st121 0 1.65
VS_st122 s_st122 0 0
VS_st123 s_st123 0 1.65
VS_st124 s_st124 0 1.65
VS_st125 s_st125 0 1.65
VS_st126 s_st126 0 0
VS_st127 s_st127 0 0
VS_st13 s_st13 0 1.65
VS_st14 s_st14 0 1.65
VS_st15 s_st15 0 0
VS_st16 s_st16 0 0
VS_st17 s_st17 0 1.65
VS_st18 s_st18 0 0
VS_st19 s_st19 0 1.65
VS_st2 s_st2 0 0
VS_st20 s_st20 0 1.65
VS_st21 s_st21 0 0
VS_st22 s_st22 0 0
VS_st23 s_st23 0 1.65
VS_st24 s_st24 0 0
VS_st25 s_st25 0 1.65
VS_st26 s_st26 0 0
VS_st27 s_st27 0 1.65
VS_st28 s_st28 0 1.65
VS_st29 s_st29 0 1.65
VS_st3 s_st3 0 1.65
VS_st30 s_st30 0 0
VS_st31 s_st31 0 1.65
VS_st32 s_st32 0 0
VS_st33 s_st33 0 1.65
VS_st34 s_st34 0 0
VS_st35 s_st35 0 1.65
VS_st36 s_st36 0 1.65
VS_st37 s_st37 0 0
VS_st38 s_st38 0 1.65
VS_st39 s_st39 0 1.65
VS_st4 s_st4 0 1.65
VS_st40 s_st40 0 0
VS_st41 s_st41 0 1.65
VS_st42 s_st42 0 0
VS_st43 s_st43 0 1.65
VS_st44 s_st44 0 1.65
VS_st45 s_st45 0 1.65
VS_st46 s_st46 0 1.65
VS_st47 s_st47 0 1.65
VS_st48 s_st48 0 0
VS_st49 s_st49 0 1.65
VS_st5 s_st5 0 0
VS_st50 s_st50 0 0
VS_st51 s_st51 0 1.65
VS_st52 s_st52 0 1.65
VS_st53 s_st53 0 0
VS_st54 s_st54 0 0
VS_st55 s_st55 0 0
VS_st56 s_st56 0 0
VS_st57 s_st57 0 1.65
VS_st58 s_st58 0 0
VS_st59 s_st59 0 1.65
VS_st6 s_st6 0 1.65
VS_st60 s_st60 0 1.65
VS_st61 s_st61 0 1.65
VS_st62 s_st62 0 0
VS_st63 s_st63 0 0
VS_st64 s_st64 0 0
VS_st65 s_st65 0 1.65
VS_st66 s_st66 0 0
VS_st67 s_st67 0 1.65
VS_st68 s_st68 0 1.65
VS_st69 s_st69 0 0
VS_st7 s_st7 0 0
VS_st70 s_st70 0 1.65
VS_st71 s_st71 0 0
VS_st72 s_st72 0 0
VS_st73 s_st73 0 1.65
VS_st74 s_st74 0 0
VS_st75 s_st75 0 1.65
VS_st76 s_st76 0 1.65
VS_st77 s_st77 0 1.65
VS_st78 s_st78 0 1.65
VS_st79 s_st79 0 0
VS_st8 s_st8 0 0
VS_st80 s_st80 0 0
VS_st81 s_st81 0 1.65
VS_st82 s_st82 0 0
VS_st83 s_st83 0 1.65
VS_st84 s_st84 0 1.65
VS_st85 s_st85 0 0
VS_st86 s_st86 0 0
VS_st87 s_st87 0 1.65
VS_st88 s_st88 0 0
VS_st89 s_st89 0 1.65
VS_st9 s_st9 0 1.65
VS_st90 s_st90 0 0
VS_st91 s_st91 0 1.65
VS_st92 s_st92 0 1.65
VS_st93 s_st93 0 1.65
VS_st94 s_st94 0 0
VS_st95 s_st95 0 1.65
VS_st96 s_st96 0 0
VS_st97 s_st97 0 1.65
VS_st98 s_st98 0 0
VS_st99 s_st99 0 1.65
XINV0 n0 s_st0 vdd gnm sg13g2_inv_1
CL0 n0 gnm 2f
XINV1 n1 s_st1 vdd gnm sg13g2_inv_1
CL1 n1 gnm 2f
XINV2 n2 s_st2 vdd gnm sg13g2_inv_1
CL2 n2 gnm 2f
XINV3 n3 s_st3 vdd gnm sg13g2_inv_1
CL3 n3 gnm 2f
XINV4 n4 s_st4 vdd gnm sg13g2_inv_1
CL4 n4 gnm 2f
XINV5 n5 s_st5 vdd gnm sg13g2_inv_1
CL5 n5 gnm 2f
XINV6 n6 s_st6 vdd gnm sg13g2_inv_1
CL6 n6 gnm 2f
XINV7 n7 s_st7 vdd gnm sg13g2_inv_1
CL7 n7 gnm 2f
XINV8 n8 s_st8 vdd gnm sg13g2_inv_1
CL8 n8 gnm 2f
XINV9 n9 s_st9 vdd gnm sg13g2_inv_1
CL9 n9 gnm 2f
XINV10 n10 s_st10 vdd gnm sg13g2_inv_1
CL10 n10 gnm 2f
XINV11 n11 s_st11 vdd gnm sg13g2_inv_1
CL11 n11 gnm 2f
XINV12 n12 s_st12 vdd gnm sg13g2_inv_1
CL12 n12 gnm 2f
XINV13 n13 s_st13 vdd gnm sg13g2_inv_1
CL13 n13 gnm 2f
XINV14 n14 s_st14 vdd gnm sg13g2_inv_1
CL14 n14 gnm 2f
XINV15 n15 s_st15 vdd gnm sg13g2_inv_1
CL15 n15 gnm 2f
XINV16 n16 s_st16 vdd gnm sg13g2_inv_1
CL16 n16 gnm 2f
XINV17 n17 s_st17 vdd gnm sg13g2_inv_1
CL17 n17 gnm 2f
XINV18 n18 s_st18 vdd gnm sg13g2_inv_1
CL18 n18 gnm 2f
XINV19 n19 s_st19 vdd gnm sg13g2_inv_1
CL19 n19 gnm 2f
XINV20 n20 s_st20 vdd gnm sg13g2_inv_1
CL20 n20 gnm 2f
XINV21 n21 s_st21 vdd gnm sg13g2_inv_1
CL21 n21 gnm 2f
XINV22 n22 s_st22 vdd gnm sg13g2_inv_1
CL22 n22 gnm 2f
XINV23 n23 s_st23 vdd gnm sg13g2_inv_1
CL23 n23 gnm 2f
XINV24 n24 s_st24 vdd gnm sg13g2_inv_1
CL24 n24 gnm 2f
XINV25 n25 s_st25 vdd gnm sg13g2_inv_1
CL25 n25 gnm 2f
XINV26 n26 s_st26 vdd gnm sg13g2_inv_1
CL26 n26 gnm 2f
XINV27 n27 s_st27 vdd gnm sg13g2_inv_1
CL27 n27 gnm 2f
XINV28 n28 s_st28 vdd gnm sg13g2_inv_1
CL28 n28 gnm 2f
XINV29 n29 s_st29 vdd gnm sg13g2_inv_1
CL29 n29 gnm 2f
XINV30 n30 s_st30 vdd gnm sg13g2_inv_1
CL30 n30 gnm 2f
XINV31 n31 s_st31 vdd gnm sg13g2_inv_1
CL31 n31 gnm 2f
XINV32 n32 s_st32 vdd gnm sg13g2_inv_1
CL32 n32 gnm 2f
XINV33 n33 s_st33 vdd gnm sg13g2_inv_1
CL33 n33 gnm 2f
XINV34 n34 s_st34 vdd gnm sg13g2_inv_1
CL34 n34 gnm 2f
XINV35 n35 s_st35 vdd gnm sg13g2_inv_1
CL35 n35 gnm 2f
XINV36 n36 s_st36 vdd gnm sg13g2_inv_1
CL36 n36 gnm 2f
XINV37 n37 s_st37 vdd gnm sg13g2_inv_1
CL37 n37 gnm 2f
XINV38 n38 s_st38 vdd gnm sg13g2_inv_1
CL38 n38 gnm 2f
XINV39 n39 s_st39 vdd gnm sg13g2_inv_1
CL39 n39 gnm 2f
XINV40 n40 s_st40 vdd gnm sg13g2_inv_1
CL40 n40 gnm 2f
XINV41 n41 s_st41 vdd gnm sg13g2_inv_1
CL41 n41 gnm 2f
XINV42 n42 s_st42 vdd gnm sg13g2_inv_1
CL42 n42 gnm 2f
XINV43 n43 s_st43 vdd gnm sg13g2_inv_1
CL43 n43 gnm 2f
XINV44 n44 s_st44 vdd gnm sg13g2_inv_1
CL44 n44 gnm 2f
XINV45 n45 s_st45 vdd gnm sg13g2_inv_1
CL45 n45 gnm 2f
XINV46 n46 s_st46 vdd gnm sg13g2_inv_1
CL46 n46 gnm 2f
XINV47 n47 s_st47 vdd gnm sg13g2_inv_1
CL47 n47 gnm 2f
XINV48 n48 s_st48 vdd gnm sg13g2_inv_1
CL48 n48 gnm 2f
XINV49 n49 s_st49 vdd gnm sg13g2_inv_1
CL49 n49 gnm 2f
XINV50 n50 s_st50 vdd gnm sg13g2_inv_1
CL50 n50 gnm 2f
XINV51 n51 s_st51 vdd gnm sg13g2_inv_1
CL51 n51 gnm 2f
XINV52 n52 s_st52 vdd gnm sg13g2_inv_1
CL52 n52 gnm 2f
XINV53 n53 s_st53 vdd gnm sg13g2_inv_1
CL53 n53 gnm 2f
XINV54 n54 s_st54 vdd gnm sg13g2_inv_1
CL54 n54 gnm 2f
XINV55 n55 s_st55 vdd gnm sg13g2_inv_1
CL55 n55 gnm 2f
XINV56 n56 s_st56 vdd gnm sg13g2_inv_1
CL56 n56 gnm 2f
XINV57 n57 s_st57 vdd gnm sg13g2_inv_1
CL57 n57 gnm 2f
XINV58 n58 s_st58 vdd gnm sg13g2_inv_1
CL58 n58 gnm 2f
XINV59 n59 s_st59 vdd gnm sg13g2_inv_1
CL59 n59 gnm 2f
XINV60 n60 s_st60 vdd gnm sg13g2_inv_1
CL60 n60 gnm 2f
XINV61 n61 s_st61 vdd gnm sg13g2_inv_1
CL61 n61 gnm 2f
XINV62 n62 s_st62 vdd gnm sg13g2_inv_1
CL62 n62 gnm 2f
XINV63 n63 s_st63 vdd gnm sg13g2_inv_1
CL63 n63 gnm 2f
XINV64 n64 s_st64 vdd gnm sg13g2_inv_1
CL64 n64 gnm 2f
XINV65 n65 s_st65 vdd gnm sg13g2_inv_1
CL65 n65 gnm 2f
XINV66 n66 s_st66 vdd gnm sg13g2_inv_1
CL66 n66 gnm 2f
XINV67 n67 s_st67 vdd gnm sg13g2_inv_1
CL67 n67 gnm 2f
XINV68 n68 s_st68 vdd gnm sg13g2_inv_1
CL68 n68 gnm 2f
XINV69 n69 s_st69 vdd gnm sg13g2_inv_1
CL69 n69 gnm 2f
XINV70 n70 s_st70 vdd gnm sg13g2_inv_1
CL70 n70 gnm 2f
XINV71 n71 s_st71 vdd gnm sg13g2_inv_1
CL71 n71 gnm 2f
XINV72 n72 s_st72 vdd gnm sg13g2_inv_1
CL72 n72 gnm 2f
XINV73 n73 s_st73 vdd gnm sg13g2_inv_1
CL73 n73 gnm 2f
XINV74 n74 s_st74 vdd gnm sg13g2_inv_1
CL74 n74 gnm 2f
XINV75 n75 s_st75 vdd gnm sg13g2_inv_1
CL75 n75 gnm 2f
XINV76 n76 s_st76 vdd gnm sg13g2_inv_1
CL76 n76 gnm 2f
XINV77 n77 s_st77 vdd gnm sg13g2_inv_1
CL77 n77 gnm 2f
XINV78 n78 s_st78 vdd gnm sg13g2_inv_1
CL78 n78 gnm 2f
XINV79 n79 s_st79 vdd gnm sg13g2_inv_1
CL79 n79 gnm 2f
XINV80 n80 s_st80 vdd gnm sg13g2_inv_1
CL80 n80 gnm 2f
XINV81 n81 s_st81 vdd gnm sg13g2_inv_1
CL81 n81 gnm 2f
XINV82 n82 s_st82 vdd gnm sg13g2_inv_1
CL82 n82 gnm 2f
XINV83 n83 s_st83 vdd gnm sg13g2_inv_1
CL83 n83 gnm 2f
XINV84 n84 s_st84 vdd gnm sg13g2_inv_1
CL84 n84 gnm 2f
XINV85 n85 s_st85 vdd gnm sg13g2_inv_1
CL85 n85 gnm 2f
XINV86 n86 s_st86 vdd gnm sg13g2_inv_1
CL86 n86 gnm 2f
XINV87 n87 s_st87 vdd gnm sg13g2_inv_1
CL87 n87 gnm 2f
XINV88 n88 s_st88 vdd gnm sg13g2_inv_1
CL88 n88 gnm 2f
XINV89 n89 s_st89 vdd gnm sg13g2_inv_1
CL89 n89 gnm 2f
XINV90 n90 s_st90 vdd gnm sg13g2_inv_1
CL90 n90 gnm 2f
XINV91 n91 s_st91 vdd gnm sg13g2_inv_1
CL91 n91 gnm 2f
XINV92 n92 s_st92 vdd gnm sg13g2_inv_1
CL92 n92 gnm 2f
XINV93 n93 s_st93 vdd gnm sg13g2_inv_1
CL93 n93 gnm 2f
XINV94 n94 s_st94 vdd gnm sg13g2_inv_1
CL94 n94 gnm 2f
XINV95 n95 s_st95 vdd gnm sg13g2_inv_1
CL95 n95 gnm 2f
XINV96 n96 s_st96 vdd gnm sg13g2_inv_1
CL96 n96 gnm 2f
XINV97 n97 s_st97 vdd gnm sg13g2_inv_1
CL97 n97 gnm 2f
XINV98 n98 s_st98 vdd gnm sg13g2_inv_1
CL98 n98 gnm 2f
XINV99 n99 s_st99 vdd gnm sg13g2_inv_1
CL99 n99 gnm 2f
XINV100 n100 s_st100 vdd gnm sg13g2_inv_1
CL100 n100 gnm 2f
XINV101 n101 s_st101 vdd gnm sg13g2_inv_1
CL101 n101 gnm 2f
XINV102 n102 s_st102 vdd gnm sg13g2_inv_1
CL102 n102 gnm 2f
XINV103 n103 s_st103 vdd gnm sg13g2_inv_1
CL103 n103 gnm 2f
XINV104 n104 s_st104 vdd gnm sg13g2_inv_1
CL104 n104 gnm 2f
XINV105 n105 s_st105 vdd gnm sg13g2_inv_1
CL105 n105 gnm 2f
XINV106 n106 s_st106 vdd gnm sg13g2_inv_1
CL106 n106 gnm 2f
XINV107 n107 s_st107 vdd gnm sg13g2_inv_1
CL107 n107 gnm 2f
XINV108 n108 s_st108 vdd gnm sg13g2_inv_1
CL108 n108 gnm 2f
XINV109 n109 s_st109 vdd gnm sg13g2_inv_1
CL109 n109 gnm 2f
XINV110 n110 s_st110 vdd gnm sg13g2_inv_1
CL110 n110 gnm 2f
XINV111 n111 s_st111 vdd gnm sg13g2_inv_1
CL111 n111 gnm 2f
XINV112 n112 s_st112 vdd gnm sg13g2_inv_1
CL112 n112 gnm 2f
XINV113 n113 s_st113 vdd gnm sg13g2_inv_1
CL113 n113 gnm 2f
XINV114 n114 s_st114 vdd gnm sg13g2_inv_1
CL114 n114 gnm 2f
XINV115 n115 s_st115 vdd gnm sg13g2_inv_1
CL115 n115 gnm 2f
XINV116 n116 s_st116 vdd gnm sg13g2_inv_1
CL116 n116 gnm 2f
XINV117 n117 s_st117 vdd gnm sg13g2_inv_1
CL117 n117 gnm 2f
XINV118 n118 s_st118 vdd gnm sg13g2_inv_1
CL118 n118 gnm 2f
XINV119 n119 s_st119 vdd gnm sg13g2_inv_1
CL119 n119 gnm 2f
XINV120 n120 s_st120 vdd gnm sg13g2_inv_1
CL120 n120 gnm 2f
XINV121 n121 s_st121 vdd gnm sg13g2_inv_1
CL121 n121 gnm 2f
XINV122 n122 s_st122 vdd gnm sg13g2_inv_1
CL122 n122 gnm 2f
XINV123 n123 s_st123 vdd gnm sg13g2_inv_1
CL123 n123 gnm 2f
XINV124 n124 s_st124 vdd gnm sg13g2_inv_1
CL124 n124 gnm 2f
XINV125 n125 s_st125 vdd gnm sg13g2_inv_1
CL125 n125 gnm 2f
XINV126 n126 s_st126 vdd gnm sg13g2_inv_1
CL126 n126 gnm 2f
XINV127 n127 s_st127 vdd gnm sg13g2_inv_1
CL127 n127 gnm 2f
XXOR2128 n128 n0 s_rk0 vdd gnm sg13g2_xor2_1
CL128 n128 gnm 2f
XXOR2129 n129 n1 s_rk1 vdd gnm sg13g2_xor2_1
CL129 n129 gnm 2f
XXOR2130 n130 n2 s_rk2 vdd gnm sg13g2_xor2_1
CL130 n130 gnm 2f
XXOR2131 n131 n3 s_rk3 vdd gnm sg13g2_xor2_1
CL131 n131 gnm 2f
XXOR2132 n132 n4 s_rk4 vdd gnm sg13g2_xor2_1
CL132 n132 gnm 2f
XXOR2133 n133 n5 s_rk5 vdd gnm sg13g2_xor2_1
CL133 n133 gnm 2f
XXOR2134 n134 n6 s_rk6 vdd gnm sg13g2_xor2_1
CL134 n134 gnm 2f
XXOR2135 n135 n7 s_rk7 vdd gnm sg13g2_xor2_1
CL135 n135 gnm 2f
XXOR2136 n136 n8 s_rk8 vdd gnm sg13g2_xor2_1
CL136 n136 gnm 2f
CW136 n136 gnm 4.608000f
XXOR2137 n137 n9 s_rk9 vdd gnm sg13g2_xor2_1
CL137 n137 gnm 2f
CW137 n137 gnm 4.608000f
XXOR2138 n138 n10 s_rk10 vdd gnm sg13g2_xor2_1
CL138 n138 gnm 2f
CW138 n138 gnm 4.608000f
XXOR2139 n139 n11 s_rk11 vdd gnm sg13g2_xor2_1
CL139 n139 gnm 2f
CW139 n139 gnm 4.608000f
XXOR2140 n140 n12 s_rk12 vdd gnm sg13g2_xor2_1
CL140 n140 gnm 2f
CW140 n140 gnm 4.608000f
XXOR2141 n141 n13 s_rk13 vdd gnm sg13g2_xor2_1
CL141 n141 gnm 2f
CW141 n141 gnm 4.608000f
XXOR2142 n142 n14 s_rk14 vdd gnm sg13g2_xor2_1
CL142 n142 gnm 2f
CW142 n142 gnm 4.608000f
XXOR2143 n143 n15 s_rk15 vdd gnm sg13g2_xor2_1
CL143 n143 gnm 2f
CW143 n143 gnm 4.608000f
XXOR2144 n144 n16 s_rk16 vdd gnm sg13g2_xor2_1
CL144 n144 gnm 2f
CW144 n144 gnm 9.216000f
XXOR2145 n145 n17 s_rk17 vdd gnm sg13g2_xor2_1
CL145 n145 gnm 2f
CW145 n145 gnm 9.216000f
XXOR2146 n146 n18 s_rk18 vdd gnm sg13g2_xor2_1
CL146 n146 gnm 2f
CW146 n146 gnm 9.216000f
XXOR2147 n147 n19 s_rk19 vdd gnm sg13g2_xor2_1
CL147 n147 gnm 2f
CW147 n147 gnm 9.216000f
XXOR2148 n148 n20 s_rk20 vdd gnm sg13g2_xor2_1
CL148 n148 gnm 2f
CW148 n148 gnm 9.216000f
XXOR2149 n149 n21 s_rk21 vdd gnm sg13g2_xor2_1
CL149 n149 gnm 2f
CW149 n149 gnm 9.216000f
XXOR2150 n150 n22 s_rk22 vdd gnm sg13g2_xor2_1
CL150 n150 gnm 2f
CW150 n150 gnm 9.216000f
XXOR2151 n151 n23 s_rk23 vdd gnm sg13g2_xor2_1
CL151 n151 gnm 2f
CW151 n151 gnm 9.216000f
XXOR2152 n152 n24 s_rk24 vdd gnm sg13g2_xor2_1
CL152 n152 gnm 2f
CW152 n152 gnm 4.608000f
XXOR2153 n153 n25 s_rk25 vdd gnm sg13g2_xor2_1
CL153 n153 gnm 2f
CW153 n153 gnm 4.608000f
XXOR2154 n154 n26 s_rk26 vdd gnm sg13g2_xor2_1
CL154 n154 gnm 2f
CW154 n154 gnm 4.608000f
XXOR2155 n155 n27 s_rk27 vdd gnm sg13g2_xor2_1
CL155 n155 gnm 2f
CW155 n155 gnm 4.608000f
XXOR2156 n156 n28 s_rk28 vdd gnm sg13g2_xor2_1
CL156 n156 gnm 2f
CW156 n156 gnm 4.608000f
XXOR2157 n157 n29 s_rk29 vdd gnm sg13g2_xor2_1
CL157 n157 gnm 2f
CW157 n157 gnm 4.608000f
XXOR2158 n158 n30 s_rk30 vdd gnm sg13g2_xor2_1
CL158 n158 gnm 2f
CW158 n158 gnm 4.608000f
XXOR2159 n159 n31 s_rk31 vdd gnm sg13g2_xor2_1
CL159 n159 gnm 2f
CW159 n159 gnm 4.608000f
XXOR2160 n160 n32 s_rk32 vdd gnm sg13g2_xor2_1
CL160 n160 gnm 2f
XXOR2161 n161 n33 s_rk33 vdd gnm sg13g2_xor2_1
CL161 n161 gnm 2f
XXOR2162 n162 n34 s_rk34 vdd gnm sg13g2_xor2_1
CL162 n162 gnm 2f
XXOR2163 n163 n35 s_rk35 vdd gnm sg13g2_xor2_1
CL163 n163 gnm 2f
XXOR2164 n164 n36 s_rk36 vdd gnm sg13g2_xor2_1
CL164 n164 gnm 2f
XXOR2165 n165 n37 s_rk37 vdd gnm sg13g2_xor2_1
CL165 n165 gnm 2f
XXOR2166 n166 n38 s_rk38 vdd gnm sg13g2_xor2_1
CL166 n166 gnm 2f
XXOR2167 n167 n39 s_rk39 vdd gnm sg13g2_xor2_1
CL167 n167 gnm 2f
XXOR2168 n168 n40 s_rk40 vdd gnm sg13g2_xor2_1
CL168 n168 gnm 2f
CW168 n168 gnm 4.608000f
XXOR2169 n169 n41 s_rk41 vdd gnm sg13g2_xor2_1
CL169 n169 gnm 2f
CW169 n169 gnm 4.608000f
XXOR2170 n170 n42 s_rk42 vdd gnm sg13g2_xor2_1
CL170 n170 gnm 2f
CW170 n170 gnm 4.608000f
XXOR2171 n171 n43 s_rk43 vdd gnm sg13g2_xor2_1
CL171 n171 gnm 2f
CW171 n171 gnm 4.608000f
XXOR2172 n172 n44 s_rk44 vdd gnm sg13g2_xor2_1
CL172 n172 gnm 2f
CW172 n172 gnm 4.608000f
XXOR2173 n173 n45 s_rk45 vdd gnm sg13g2_xor2_1
CL173 n173 gnm 2f
CW173 n173 gnm 4.608000f
XXOR2174 n174 n46 s_rk46 vdd gnm sg13g2_xor2_1
CL174 n174 gnm 2f
CW174 n174 gnm 4.608000f
XXOR2175 n175 n47 s_rk47 vdd gnm sg13g2_xor2_1
CL175 n175 gnm 2f
CW175 n175 gnm 4.608000f
XXOR2176 n176 n48 s_rk48 vdd gnm sg13g2_xor2_1
CL176 n176 gnm 2f
CW176 n176 gnm 9.216000f
XXOR2177 n177 n49 s_rk49 vdd gnm sg13g2_xor2_1
CL177 n177 gnm 2f
CW177 n177 gnm 9.216000f
XXOR2178 n178 n50 s_rk50 vdd gnm sg13g2_xor2_1
CL178 n178 gnm 2f
CW178 n178 gnm 9.216000f
XXOR2179 n179 n51 s_rk51 vdd gnm sg13g2_xor2_1
CL179 n179 gnm 2f
CW179 n179 gnm 9.216000f
XXOR2180 n180 n52 s_rk52 vdd gnm sg13g2_xor2_1
CL180 n180 gnm 2f
CW180 n180 gnm 9.216000f
XXOR2181 n181 n53 s_rk53 vdd gnm sg13g2_xor2_1
CL181 n181 gnm 2f
CW181 n181 gnm 9.216000f
XXOR2182 n182 n54 s_rk54 vdd gnm sg13g2_xor2_1
CL182 n182 gnm 2f
CW182 n182 gnm 9.216000f
XXOR2183 n183 n55 s_rk55 vdd gnm sg13g2_xor2_1
CL183 n183 gnm 2f
CW183 n183 gnm 9.216000f
XXOR2184 n184 n56 s_rk56 vdd gnm sg13g2_xor2_1
CL184 n184 gnm 2f
CW184 n184 gnm 4.608000f
XXOR2185 n185 n57 s_rk57 vdd gnm sg13g2_xor2_1
CL185 n185 gnm 2f
CW185 n185 gnm 4.608000f
XXOR2186 n186 n58 s_rk58 vdd gnm sg13g2_xor2_1
CL186 n186 gnm 2f
CW186 n186 gnm 4.608000f
XXOR2187 n187 n59 s_rk59 vdd gnm sg13g2_xor2_1
CL187 n187 gnm 2f
CW187 n187 gnm 4.608000f
XXOR2188 n188 n60 s_rk60 vdd gnm sg13g2_xor2_1
CL188 n188 gnm 2f
CW188 n188 gnm 4.608000f
XXOR2189 n189 n61 s_rk61 vdd gnm sg13g2_xor2_1
CL189 n189 gnm 2f
CW189 n189 gnm 4.608000f
XXOR2190 n190 n62 s_rk62 vdd gnm sg13g2_xor2_1
CL190 n190 gnm 2f
CW190 n190 gnm 4.608000f
XXOR2191 n191 n63 s_rk63 vdd gnm sg13g2_xor2_1
CL191 n191 gnm 2f
CW191 n191 gnm 4.608000f
XXOR2192 n192 n64 s_rk64 vdd gnm sg13g2_xor2_1
CL192 n192 gnm 2f
XXOR2193 n193 n65 s_rk65 vdd gnm sg13g2_xor2_1
CL193 n193 gnm 2f
XXOR2194 n194 n66 s_rk66 vdd gnm sg13g2_xor2_1
CL194 n194 gnm 2f
XXOR2195 n195 n67 s_rk67 vdd gnm sg13g2_xor2_1
CL195 n195 gnm 2f
XXOR2196 n196 n68 s_rk68 vdd gnm sg13g2_xor2_1
CL196 n196 gnm 2f
XXOR2197 n197 n69 s_rk69 vdd gnm sg13g2_xor2_1
CL197 n197 gnm 2f
XXOR2198 n198 n70 s_rk70 vdd gnm sg13g2_xor2_1
CL198 n198 gnm 2f
XXOR2199 n199 n71 s_rk71 vdd gnm sg13g2_xor2_1
CL199 n199 gnm 2f
XXOR2200 n200 n72 s_rk72 vdd gnm sg13g2_xor2_1
CL200 n200 gnm 2f
CW200 n200 gnm 4.608000f
XXOR2201 n201 n73 s_rk73 vdd gnm sg13g2_xor2_1
CL201 n201 gnm 2f
CW201 n201 gnm 4.608000f
XXOR2202 n202 n74 s_rk74 vdd gnm sg13g2_xor2_1
CL202 n202 gnm 2f
CW202 n202 gnm 4.608000f
XXOR2203 n203 n75 s_rk75 vdd gnm sg13g2_xor2_1
CL203 n203 gnm 2f
CW203 n203 gnm 4.608000f
XXOR2204 n204 n76 s_rk76 vdd gnm sg13g2_xor2_1
CL204 n204 gnm 2f
CW204 n204 gnm 4.608000f
XXOR2205 n205 n77 s_rk77 vdd gnm sg13g2_xor2_1
CL205 n205 gnm 2f
CW205 n205 gnm 4.608000f
XXOR2206 n206 n78 s_rk78 vdd gnm sg13g2_xor2_1
CL206 n206 gnm 2f
CW206 n206 gnm 4.608000f
XXOR2207 n207 n79 s_rk79 vdd gnm sg13g2_xor2_1
CL207 n207 gnm 2f
CW207 n207 gnm 4.608000f
XXOR2208 n208 n80 s_rk80 vdd gnm sg13g2_xor2_1
CL208 n208 gnm 2f
CW208 n208 gnm 9.216000f
XXOR2209 n209 n81 s_rk81 vdd gnm sg13g2_xor2_1
CL209 n209 gnm 2f
CW209 n209 gnm 9.216000f
XXOR2210 n210 n82 s_rk82 vdd gnm sg13g2_xor2_1
CL210 n210 gnm 2f
CW210 n210 gnm 9.216000f
XXOR2211 n211 n83 s_rk83 vdd gnm sg13g2_xor2_1
CL211 n211 gnm 2f
CW211 n211 gnm 9.216000f
XXOR2212 n212 n84 s_rk84 vdd gnm sg13g2_xor2_1
CL212 n212 gnm 2f
CW212 n212 gnm 9.216000f
XXOR2213 n213 n85 s_rk85 vdd gnm sg13g2_xor2_1
CL213 n213 gnm 2f
CW213 n213 gnm 9.216000f
XXOR2214 n214 n86 s_rk86 vdd gnm sg13g2_xor2_1
CL214 n214 gnm 2f
CW214 n214 gnm 9.216000f
XXOR2215 n215 n87 s_rk87 vdd gnm sg13g2_xor2_1
CL215 n215 gnm 2f
CW215 n215 gnm 9.216000f
XXOR2216 n216 n88 s_rk88 vdd gnm sg13g2_xor2_1
CL216 n216 gnm 2f
CW216 n216 gnm 4.608000f
XXOR2217 n217 n89 s_rk89 vdd gnm sg13g2_xor2_1
CL217 n217 gnm 2f
CW217 n217 gnm 4.608000f
XXOR2218 n218 n90 s_rk90 vdd gnm sg13g2_xor2_1
CL218 n218 gnm 2f
CW218 n218 gnm 4.608000f
XXOR2219 n219 n91 s_rk91 vdd gnm sg13g2_xor2_1
CL219 n219 gnm 2f
CW219 n219 gnm 4.608000f
XXOR2220 n220 n92 s_rk92 vdd gnm sg13g2_xor2_1
CL220 n220 gnm 2f
CW220 n220 gnm 4.608000f
XXOR2221 n221 n93 s_rk93 vdd gnm sg13g2_xor2_1
CL221 n221 gnm 2f
CW221 n221 gnm 4.608000f
XXOR2222 n222 n94 s_rk94 vdd gnm sg13g2_xor2_1
CL222 n222 gnm 2f
CW222 n222 gnm 4.608000f
XXOR2223 n223 n95 s_rk95 vdd gnm sg13g2_xor2_1
CL223 n223 gnm 2f
CW223 n223 gnm 4.608000f
XXOR2224 n224 n96 s_rk96 vdd gnm sg13g2_xor2_1
CL224 n224 gnm 2f
XXOR2225 n225 n97 s_rk97 vdd gnm sg13g2_xor2_1
CL225 n225 gnm 2f
XXOR2226 n226 n98 s_rk98 vdd gnm sg13g2_xor2_1
CL226 n226 gnm 2f
XXOR2227 n227 n99 s_rk99 vdd gnm sg13g2_xor2_1
CL227 n227 gnm 2f
XXOR2228 n228 n100 s_rk100 vdd gnm sg13g2_xor2_1
CL228 n228 gnm 2f
XXOR2229 n229 n101 s_rk101 vdd gnm sg13g2_xor2_1
CL229 n229 gnm 2f
XXOR2230 n230 n102 s_rk102 vdd gnm sg13g2_xor2_1
CL230 n230 gnm 2f
XXOR2231 n231 n103 s_rk103 vdd gnm sg13g2_xor2_1
CL231 n231 gnm 2f
XXOR2232 n232 n104 s_rk104 vdd gnm sg13g2_xor2_1
CL232 n232 gnm 2f
CW232 n232 gnm 4.608000f
XXOR2233 n233 n105 s_rk105 vdd gnm sg13g2_xor2_1
CL233 n233 gnm 2f
CW233 n233 gnm 4.608000f
XXOR2234 n234 n106 s_rk106 vdd gnm sg13g2_xor2_1
CL234 n234 gnm 2f
CW234 n234 gnm 4.608000f
XXOR2235 n235 n107 s_rk107 vdd gnm sg13g2_xor2_1
CL235 n235 gnm 2f
CW235 n235 gnm 4.608000f
XXOR2236 n236 n108 s_rk108 vdd gnm sg13g2_xor2_1
CL236 n236 gnm 2f
CW236 n236 gnm 4.608000f
XXOR2237 n237 n109 s_rk109 vdd gnm sg13g2_xor2_1
CL237 n237 gnm 2f
CW237 n237 gnm 4.608000f
XXOR2238 n238 n110 s_rk110 vdd gnm sg13g2_xor2_1
CL238 n238 gnm 2f
CW238 n238 gnm 4.608000f
XXOR2239 n239 n111 s_rk111 vdd gnm sg13g2_xor2_1
CL239 n239 gnm 2f
CW239 n239 gnm 4.608000f
XXOR2240 n240 n112 s_rk112 vdd gnm sg13g2_xor2_1
CL240 n240 gnm 2f
CW240 n240 gnm 9.216000f
XXOR2241 n241 n113 s_rk113 vdd gnm sg13g2_xor2_1
CL241 n241 gnm 2f
CW241 n241 gnm 9.216000f
XXOR2242 n242 n114 s_rk114 vdd gnm sg13g2_xor2_1
CL242 n242 gnm 2f
CW242 n242 gnm 9.216000f
XXOR2243 n243 n115 s_rk115 vdd gnm sg13g2_xor2_1
CL243 n243 gnm 2f
CW243 n243 gnm 9.216000f
XXOR2244 n244 n116 s_rk116 vdd gnm sg13g2_xor2_1
CL244 n244 gnm 2f
CW244 n244 gnm 9.216000f
XXOR2245 n245 n117 s_rk117 vdd gnm sg13g2_xor2_1
CL245 n245 gnm 2f
CW245 n245 gnm 9.216000f
XXOR2246 n246 n118 s_rk118 vdd gnm sg13g2_xor2_1
CL246 n246 gnm 2f
CW246 n246 gnm 9.216000f
XXOR2247 n247 n119 s_rk119 vdd gnm sg13g2_xor2_1
CL247 n247 gnm 2f
CW247 n247 gnm 9.216000f
XXOR2248 n248 n120 s_rk120 vdd gnm sg13g2_xor2_1
CL248 n248 gnm 2f
CW248 n248 gnm 4.608000f
XXOR2249 n249 n121 s_rk121 vdd gnm sg13g2_xor2_1
CL249 n249 gnm 2f
CW249 n249 gnm 4.608000f
XXOR2250 n250 n122 s_rk122 vdd gnm sg13g2_xor2_1
CL250 n250 gnm 2f
CW250 n250 gnm 4.608000f
XXOR2251 n251 n123 s_rk123 vdd gnm sg13g2_xor2_1
CL251 n251 gnm 2f
CW251 n251 gnm 4.608000f
XXOR2252 n252 n124 s_rk124 vdd gnm sg13g2_xor2_1
CL252 n252 gnm 2f
CW252 n252 gnm 4.608000f
XXOR2253 n253 n125 s_rk125 vdd gnm sg13g2_xor2_1
CL253 n253 gnm 2f
CW253 n253 gnm 4.608000f
XXOR2254 n254 n126 s_rk126 vdd gnm sg13g2_xor2_1
CL254 n254 gnm 2f
CW254 n254 gnm 4.608000f
XXOR2255 n255 n127 s_rk127 vdd gnm sg13g2_xor2_1
CL255 n255 gnm 2f
CW255 n255 gnm 4.608000f
XINV256 n256 n128 vdd gnm sg13g2_inv_1
CL256 n256 gnm 2f
XINV257 n257 n129 vdd gnm sg13g2_inv_1
CL257 n257 gnm 2f
XINV258 n258 n130 vdd gnm sg13g2_inv_1
CL258 n258 gnm 2f
XINV259 n259 n131 vdd gnm sg13g2_inv_1
CL259 n259 gnm 2f
XINV260 n260 n132 vdd gnm sg13g2_inv_1
CL260 n260 gnm 2f
XINV261 n261 n133 vdd gnm sg13g2_inv_1
CL261 n261 gnm 2f
XINV262 n262 n134 vdd gnm sg13g2_inv_1
CL262 n262 gnm 2f
XINV263 n263 n135 vdd gnm sg13g2_inv_1
CL263 n263 gnm 2f
XINV264 n264 n168 vdd gnm sg13g2_inv_1
CL264 n264 gnm 2f
XINV265 n265 n169 vdd gnm sg13g2_inv_1
CL265 n265 gnm 2f
XINV266 n266 n170 vdd gnm sg13g2_inv_1
CL266 n266 gnm 2f
XINV267 n267 n171 vdd gnm sg13g2_inv_1
CL267 n267 gnm 2f
XINV268 n268 n172 vdd gnm sg13g2_inv_1
CL268 n268 gnm 2f
XINV269 n269 n173 vdd gnm sg13g2_inv_1
CL269 n269 gnm 2f
XINV270 n270 n174 vdd gnm sg13g2_inv_1
CL270 n270 gnm 2f
XINV271 n271 n175 vdd gnm sg13g2_inv_1
CL271 n271 gnm 2f
XINV272 n272 n208 vdd gnm sg13g2_inv_1
CL272 n272 gnm 2f
XINV273 n273 n209 vdd gnm sg13g2_inv_1
CL273 n273 gnm 2f
XINV274 n274 n210 vdd gnm sg13g2_inv_1
CL274 n274 gnm 2f
XINV275 n275 n211 vdd gnm sg13g2_inv_1
CL275 n275 gnm 2f
XINV276 n276 n212 vdd gnm sg13g2_inv_1
CL276 n276 gnm 2f
XINV277 n277 n213 vdd gnm sg13g2_inv_1
CL277 n277 gnm 2f
XINV278 n278 n214 vdd gnm sg13g2_inv_1
CL278 n278 gnm 2f
XINV279 n279 n215 vdd gnm sg13g2_inv_1
CL279 n279 gnm 2f
XINV280 n280 n248 vdd gnm sg13g2_inv_1
CL280 n280 gnm 2f
XINV281 n281 n249 vdd gnm sg13g2_inv_1
CL281 n281 gnm 2f
XINV282 n282 n250 vdd gnm sg13g2_inv_1
CL282 n282 gnm 2f
XINV283 n283 n251 vdd gnm sg13g2_inv_1
CL283 n283 gnm 2f
XINV284 n284 n252 vdd gnm sg13g2_inv_1
CL284 n284 gnm 2f
XINV285 n285 n253 vdd gnm sg13g2_inv_1
CL285 n285 gnm 2f
XINV286 n286 n254 vdd gnm sg13g2_inv_1
CL286 n286 gnm 2f
XINV287 n287 n255 vdd gnm sg13g2_inv_1
CL287 n287 gnm 2f
XINV288 n288 n160 vdd gnm sg13g2_inv_1
CL288 n288 gnm 2f
XINV289 n289 n161 vdd gnm sg13g2_inv_1
CL289 n289 gnm 2f
XINV290 n290 n162 vdd gnm sg13g2_inv_1
CL290 n290 gnm 2f
XINV291 n291 n163 vdd gnm sg13g2_inv_1
CL291 n291 gnm 2f
XINV292 n292 n164 vdd gnm sg13g2_inv_1
CL292 n292 gnm 2f
XINV293 n293 n165 vdd gnm sg13g2_inv_1
CL293 n293 gnm 2f
XINV294 n294 n166 vdd gnm sg13g2_inv_1
CL294 n294 gnm 2f
XINV295 n295 n167 vdd gnm sg13g2_inv_1
CL295 n295 gnm 2f
XINV296 n296 n200 vdd gnm sg13g2_inv_1
CL296 n296 gnm 2f
XINV297 n297 n201 vdd gnm sg13g2_inv_1
CL297 n297 gnm 2f
XINV298 n298 n202 vdd gnm sg13g2_inv_1
CL298 n298 gnm 2f
XINV299 n299 n203 vdd gnm sg13g2_inv_1
CL299 n299 gnm 2f
XINV300 n300 n204 vdd gnm sg13g2_inv_1
CL300 n300 gnm 2f
XINV301 n301 n205 vdd gnm sg13g2_inv_1
CL301 n301 gnm 2f
XINV302 n302 n206 vdd gnm sg13g2_inv_1
CL302 n302 gnm 2f
XINV303 n303 n207 vdd gnm sg13g2_inv_1
CL303 n303 gnm 2f
XINV304 n304 n240 vdd gnm sg13g2_inv_1
CL304 n304 gnm 2f
XINV305 n305 n241 vdd gnm sg13g2_inv_1
CL305 n305 gnm 2f
XINV306 n306 n242 vdd gnm sg13g2_inv_1
CL306 n306 gnm 2f
XINV307 n307 n243 vdd gnm sg13g2_inv_1
CL307 n307 gnm 2f
XINV308 n308 n244 vdd gnm sg13g2_inv_1
CL308 n308 gnm 2f
XINV309 n309 n245 vdd gnm sg13g2_inv_1
CL309 n309 gnm 2f
XINV310 n310 n246 vdd gnm sg13g2_inv_1
CL310 n310 gnm 2f
XINV311 n311 n247 vdd gnm sg13g2_inv_1
CL311 n311 gnm 2f
XINV312 n312 n152 vdd gnm sg13g2_inv_1
CL312 n312 gnm 2f
XINV313 n313 n153 vdd gnm sg13g2_inv_1
CL313 n313 gnm 2f
XINV314 n314 n154 vdd gnm sg13g2_inv_1
CL314 n314 gnm 2f
XINV315 n315 n155 vdd gnm sg13g2_inv_1
CL315 n315 gnm 2f
XINV316 n316 n156 vdd gnm sg13g2_inv_1
CL316 n316 gnm 2f
XINV317 n317 n157 vdd gnm sg13g2_inv_1
CL317 n317 gnm 2f
XINV318 n318 n158 vdd gnm sg13g2_inv_1
CL318 n318 gnm 2f
XINV319 n319 n159 vdd gnm sg13g2_inv_1
CL319 n319 gnm 2f
XINV320 n320 n192 vdd gnm sg13g2_inv_1
CL320 n320 gnm 2f
XINV321 n321 n193 vdd gnm sg13g2_inv_1
CL321 n321 gnm 2f
XINV322 n322 n194 vdd gnm sg13g2_inv_1
CL322 n322 gnm 2f
XINV323 n323 n195 vdd gnm sg13g2_inv_1
CL323 n323 gnm 2f
XINV324 n324 n196 vdd gnm sg13g2_inv_1
CL324 n324 gnm 2f
XINV325 n325 n197 vdd gnm sg13g2_inv_1
CL325 n325 gnm 2f
XINV326 n326 n198 vdd gnm sg13g2_inv_1
CL326 n326 gnm 2f
XINV327 n327 n199 vdd gnm sg13g2_inv_1
CL327 n327 gnm 2f
XINV328 n328 n232 vdd gnm sg13g2_inv_1
CL328 n328 gnm 2f
XINV329 n329 n233 vdd gnm sg13g2_inv_1
CL329 n329 gnm 2f
XINV330 n330 n234 vdd gnm sg13g2_inv_1
CL330 n330 gnm 2f
XINV331 n331 n235 vdd gnm sg13g2_inv_1
CL331 n331 gnm 2f
XINV332 n332 n236 vdd gnm sg13g2_inv_1
CL332 n332 gnm 2f
XINV333 n333 n237 vdd gnm sg13g2_inv_1
CL333 n333 gnm 2f
XINV334 n334 n238 vdd gnm sg13g2_inv_1
CL334 n334 gnm 2f
XINV335 n335 n239 vdd gnm sg13g2_inv_1
CL335 n335 gnm 2f
XINV336 n336 n144 vdd gnm sg13g2_inv_1
CL336 n336 gnm 2f
XINV337 n337 n145 vdd gnm sg13g2_inv_1
CL337 n337 gnm 2f
XINV338 n338 n146 vdd gnm sg13g2_inv_1
CL338 n338 gnm 2f
XINV339 n339 n147 vdd gnm sg13g2_inv_1
CL339 n339 gnm 2f
XINV340 n340 n148 vdd gnm sg13g2_inv_1
CL340 n340 gnm 2f
XINV341 n341 n149 vdd gnm sg13g2_inv_1
CL341 n341 gnm 2f
XINV342 n342 n150 vdd gnm sg13g2_inv_1
CL342 n342 gnm 2f
XINV343 n343 n151 vdd gnm sg13g2_inv_1
CL343 n343 gnm 2f
XINV344 n344 n184 vdd gnm sg13g2_inv_1
CL344 n344 gnm 2f
XINV345 n345 n185 vdd gnm sg13g2_inv_1
CL345 n345 gnm 2f
XINV346 n346 n186 vdd gnm sg13g2_inv_1
CL346 n346 gnm 2f
XINV347 n347 n187 vdd gnm sg13g2_inv_1
CL347 n347 gnm 2f
XINV348 n348 n188 vdd gnm sg13g2_inv_1
CL348 n348 gnm 2f
XINV349 n349 n189 vdd gnm sg13g2_inv_1
CL349 n349 gnm 2f
XINV350 n350 n190 vdd gnm sg13g2_inv_1
CL350 n350 gnm 2f
XINV351 n351 n191 vdd gnm sg13g2_inv_1
CL351 n351 gnm 2f
XINV352 n352 n224 vdd gnm sg13g2_inv_1
CL352 n352 gnm 2f
XINV353 n353 n225 vdd gnm sg13g2_inv_1
CL353 n353 gnm 2f
XINV354 n354 n226 vdd gnm sg13g2_inv_1
CL354 n354 gnm 2f
XINV355 n355 n227 vdd gnm sg13g2_inv_1
CL355 n355 gnm 2f
XINV356 n356 n228 vdd gnm sg13g2_inv_1
CL356 n356 gnm 2f
XINV357 n357 n229 vdd gnm sg13g2_inv_1
CL357 n357 gnm 2f
XINV358 n358 n230 vdd gnm sg13g2_inv_1
CL358 n358 gnm 2f
XINV359 n359 n231 vdd gnm sg13g2_inv_1
CL359 n359 gnm 2f
XINV360 n360 n136 vdd gnm sg13g2_inv_1
CL360 n360 gnm 2f
XINV361 n361 n137 vdd gnm sg13g2_inv_1
CL361 n361 gnm 2f
XINV362 n362 n138 vdd gnm sg13g2_inv_1
CL362 n362 gnm 2f
XINV363 n363 n139 vdd gnm sg13g2_inv_1
CL363 n363 gnm 2f
XINV364 n364 n140 vdd gnm sg13g2_inv_1
CL364 n364 gnm 2f
XINV365 n365 n141 vdd gnm sg13g2_inv_1
CL365 n365 gnm 2f
XINV366 n366 n142 vdd gnm sg13g2_inv_1
CL366 n366 gnm 2f
XINV367 n367 n143 vdd gnm sg13g2_inv_1
CL367 n367 gnm 2f
XINV368 n368 n176 vdd gnm sg13g2_inv_1
CL368 n368 gnm 2f
XINV369 n369 n177 vdd gnm sg13g2_inv_1
CL369 n369 gnm 2f
XINV370 n370 n178 vdd gnm sg13g2_inv_1
CL370 n370 gnm 2f
XINV371 n371 n179 vdd gnm sg13g2_inv_1
CL371 n371 gnm 2f
XINV372 n372 n180 vdd gnm sg13g2_inv_1
CL372 n372 gnm 2f
XINV373 n373 n181 vdd gnm sg13g2_inv_1
CL373 n373 gnm 2f
XINV374 n374 n182 vdd gnm sg13g2_inv_1
CL374 n374 gnm 2f
XINV375 n375 n183 vdd gnm sg13g2_inv_1
CL375 n375 gnm 2f
XINV376 n376 n216 vdd gnm sg13g2_inv_1
CL376 n376 gnm 2f
XINV377 n377 n217 vdd gnm sg13g2_inv_1
CL377 n377 gnm 2f
XINV378 n378 n218 vdd gnm sg13g2_inv_1
CL378 n378 gnm 2f
XINV379 n379 n219 vdd gnm sg13g2_inv_1
CL379 n379 gnm 2f
XINV380 n380 n220 vdd gnm sg13g2_inv_1
CL380 n380 gnm 2f
XINV381 n381 n221 vdd gnm sg13g2_inv_1
CL381 n381 gnm 2f
XINV382 n382 n222 vdd gnm sg13g2_inv_1
CL382 n382 gnm 2f
XINV383 n383 n223 vdd gnm sg13g2_inv_1
CL383 n383 gnm 2f
CXqvdd xqvdd 0 1
BXqvdd 0 xqvdd I={ -I(VDD) }
RXqvdd xqvdd 0 0.01
.tran 0.1p 2202p 0 0.25p
.measure tran QVDD_Z FIND V(xqvdd) AT=1.500000p
.measure tran QVDD_A FIND V(xqvdd) AT=201.000000p
.measure tran QVDD_B FIND V(xqvdd) AT=1701.000000p
.measure tran QVDD_D FIND V(xqvdd) AT=2198.000000p
.measure tran M_n256 FIND V(n256) AT=2198.000000p
.measure tran C_n256 FIND V(n256) AT=1696.000000p
.measure tran M_n257 FIND V(n257) AT=2198.000000p
.measure tran C_n257 FIND V(n257) AT=1696.000000p
.measure tran M_n258 FIND V(n258) AT=2198.000000p
.measure tran C_n258 FIND V(n258) AT=1696.000000p
.measure tran M_n259 FIND V(n259) AT=2198.000000p
.measure tran C_n259 FIND V(n259) AT=1696.000000p
.measure tran M_n260 FIND V(n260) AT=2198.000000p
.measure tran C_n260 FIND V(n260) AT=1696.000000p
.measure tran M_n261 FIND V(n261) AT=2198.000000p
.measure tran C_n261 FIND V(n261) AT=1696.000000p
.measure tran M_n262 FIND V(n262) AT=2198.000000p
.measure tran C_n262 FIND V(n262) AT=1696.000000p
.measure tran M_n263 FIND V(n263) AT=2198.000000p
.measure tran C_n263 FIND V(n263) AT=1696.000000p
.measure tran M_n264 FIND V(n264) AT=2198.000000p
.measure tran C_n264 FIND V(n264) AT=1696.000000p
.measure tran M_n265 FIND V(n265) AT=2198.000000p
.measure tran C_n265 FIND V(n265) AT=1696.000000p
.measure tran M_n266 FIND V(n266) AT=2198.000000p
.measure tran C_n266 FIND V(n266) AT=1696.000000p
.measure tran M_n267 FIND V(n267) AT=2198.000000p
.measure tran C_n267 FIND V(n267) AT=1696.000000p
.measure tran M_n268 FIND V(n268) AT=2198.000000p
.measure tran C_n268 FIND V(n268) AT=1696.000000p
.measure tran M_n269 FIND V(n269) AT=2198.000000p
.measure tran C_n269 FIND V(n269) AT=1696.000000p
.measure tran M_n270 FIND V(n270) AT=2198.000000p
.measure tran C_n270 FIND V(n270) AT=1696.000000p
.measure tran M_n271 FIND V(n271) AT=2198.000000p
.measure tran C_n271 FIND V(n271) AT=1696.000000p
.measure tran M_n272 FIND V(n272) AT=2198.000000p
.measure tran C_n272 FIND V(n272) AT=1696.000000p
.measure tran M_n273 FIND V(n273) AT=2198.000000p
.measure tran C_n273 FIND V(n273) AT=1696.000000p
.measure tran M_n274 FIND V(n274) AT=2198.000000p
.measure tran C_n274 FIND V(n274) AT=1696.000000p
.measure tran M_n275 FIND V(n275) AT=2198.000000p
.measure tran C_n275 FIND V(n275) AT=1696.000000p
.measure tran M_n276 FIND V(n276) AT=2198.000000p
.measure tran C_n276 FIND V(n276) AT=1696.000000p
.measure tran M_n277 FIND V(n277) AT=2198.000000p
.measure tran C_n277 FIND V(n277) AT=1696.000000p
.measure tran M_n278 FIND V(n278) AT=2198.000000p
.measure tran C_n278 FIND V(n278) AT=1696.000000p
.measure tran M_n279 FIND V(n279) AT=2198.000000p
.measure tran C_n279 FIND V(n279) AT=1696.000000p
.measure tran M_n280 FIND V(n280) AT=2198.000000p
.measure tran C_n280 FIND V(n280) AT=1696.000000p
.measure tran M_n281 FIND V(n281) AT=2198.000000p
.measure tran C_n281 FIND V(n281) AT=1696.000000p
.measure tran M_n282 FIND V(n282) AT=2198.000000p
.measure tran C_n282 FIND V(n282) AT=1696.000000p
.measure tran M_n283 FIND V(n283) AT=2198.000000p
.measure tran C_n283 FIND V(n283) AT=1696.000000p
.measure tran M_n284 FIND V(n284) AT=2198.000000p
.measure tran C_n284 FIND V(n284) AT=1696.000000p
.measure tran M_n285 FIND V(n285) AT=2198.000000p
.measure tran C_n285 FIND V(n285) AT=1696.000000p
.measure tran M_n286 FIND V(n286) AT=2198.000000p
.measure tran C_n286 FIND V(n286) AT=1696.000000p
.measure tran M_n287 FIND V(n287) AT=2198.000000p
.measure tran C_n287 FIND V(n287) AT=1696.000000p
.measure tran M_n288 FIND V(n288) AT=2198.000000p
.measure tran C_n288 FIND V(n288) AT=1696.000000p
.measure tran M_n289 FIND V(n289) AT=2198.000000p
.measure tran C_n289 FIND V(n289) AT=1696.000000p
.measure tran M_n290 FIND V(n290) AT=2198.000000p
.measure tran C_n290 FIND V(n290) AT=1696.000000p
.measure tran M_n291 FIND V(n291) AT=2198.000000p
.measure tran C_n291 FIND V(n291) AT=1696.000000p
.measure tran M_n292 FIND V(n292) AT=2198.000000p
.measure tran C_n292 FIND V(n292) AT=1696.000000p
.measure tran M_n293 FIND V(n293) AT=2198.000000p
.measure tran C_n293 FIND V(n293) AT=1696.000000p
.measure tran M_n294 FIND V(n294) AT=2198.000000p
.measure tran C_n294 FIND V(n294) AT=1696.000000p
.measure tran M_n295 FIND V(n295) AT=2198.000000p
.measure tran C_n295 FIND V(n295) AT=1696.000000p
.measure tran M_n296 FIND V(n296) AT=2198.000000p
.measure tran C_n296 FIND V(n296) AT=1696.000000p
.measure tran M_n297 FIND V(n297) AT=2198.000000p
.measure tran C_n297 FIND V(n297) AT=1696.000000p
.measure tran M_n298 FIND V(n298) AT=2198.000000p
.measure tran C_n298 FIND V(n298) AT=1696.000000p
.measure tran M_n299 FIND V(n299) AT=2198.000000p
.measure tran C_n299 FIND V(n299) AT=1696.000000p
.measure tran M_n300 FIND V(n300) AT=2198.000000p
.measure tran C_n300 FIND V(n300) AT=1696.000000p
.measure tran M_n301 FIND V(n301) AT=2198.000000p
.measure tran C_n301 FIND V(n301) AT=1696.000000p
.measure tran M_n302 FIND V(n302) AT=2198.000000p
.measure tran C_n302 FIND V(n302) AT=1696.000000p
.measure tran M_n303 FIND V(n303) AT=2198.000000p
.measure tran C_n303 FIND V(n303) AT=1696.000000p
.measure tran M_n304 FIND V(n304) AT=2198.000000p
.measure tran C_n304 FIND V(n304) AT=1696.000000p
.measure tran M_n305 FIND V(n305) AT=2198.000000p
.measure tran C_n305 FIND V(n305) AT=1696.000000p
.measure tran M_n306 FIND V(n306) AT=2198.000000p
.measure tran C_n306 FIND V(n306) AT=1696.000000p
.measure tran M_n307 FIND V(n307) AT=2198.000000p
.measure tran C_n307 FIND V(n307) AT=1696.000000p
.measure tran M_n308 FIND V(n308) AT=2198.000000p
.measure tran C_n308 FIND V(n308) AT=1696.000000p
.measure tran M_n309 FIND V(n309) AT=2198.000000p
.measure tran C_n309 FIND V(n309) AT=1696.000000p
.measure tran M_n310 FIND V(n310) AT=2198.000000p
.measure tran C_n310 FIND V(n310) AT=1696.000000p
.measure tran M_n311 FIND V(n311) AT=2198.000000p
.measure tran C_n311 FIND V(n311) AT=1696.000000p
.measure tran M_n312 FIND V(n312) AT=2198.000000p
.measure tran C_n312 FIND V(n312) AT=1696.000000p
.measure tran M_n313 FIND V(n313) AT=2198.000000p
.measure tran C_n313 FIND V(n313) AT=1696.000000p
.measure tran M_n314 FIND V(n314) AT=2198.000000p
.measure tran C_n314 FIND V(n314) AT=1696.000000p
.measure tran M_n315 FIND V(n315) AT=2198.000000p
.measure tran C_n315 FIND V(n315) AT=1696.000000p
.measure tran M_n316 FIND V(n316) AT=2198.000000p
.measure tran C_n316 FIND V(n316) AT=1696.000000p
.measure tran M_n317 FIND V(n317) AT=2198.000000p
.measure tran C_n317 FIND V(n317) AT=1696.000000p
.measure tran M_n318 FIND V(n318) AT=2198.000000p
.measure tran C_n318 FIND V(n318) AT=1696.000000p
.measure tran M_n319 FIND V(n319) AT=2198.000000p
.measure tran C_n319 FIND V(n319) AT=1696.000000p
.measure tran M_n320 FIND V(n320) AT=2198.000000p
.measure tran C_n320 FIND V(n320) AT=1696.000000p
.measure tran M_n321 FIND V(n321) AT=2198.000000p
.measure tran C_n321 FIND V(n321) AT=1696.000000p
.measure tran M_n322 FIND V(n322) AT=2198.000000p
.measure tran C_n322 FIND V(n322) AT=1696.000000p
.measure tran M_n323 FIND V(n323) AT=2198.000000p
.measure tran C_n323 FIND V(n323) AT=1696.000000p
.measure tran M_n324 FIND V(n324) AT=2198.000000p
.measure tran C_n324 FIND V(n324) AT=1696.000000p
.measure tran M_n325 FIND V(n325) AT=2198.000000p
.measure tran C_n325 FIND V(n325) AT=1696.000000p
.measure tran M_n326 FIND V(n326) AT=2198.000000p
.measure tran C_n326 FIND V(n326) AT=1696.000000p
.measure tran M_n327 FIND V(n327) AT=2198.000000p
.measure tran C_n327 FIND V(n327) AT=1696.000000p
.measure tran M_n328 FIND V(n328) AT=2198.000000p
.measure tran C_n328 FIND V(n328) AT=1696.000000p
.measure tran M_n329 FIND V(n329) AT=2198.000000p
.measure tran C_n329 FIND V(n329) AT=1696.000000p
.measure tran M_n330 FIND V(n330) AT=2198.000000p
.measure tran C_n330 FIND V(n330) AT=1696.000000p
.measure tran M_n331 FIND V(n331) AT=2198.000000p
.measure tran C_n331 FIND V(n331) AT=1696.000000p
.measure tran M_n332 FIND V(n332) AT=2198.000000p
.measure tran C_n332 FIND V(n332) AT=1696.000000p
.measure tran M_n333 FIND V(n333) AT=2198.000000p
.measure tran C_n333 FIND V(n333) AT=1696.000000p
.measure tran M_n334 FIND V(n334) AT=2198.000000p
.measure tran C_n334 FIND V(n334) AT=1696.000000p
.measure tran M_n335 FIND V(n335) AT=2198.000000p
.measure tran C_n335 FIND V(n335) AT=1696.000000p
.measure tran M_n336 FIND V(n336) AT=2198.000000p
.measure tran C_n336 FIND V(n336) AT=1696.000000p
.measure tran M_n337 FIND V(n337) AT=2198.000000p
.measure tran C_n337 FIND V(n337) AT=1696.000000p
.measure tran M_n338 FIND V(n338) AT=2198.000000p
.measure tran C_n338 FIND V(n338) AT=1696.000000p
.measure tran M_n339 FIND V(n339) AT=2198.000000p
.measure tran C_n339 FIND V(n339) AT=1696.000000p
.measure tran M_n340 FIND V(n340) AT=2198.000000p
.measure tran C_n340 FIND V(n340) AT=1696.000000p
.measure tran M_n341 FIND V(n341) AT=2198.000000p
.measure tran C_n341 FIND V(n341) AT=1696.000000p
.measure tran M_n342 FIND V(n342) AT=2198.000000p
.measure tran C_n342 FIND V(n342) AT=1696.000000p
.measure tran M_n343 FIND V(n343) AT=2198.000000p
.measure tran C_n343 FIND V(n343) AT=1696.000000p
.measure tran M_n344 FIND V(n344) AT=2198.000000p
.measure tran C_n344 FIND V(n344) AT=1696.000000p
.measure tran M_n345 FIND V(n345) AT=2198.000000p
.measure tran C_n345 FIND V(n345) AT=1696.000000p
.measure tran M_n346 FIND V(n346) AT=2198.000000p
.measure tran C_n346 FIND V(n346) AT=1696.000000p
.measure tran M_n347 FIND V(n347) AT=2198.000000p
.measure tran C_n347 FIND V(n347) AT=1696.000000p
.measure tran M_n348 FIND V(n348) AT=2198.000000p
.measure tran C_n348 FIND V(n348) AT=1696.000000p
.measure tran M_n349 FIND V(n349) AT=2198.000000p
.measure tran C_n349 FIND V(n349) AT=1696.000000p
.measure tran M_n350 FIND V(n350) AT=2198.000000p
.measure tran C_n350 FIND V(n350) AT=1696.000000p
.measure tran M_n351 FIND V(n351) AT=2198.000000p
.measure tran C_n351 FIND V(n351) AT=1696.000000p
.measure tran M_n352 FIND V(n352) AT=2198.000000p
.measure tran C_n352 FIND V(n352) AT=1696.000000p
.measure tran M_n353 FIND V(n353) AT=2198.000000p
.measure tran C_n353 FIND V(n353) AT=1696.000000p
.measure tran M_n354 FIND V(n354) AT=2198.000000p
.measure tran C_n354 FIND V(n354) AT=1696.000000p
.measure tran M_n355 FIND V(n355) AT=2198.000000p
.measure tran C_n355 FIND V(n355) AT=1696.000000p
.measure tran M_n356 FIND V(n356) AT=2198.000000p
.measure tran C_n356 FIND V(n356) AT=1696.000000p
.measure tran M_n357 FIND V(n357) AT=2198.000000p
.measure tran C_n357 FIND V(n357) AT=1696.000000p
.measure tran M_n358 FIND V(n358) AT=2198.000000p
.measure tran C_n358 FIND V(n358) AT=1696.000000p
.measure tran M_n359 FIND V(n359) AT=2198.000000p
.measure tran C_n359 FIND V(n359) AT=1696.000000p
.measure tran M_n360 FIND V(n360) AT=2198.000000p
.measure tran C_n360 FIND V(n360) AT=1696.000000p
.measure tran M_n361 FIND V(n361) AT=2198.000000p
.measure tran C_n361 FIND V(n361) AT=1696.000000p
.measure tran M_n362 FIND V(n362) AT=2198.000000p
.measure tran C_n362 FIND V(n362) AT=1696.000000p
.measure tran M_n363 FIND V(n363) AT=2198.000000p
.measure tran C_n363 FIND V(n363) AT=1696.000000p
.measure tran M_n364 FIND V(n364) AT=2198.000000p
.measure tran C_n364 FIND V(n364) AT=1696.000000p
.measure tran M_n365 FIND V(n365) AT=2198.000000p
.measure tran C_n365 FIND V(n365) AT=1696.000000p
.measure tran M_n366 FIND V(n366) AT=2198.000000p
.measure tran C_n366 FIND V(n366) AT=1696.000000p
.measure tran M_n367 FIND V(n367) AT=2198.000000p
.measure tran C_n367 FIND V(n367) AT=1696.000000p
.measure tran M_n368 FIND V(n368) AT=2198.000000p
.measure tran C_n368 FIND V(n368) AT=1696.000000p
.measure tran M_n369 FIND V(n369) AT=2198.000000p
.measure tran C_n369 FIND V(n369) AT=1696.000000p
.measure tran M_n370 FIND V(n370) AT=2198.000000p
.measure tran C_n370 FIND V(n370) AT=1696.000000p
.measure tran M_n371 FIND V(n371) AT=2198.000000p
.measure tran C_n371 FIND V(n371) AT=1696.000000p
.measure tran M_n372 FIND V(n372) AT=2198.000000p
.measure tran C_n372 FIND V(n372) AT=1696.000000p
.measure tran M_n373 FIND V(n373) AT=2198.000000p
.measure tran C_n373 FIND V(n373) AT=1696.000000p
.measure tran M_n374 FIND V(n374) AT=2198.000000p
.measure tran C_n374 FIND V(n374) AT=1696.000000p
.measure tran M_n375 FIND V(n375) AT=2198.000000p
.measure tran C_n375 FIND V(n375) AT=1696.000000p
.measure tran M_n376 FIND V(n376) AT=2198.000000p
.measure tran C_n376 FIND V(n376) AT=1696.000000p
.measure tran M_n377 FIND V(n377) AT=2198.000000p
.measure tran C_n377 FIND V(n377) AT=1696.000000p
.measure tran M_n378 FIND V(n378) AT=2198.000000p
.measure tran C_n378 FIND V(n378) AT=1696.000000p
.measure tran M_n379 FIND V(n379) AT=2198.000000p
.measure tran C_n379 FIND V(n379) AT=1696.000000p
.measure tran M_n380 FIND V(n380) AT=2198.000000p
.measure tran C_n380 FIND V(n380) AT=1696.000000p
.measure tran M_n381 FIND V(n381) AT=2198.000000p
.measure tran C_n381 FIND V(n381) AT=1696.000000p
.measure tran M_n382 FIND V(n382) AT=2198.000000p
.measure tran C_n382 FIND V(n382) AT=1696.000000p
.measure tran M_n383 FIND V(n383) AT=2198.000000p
.measure tran C_n383 FIND V(n383) AT=1696.000000p
.print tran V(vdd) I(VDD) V(xqvdd) V(n256) V(n257) V(n258) V(n259) V(n260) V(n261) V(n262) V(n263) V(n264) V(n265) V(n266) V(n267) V(n268) V(n269) V(n270) V(n271) V(n272) V(n273) V(n274) V(n275) V(n276) V(n277) V(n278) V(n279) V(n280) V(n281) V(n282) V(n283) V(n284) V(n285) V(n286) V(n287) V(n288) V(n289) V(n290) V(n291) V(n292) V(n293) V(n294) V(n295) V(n296) V(n297) V(n298) V(n299) V(n300) V(n301) V(n302) V(n303) V(n304) V(n305) V(n306) V(n307) V(n308) V(n309) V(n310) V(n311) V(n312) V(n313) V(n314) V(n315) V(n316) V(n317) V(n318) V(n319) V(n320) V(n321) V(n322) V(n323) V(n324) V(n325) V(n326) V(n327) V(n328) V(n329) V(n330) V(n331) V(n332) V(n333) V(n334) V(n335) V(n336) V(n337) V(n338) V(n339) V(n340) V(n341) V(n342) V(n343) V(n344) V(n345) V(n346) V(n347) V(n348) V(n349) V(n350) V(n351) V(n352) V(n353) V(n354) V(n355) V(n356) V(n357) V(n358) V(n359) V(n360) V(n361) V(n362) V(n363) V(n364) V(n365) V(n366) V(n367) V(n368) V(n369) V(n370) V(n371) V(n372) V(n373) V(n374) V(n375) V(n376) V(n377) V(n378) V(n379) V(n380) V(n381) V(n382) V(n383)
.end
