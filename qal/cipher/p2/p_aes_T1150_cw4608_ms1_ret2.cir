.hdl "/usr/local/share/xyce/verilog-a/psp103/psp103.va"
.include "/usr/local/src/kestrel/sim/models/sg13g2_psp103_tt.lib"
.include "/usr/local/src/stat-sim/qal/sg13lv_compat.sp"
.OPTIONS TIMEINT METHOD=GEAR RELTOL=1e-6 ABSTOL=1e-15 CHGTOL=1e-17
.include "/usr/local/src/IHP-Open-PDK/ihp-sg13g2/libs.ref/sg13g2_stdcell/spice/sg13g2_stdcell.spice"
VHI vhi 0 1.5
VMG1 gn1 0 0
VS_s_rk0 s_rk0 0 0
VS_s_rk1 s_rk1 0 1.65
VS_s_rk10 s_rk10 0 0
VS_s_rk100 s_rk100 0 1.65
VS_s_rk101 s_rk101 0 0
VS_s_rk102 s_rk102 0 1.65
VS_s_rk103 s_rk103 0 0
VS_s_rk104 s_rk104 0 1.65
VS_s_rk105 s_rk105 0 1.65
VS_s_rk106 s_rk106 0 1.65
VS_s_rk107 s_rk107 0 0
VS_s_rk108 s_rk108 0 1.65
VS_s_rk109 s_rk109 0 1.65
VS_s_rk11 s_rk11 0 0
VS_s_rk110 s_rk110 0 1.65
VS_s_rk111 s_rk111 0 0
VS_s_rk112 s_rk112 0 0
VS_s_rk113 s_rk113 0 0
VS_s_rk114 s_rk114 0 0
VS_s_rk115 s_rk115 0 1.65
VS_s_rk116 s_rk116 0 1.65
VS_s_rk117 s_rk117 0 0
VS_s_rk118 s_rk118 0 0
VS_s_rk119 s_rk119 0 1.65
VS_s_rk12 s_rk12 0 1.65
VS_s_rk120 s_rk120 0 1.65
VS_s_rk121 s_rk121 0 0
VS_s_rk122 s_rk122 0 1.65
VS_s_rk123 s_rk123 0 1.65
VS_s_rk124 s_rk124 0 1.65
VS_s_rk125 s_rk125 0 1.65
VS_s_rk126 s_rk126 0 0
VS_s_rk127 s_rk127 0 1.65
VS_s_rk13 s_rk13 0 0
VS_s_rk14 s_rk14 0 0
VS_s_rk15 s_rk15 0 0
VS_s_rk16 s_rk16 0 0
VS_s_rk17 s_rk17 0 0
VS_s_rk18 s_rk18 0 1.65
VS_s_rk19 s_rk19 0 0
VS_s_rk2 s_rk2 0 1.65
VS_s_rk20 s_rk20 0 1.65
VS_s_rk21 s_rk21 0 1.65
VS_s_rk22 s_rk22 0 0
VS_s_rk23 s_rk23 0 0
VS_s_rk24 s_rk24 0 1.65
VS_s_rk25 s_rk25 0 0
VS_s_rk26 s_rk26 0 0
VS_s_rk27 s_rk27 0 1.65
VS_s_rk28 s_rk28 0 1.65
VS_s_rk29 s_rk29 0 0
VS_s_rk3 s_rk3 0 1.65
VS_s_rk30 s_rk30 0 1.65
VS_s_rk31 s_rk31 0 0
VS_s_rk32 s_rk32 0 0
VS_s_rk33 s_rk33 0 1.65
VS_s_rk34 s_rk34 0 0
VS_s_rk35 s_rk35 0 1.65
VS_s_rk36 s_rk36 0 1.65
VS_s_rk37 s_rk37 0 1.65
VS_s_rk38 s_rk38 0 1.65
VS_s_rk39 s_rk39 0 0
VS_s_rk4 s_rk4 0 0
VS_s_rk40 s_rk40 0 1.65
VS_s_rk41 s_rk41 0 1.65
VS_s_rk42 s_rk42 0 1.65
VS_s_rk43 s_rk43 0 1.65
VS_s_rk44 s_rk44 0 1.65
VS_s_rk45 s_rk45 0 0
VS_s_rk46 s_rk46 0 0
VS_s_rk47 s_rk47 0 1.65
VS_s_rk48 s_rk48 0 0
VS_s_rk49 s_rk49 0 0
VS_s_rk5 s_rk5 0 0
VS_s_rk50 s_rk50 0 0
VS_s_rk51 s_rk51 0 0
VS_s_rk52 s_rk52 0 0
VS_s_rk53 s_rk53 0 1.65
VS_s_rk54 s_rk54 0 0
VS_s_rk55 s_rk55 0 1.65
VS_s_rk56 s_rk56 0 1.65
VS_s_rk57 s_rk57 0 0
VS_s_rk58 s_rk58 0 1.65
VS_s_rk59 s_rk59 0 0
VS_s_rk6 s_rk6 0 0
VS_s_rk60 s_rk60 0 0
VS_s_rk61 s_rk61 0 0
VS_s_rk62 s_rk62 0 1.65
VS_s_rk63 s_rk63 0 1.65
VS_s_rk64 s_rk64 0 0
VS_s_rk65 s_rk65 0 1.65
VS_s_rk66 s_rk66 0 1.65
VS_s_rk67 s_rk67 0 0
VS_s_rk68 s_rk68 0 0
VS_s_rk69 s_rk69 0 1.65
VS_s_rk7 s_rk7 0 0
VS_s_rk70 s_rk70 0 1.65
VS_s_rk71 s_rk71 0 1.65
VS_s_rk72 s_rk72 0 1.65
VS_s_rk73 s_rk73 0 1.65
VS_s_rk74 s_rk74 0 0
VS_s_rk75 s_rk75 0 1.65
VS_s_rk76 s_rk76 0 0
VS_s_rk77 s_rk77 0 0
VS_s_rk78 s_rk78 0 0
VS_s_rk79 s_rk79 0 0
VS_s_rk8 s_rk8 0 1.65
VS_s_rk80 s_rk80 0 0
VS_s_rk81 s_rk81 0 0
VS_s_rk82 s_rk82 0 1.65
VS_s_rk83 s_rk83 0 1.65
VS_s_rk84 s_rk84 0 0
VS_s_rk85 s_rk85 0 1.65
VS_s_rk86 s_rk86 0 0
VS_s_rk87 s_rk87 0 0
VS_s_rk88 s_rk88 0 1.65
VS_s_rk89 s_rk89 0 0
VS_s_rk9 s_rk9 0 1.65
VS_s_rk90 s_rk90 0 0
VS_s_rk91 s_rk91 0 0
VS_s_rk92 s_rk92 0 1.65
VS_s_rk93 s_rk93 0 1.65
VS_s_rk94 s_rk94 0 0
VS_s_rk95 s_rk95 0 0
VS_s_rk96 s_rk96 0 0
VS_s_rk97 s_rk97 0 1.65
VS_s_rk98 s_rk98 0 0
VS_s_rk99 s_rk99 0 0
VS_s_st0 s_st0 0 0
VS_s_st1 s_st1 0 1.65
VS_s_st10 s_st10 0 0
VS_s_st100 s_st100 0 1.65
VS_s_st101 s_st101 0 0
VS_s_st102 s_st102 0 1.65
VS_s_st103 s_st103 0 1.65
VS_s_st104 s_st104 0 0
VS_s_st105 s_st105 0 1.65
VS_s_st106 s_st106 0 0
VS_s_st107 s_st107 0 1.65
VS_s_st108 s_st108 0 1.65
VS_s_st109 s_st109 0 1.65
VS_s_st11 s_st11 0 1.65
VS_s_st110 s_st110 0 1.65
VS_s_st111 s_st111 0 1.65
VS_s_st112 s_st112 0 0
VS_s_st113 s_st113 0 1.65
VS_s_st114 s_st114 0 0
VS_s_st115 s_st115 0 1.65
VS_s_st116 s_st116 0 1.65
VS_s_st117 s_st117 0 0
VS_s_st118 s_st118 0 0
VS_s_st119 s_st119 0 0
VS_s_st12 s_st12 0 1.65
VS_s_st120 s_st120 0 0
VS_s_st121 s_st121 0 1.65
VS_s_st122 s_st122 0 0
VS_s_st123 s_st123 0 1.65
VS_s_st124 s_st124 0 1.65
VS_s_st125 s_st125 0 1.65
VS_s_st126 s_st126 0 0
VS_s_st127 s_st127 0 0
VS_s_st13 s_st13 0 1.65
VS_s_st14 s_st14 0 1.65
VS_s_st15 s_st15 0 0
VS_s_st16 s_st16 0 0
VS_s_st17 s_st17 0 1.65
VS_s_st18 s_st18 0 0
VS_s_st19 s_st19 0 1.65
VS_s_st2 s_st2 0 0
VS_s_st20 s_st20 0 1.65
VS_s_st21 s_st21 0 0
VS_s_st22 s_st22 0 0
VS_s_st23 s_st23 0 1.65
VS_s_st24 s_st24 0 0
VS_s_st25 s_st25 0 1.65
VS_s_st26 s_st26 0 0
VS_s_st27 s_st27 0 1.65
VS_s_st28 s_st28 0 1.65
VS_s_st29 s_st29 0 1.65
VS_s_st3 s_st3 0 1.65
VS_s_st30 s_st30 0 0
VS_s_st31 s_st31 0 1.65
VS_s_st32 s_st32 0 0
VS_s_st33 s_st33 0 1.65
VS_s_st34 s_st34 0 0
VS_s_st35 s_st35 0 1.65
VS_s_st36 s_st36 0 1.65
VS_s_st37 s_st37 0 0
VS_s_st38 s_st38 0 1.65
VS_s_st39 s_st39 0 1.65
VS_s_st4 s_st4 0 1.65
VS_s_st40 s_st40 0 0
VS_s_st41 s_st41 0 1.65
VS_s_st42 s_st42 0 0
VS_s_st43 s_st43 0 1.65
VS_s_st44 s_st44 0 1.65
VS_s_st45 s_st45 0 1.65
VS_s_st46 s_st46 0 1.65
VS_s_st47 s_st47 0 1.65
VS_s_st48 s_st48 0 0
VS_s_st49 s_st49 0 1.65
VS_s_st5 s_st5 0 0
VS_s_st50 s_st50 0 0
VS_s_st51 s_st51 0 1.65
VS_s_st52 s_st52 0 1.65
VS_s_st53 s_st53 0 0
VS_s_st54 s_st54 0 0
VS_s_st55 s_st55 0 0
VS_s_st56 s_st56 0 0
VS_s_st57 s_st57 0 1.65
VS_s_st58 s_st58 0 0
VS_s_st59 s_st59 0 1.65
VS_s_st6 s_st6 0 1.65
VS_s_st60 s_st60 0 1.65
VS_s_st61 s_st61 0 1.65
VS_s_st62 s_st62 0 0
VS_s_st63 s_st63 0 0
VS_s_st64 s_st64 0 0
VS_s_st65 s_st65 0 1.65
VS_s_st66 s_st66 0 0
VS_s_st67 s_st67 0 1.65
VS_s_st68 s_st68 0 1.65
VS_s_st69 s_st69 0 0
VS_s_st7 s_st7 0 0
VS_s_st70 s_st70 0 1.65
VS_s_st71 s_st71 0 0
VS_s_st72 s_st72 0 0
VS_s_st73 s_st73 0 1.65
VS_s_st74 s_st74 0 0
VS_s_st75 s_st75 0 1.65
VS_s_st76 s_st76 0 1.65
VS_s_st77 s_st77 0 1.65
VS_s_st78 s_st78 0 1.65
VS_s_st79 s_st79 0 0
VS_s_st8 s_st8 0 0
VS_s_st80 s_st80 0 0
VS_s_st81 s_st81 0 1.65
VS_s_st82 s_st82 0 0
VS_s_st83 s_st83 0 1.65
VS_s_st84 s_st84 0 1.65
VS_s_st85 s_st85 0 0
VS_s_st86 s_st86 0 0
VS_s_st87 s_st87 0 1.65
VS_s_st88 s_st88 0 0
VS_s_st89 s_st89 0 1.65
VS_s_st9 s_st9 0 1.65
VS_s_st90 s_st90 0 0
VS_s_st91 s_st91 0 1.65
VS_s_st92 s_st92 0 1.65
VS_s_st93 s_st93 0 1.65
VS_s_st94 s_st94 0 0
VS_s_st95 s_st95 0 1.65
VS_s_st96 s_st96 0 0
VS_s_st97 s_st97 0 1.65
VS_s_st98 s_st98 0 0
VS_s_st99 s_st99 0 1.65
XINV1_0 o1_0 s_st0 rail1 gn1 sg13g2_inv_1
CL1_0 o1_0 gn1 2f
XINV1_1 o1_1 s_st1 rail1 gn1 sg13g2_inv_1
CL1_1 o1_1 gn1 2f
XINV1_2 o1_2 s_st2 rail1 gn1 sg13g2_inv_1
CL1_2 o1_2 gn1 2f
XINV1_3 o1_3 s_st3 rail1 gn1 sg13g2_inv_1
CL1_3 o1_3 gn1 2f
XINV1_4 o1_4 s_st4 rail1 gn1 sg13g2_inv_1
CL1_4 o1_4 gn1 2f
XINV1_5 o1_5 s_st5 rail1 gn1 sg13g2_inv_1
CL1_5 o1_5 gn1 2f
XINV1_6 o1_6 s_st6 rail1 gn1 sg13g2_inv_1
CL1_6 o1_6 gn1 2f
XINV1_7 o1_7 s_st7 rail1 gn1 sg13g2_inv_1
CL1_7 o1_7 gn1 2f
XINV1_8 o1_8 s_st8 rail1 gn1 sg13g2_inv_1
CL1_8 o1_8 gn1 2f
XINV1_9 o1_9 s_st9 rail1 gn1 sg13g2_inv_1
CL1_9 o1_9 gn1 2f
XINV1_10 o1_10 s_st10 rail1 gn1 sg13g2_inv_1
CL1_10 o1_10 gn1 2f
XINV1_11 o1_11 s_st11 rail1 gn1 sg13g2_inv_1
CL1_11 o1_11 gn1 2f
XINV1_12 o1_12 s_st12 rail1 gn1 sg13g2_inv_1
CL1_12 o1_12 gn1 2f
XINV1_13 o1_13 s_st13 rail1 gn1 sg13g2_inv_1
CL1_13 o1_13 gn1 2f
XINV1_14 o1_14 s_st14 rail1 gn1 sg13g2_inv_1
CL1_14 o1_14 gn1 2f
XINV1_15 o1_15 s_st15 rail1 gn1 sg13g2_inv_1
CL1_15 o1_15 gn1 2f
XINV1_16 o1_16 s_st16 rail1 gn1 sg13g2_inv_1
CL1_16 o1_16 gn1 2f
XINV1_17 o1_17 s_st17 rail1 gn1 sg13g2_inv_1
CL1_17 o1_17 gn1 2f
XINV1_18 o1_18 s_st18 rail1 gn1 sg13g2_inv_1
CL1_18 o1_18 gn1 2f
XINV1_19 o1_19 s_st19 rail1 gn1 sg13g2_inv_1
CL1_19 o1_19 gn1 2f
XINV1_20 o1_20 s_st20 rail1 gn1 sg13g2_inv_1
CL1_20 o1_20 gn1 2f
XINV1_21 o1_21 s_st21 rail1 gn1 sg13g2_inv_1
CL1_21 o1_21 gn1 2f
XINV1_22 o1_22 s_st22 rail1 gn1 sg13g2_inv_1
CL1_22 o1_22 gn1 2f
XINV1_23 o1_23 s_st23 rail1 gn1 sg13g2_inv_1
CL1_23 o1_23 gn1 2f
XINV1_24 o1_24 s_st24 rail1 gn1 sg13g2_inv_1
CL1_24 o1_24 gn1 2f
XINV1_25 o1_25 s_st25 rail1 gn1 sg13g2_inv_1
CL1_25 o1_25 gn1 2f
XINV1_26 o1_26 s_st26 rail1 gn1 sg13g2_inv_1
CL1_26 o1_26 gn1 2f
XINV1_27 o1_27 s_st27 rail1 gn1 sg13g2_inv_1
CL1_27 o1_27 gn1 2f
XINV1_28 o1_28 s_st28 rail1 gn1 sg13g2_inv_1
CL1_28 o1_28 gn1 2f
XINV1_29 o1_29 s_st29 rail1 gn1 sg13g2_inv_1
CL1_29 o1_29 gn1 2f
XINV1_30 o1_30 s_st30 rail1 gn1 sg13g2_inv_1
CL1_30 o1_30 gn1 2f
XINV1_31 o1_31 s_st31 rail1 gn1 sg13g2_inv_1
CL1_31 o1_31 gn1 2f
XINV1_32 o1_32 s_st32 rail1 gn1 sg13g2_inv_1
CL1_32 o1_32 gn1 2f
XINV1_33 o1_33 s_st33 rail1 gn1 sg13g2_inv_1
CL1_33 o1_33 gn1 2f
XINV1_34 o1_34 s_st34 rail1 gn1 sg13g2_inv_1
CL1_34 o1_34 gn1 2f
XINV1_35 o1_35 s_st35 rail1 gn1 sg13g2_inv_1
CL1_35 o1_35 gn1 2f
XINV1_36 o1_36 s_st36 rail1 gn1 sg13g2_inv_1
CL1_36 o1_36 gn1 2f
XINV1_37 o1_37 s_st37 rail1 gn1 sg13g2_inv_1
CL1_37 o1_37 gn1 2f
XINV1_38 o1_38 s_st38 rail1 gn1 sg13g2_inv_1
CL1_38 o1_38 gn1 2f
XINV1_39 o1_39 s_st39 rail1 gn1 sg13g2_inv_1
CL1_39 o1_39 gn1 2f
XINV1_40 o1_40 s_st40 rail1 gn1 sg13g2_inv_1
CL1_40 o1_40 gn1 2f
XINV1_41 o1_41 s_st41 rail1 gn1 sg13g2_inv_1
CL1_41 o1_41 gn1 2f
XINV1_42 o1_42 s_st42 rail1 gn1 sg13g2_inv_1
CL1_42 o1_42 gn1 2f
XINV1_43 o1_43 s_st43 rail1 gn1 sg13g2_inv_1
CL1_43 o1_43 gn1 2f
XINV1_44 o1_44 s_st44 rail1 gn1 sg13g2_inv_1
CL1_44 o1_44 gn1 2f
XINV1_45 o1_45 s_st45 rail1 gn1 sg13g2_inv_1
CL1_45 o1_45 gn1 2f
XINV1_46 o1_46 s_st46 rail1 gn1 sg13g2_inv_1
CL1_46 o1_46 gn1 2f
XINV1_47 o1_47 s_st47 rail1 gn1 sg13g2_inv_1
CL1_47 o1_47 gn1 2f
XINV1_48 o1_48 s_st48 rail1 gn1 sg13g2_inv_1
CL1_48 o1_48 gn1 2f
XINV1_49 o1_49 s_st49 rail1 gn1 sg13g2_inv_1
CL1_49 o1_49 gn1 2f
XINV1_50 o1_50 s_st50 rail1 gn1 sg13g2_inv_1
CL1_50 o1_50 gn1 2f
XINV1_51 o1_51 s_st51 rail1 gn1 sg13g2_inv_1
CL1_51 o1_51 gn1 2f
XINV1_52 o1_52 s_st52 rail1 gn1 sg13g2_inv_1
CL1_52 o1_52 gn1 2f
XINV1_53 o1_53 s_st53 rail1 gn1 sg13g2_inv_1
CL1_53 o1_53 gn1 2f
XINV1_54 o1_54 s_st54 rail1 gn1 sg13g2_inv_1
CL1_54 o1_54 gn1 2f
XINV1_55 o1_55 s_st55 rail1 gn1 sg13g2_inv_1
CL1_55 o1_55 gn1 2f
XINV1_56 o1_56 s_st56 rail1 gn1 sg13g2_inv_1
CL1_56 o1_56 gn1 2f
XINV1_57 o1_57 s_st57 rail1 gn1 sg13g2_inv_1
CL1_57 o1_57 gn1 2f
XINV1_58 o1_58 s_st58 rail1 gn1 sg13g2_inv_1
CL1_58 o1_58 gn1 2f
XINV1_59 o1_59 s_st59 rail1 gn1 sg13g2_inv_1
CL1_59 o1_59 gn1 2f
XINV1_60 o1_60 s_st60 rail1 gn1 sg13g2_inv_1
CL1_60 o1_60 gn1 2f
XINV1_61 o1_61 s_st61 rail1 gn1 sg13g2_inv_1
CL1_61 o1_61 gn1 2f
XINV1_62 o1_62 s_st62 rail1 gn1 sg13g2_inv_1
CL1_62 o1_62 gn1 2f
XINV1_63 o1_63 s_st63 rail1 gn1 sg13g2_inv_1
CL1_63 o1_63 gn1 2f
XINV1_64 o1_64 s_st64 rail1 gn1 sg13g2_inv_1
CL1_64 o1_64 gn1 2f
XINV1_65 o1_65 s_st65 rail1 gn1 sg13g2_inv_1
CL1_65 o1_65 gn1 2f
XINV1_66 o1_66 s_st66 rail1 gn1 sg13g2_inv_1
CL1_66 o1_66 gn1 2f
XINV1_67 o1_67 s_st67 rail1 gn1 sg13g2_inv_1
CL1_67 o1_67 gn1 2f
XINV1_68 o1_68 s_st68 rail1 gn1 sg13g2_inv_1
CL1_68 o1_68 gn1 2f
XINV1_69 o1_69 s_st69 rail1 gn1 sg13g2_inv_1
CL1_69 o1_69 gn1 2f
XINV1_70 o1_70 s_st70 rail1 gn1 sg13g2_inv_1
CL1_70 o1_70 gn1 2f
XINV1_71 o1_71 s_st71 rail1 gn1 sg13g2_inv_1
CL1_71 o1_71 gn1 2f
XINV1_72 o1_72 s_st72 rail1 gn1 sg13g2_inv_1
CL1_72 o1_72 gn1 2f
XINV1_73 o1_73 s_st73 rail1 gn1 sg13g2_inv_1
CL1_73 o1_73 gn1 2f
XINV1_74 o1_74 s_st74 rail1 gn1 sg13g2_inv_1
CL1_74 o1_74 gn1 2f
XINV1_75 o1_75 s_st75 rail1 gn1 sg13g2_inv_1
CL1_75 o1_75 gn1 2f
XINV1_76 o1_76 s_st76 rail1 gn1 sg13g2_inv_1
CL1_76 o1_76 gn1 2f
XINV1_77 o1_77 s_st77 rail1 gn1 sg13g2_inv_1
CL1_77 o1_77 gn1 2f
XINV1_78 o1_78 s_st78 rail1 gn1 sg13g2_inv_1
CL1_78 o1_78 gn1 2f
XINV1_79 o1_79 s_st79 rail1 gn1 sg13g2_inv_1
CL1_79 o1_79 gn1 2f
XINV1_80 o1_80 s_st80 rail1 gn1 sg13g2_inv_1
CL1_80 o1_80 gn1 2f
XINV1_81 o1_81 s_st81 rail1 gn1 sg13g2_inv_1
CL1_81 o1_81 gn1 2f
XINV1_82 o1_82 s_st82 rail1 gn1 sg13g2_inv_1
CL1_82 o1_82 gn1 2f
XINV1_83 o1_83 s_st83 rail1 gn1 sg13g2_inv_1
CL1_83 o1_83 gn1 2f
XINV1_84 o1_84 s_st84 rail1 gn1 sg13g2_inv_1
CL1_84 o1_84 gn1 2f
XINV1_85 o1_85 s_st85 rail1 gn1 sg13g2_inv_1
CL1_85 o1_85 gn1 2f
XINV1_86 o1_86 s_st86 rail1 gn1 sg13g2_inv_1
CL1_86 o1_86 gn1 2f
XINV1_87 o1_87 s_st87 rail1 gn1 sg13g2_inv_1
CL1_87 o1_87 gn1 2f
XINV1_88 o1_88 s_st88 rail1 gn1 sg13g2_inv_1
CL1_88 o1_88 gn1 2f
XINV1_89 o1_89 s_st89 rail1 gn1 sg13g2_inv_1
CL1_89 o1_89 gn1 2f
XINV1_90 o1_90 s_st90 rail1 gn1 sg13g2_inv_1
CL1_90 o1_90 gn1 2f
XINV1_91 o1_91 s_st91 rail1 gn1 sg13g2_inv_1
CL1_91 o1_91 gn1 2f
XINV1_92 o1_92 s_st92 rail1 gn1 sg13g2_inv_1
CL1_92 o1_92 gn1 2f
XINV1_93 o1_93 s_st93 rail1 gn1 sg13g2_inv_1
CL1_93 o1_93 gn1 2f
XINV1_94 o1_94 s_st94 rail1 gn1 sg13g2_inv_1
CL1_94 o1_94 gn1 2f
XINV1_95 o1_95 s_st95 rail1 gn1 sg13g2_inv_1
CL1_95 o1_95 gn1 2f
XINV1_96 o1_96 s_st96 rail1 gn1 sg13g2_inv_1
CL1_96 o1_96 gn1 2f
XINV1_97 o1_97 s_st97 rail1 gn1 sg13g2_inv_1
CL1_97 o1_97 gn1 2f
XINV1_98 o1_98 s_st98 rail1 gn1 sg13g2_inv_1
CL1_98 o1_98 gn1 2f
XINV1_99 o1_99 s_st99 rail1 gn1 sg13g2_inv_1
CL1_99 o1_99 gn1 2f
XINV1_100 o1_100 s_st100 rail1 gn1 sg13g2_inv_1
CL1_100 o1_100 gn1 2f
XINV1_101 o1_101 s_st101 rail1 gn1 sg13g2_inv_1
CL1_101 o1_101 gn1 2f
XINV1_102 o1_102 s_st102 rail1 gn1 sg13g2_inv_1
CL1_102 o1_102 gn1 2f
XINV1_103 o1_103 s_st103 rail1 gn1 sg13g2_inv_1
CL1_103 o1_103 gn1 2f
XINV1_104 o1_104 s_st104 rail1 gn1 sg13g2_inv_1
CL1_104 o1_104 gn1 2f
XINV1_105 o1_105 s_st105 rail1 gn1 sg13g2_inv_1
CL1_105 o1_105 gn1 2f
XINV1_106 o1_106 s_st106 rail1 gn1 sg13g2_inv_1
CL1_106 o1_106 gn1 2f
XINV1_107 o1_107 s_st107 rail1 gn1 sg13g2_inv_1
CL1_107 o1_107 gn1 2f
XINV1_108 o1_108 s_st108 rail1 gn1 sg13g2_inv_1
CL1_108 o1_108 gn1 2f
XINV1_109 o1_109 s_st109 rail1 gn1 sg13g2_inv_1
CL1_109 o1_109 gn1 2f
XINV1_110 o1_110 s_st110 rail1 gn1 sg13g2_inv_1
CL1_110 o1_110 gn1 2f
XINV1_111 o1_111 s_st111 rail1 gn1 sg13g2_inv_1
CL1_111 o1_111 gn1 2f
XINV1_112 o1_112 s_st112 rail1 gn1 sg13g2_inv_1
CL1_112 o1_112 gn1 2f
XINV1_113 o1_113 s_st113 rail1 gn1 sg13g2_inv_1
CL1_113 o1_113 gn1 2f
XINV1_114 o1_114 s_st114 rail1 gn1 sg13g2_inv_1
CL1_114 o1_114 gn1 2f
XINV1_115 o1_115 s_st115 rail1 gn1 sg13g2_inv_1
CL1_115 o1_115 gn1 2f
XINV1_116 o1_116 s_st116 rail1 gn1 sg13g2_inv_1
CL1_116 o1_116 gn1 2f
XINV1_117 o1_117 s_st117 rail1 gn1 sg13g2_inv_1
CL1_117 o1_117 gn1 2f
XINV1_118 o1_118 s_st118 rail1 gn1 sg13g2_inv_1
CL1_118 o1_118 gn1 2f
XINV1_119 o1_119 s_st119 rail1 gn1 sg13g2_inv_1
CL1_119 o1_119 gn1 2f
XINV1_120 o1_120 s_st120 rail1 gn1 sg13g2_inv_1
CL1_120 o1_120 gn1 2f
XINV1_121 o1_121 s_st121 rail1 gn1 sg13g2_inv_1
CL1_121 o1_121 gn1 2f
XINV1_122 o1_122 s_st122 rail1 gn1 sg13g2_inv_1
CL1_122 o1_122 gn1 2f
XINV1_123 o1_123 s_st123 rail1 gn1 sg13g2_inv_1
CL1_123 o1_123 gn1 2f
XINV1_124 o1_124 s_st124 rail1 gn1 sg13g2_inv_1
CL1_124 o1_124 gn1 2f
XINV1_125 o1_125 s_st125 rail1 gn1 sg13g2_inv_1
CL1_125 o1_125 gn1 2f
XINV1_126 o1_126 s_st126 rail1 gn1 sg13g2_inv_1
CL1_126 o1_126 gn1 2f
XINV1_127 o1_127 s_st127 rail1 gn1 sg13g2_inv_1
CL1_127 o1_127 gn1 2f
VMG2 gn2 0 0
XXOR22_0 o2_0 o1_0 s_rk0 rail2 gn2 sg13g2_xor2_1
CL2_0 o2_0 gn2 2f
XXOR22_1 o2_1 o1_1 s_rk1 rail2 gn2 sg13g2_xor2_1
CL2_1 o2_1 gn2 2f
XXOR22_2 o2_2 o1_2 s_rk2 rail2 gn2 sg13g2_xor2_1
CL2_2 o2_2 gn2 2f
XXOR22_3 o2_3 o1_3 s_rk3 rail2 gn2 sg13g2_xor2_1
CL2_3 o2_3 gn2 2f
XXOR22_4 o2_4 o1_4 s_rk4 rail2 gn2 sg13g2_xor2_1
CL2_4 o2_4 gn2 2f
XXOR22_5 o2_5 o1_5 s_rk5 rail2 gn2 sg13g2_xor2_1
CL2_5 o2_5 gn2 2f
XXOR22_6 o2_6 o1_6 s_rk6 rail2 gn2 sg13g2_xor2_1
CL2_6 o2_6 gn2 2f
XXOR22_7 o2_7 o1_7 s_rk7 rail2 gn2 sg13g2_xor2_1
CL2_7 o2_7 gn2 2f
XXOR22_8 o2_8 o1_8 s_rk8 rail2 gn2 sg13g2_xor2_1
CL2_8 o2_8 gn2 2f
CW2_8 o2_8 gn2 4.608000f
XXOR22_9 o2_9 o1_9 s_rk9 rail2 gn2 sg13g2_xor2_1
CL2_9 o2_9 gn2 2f
CW2_9 o2_9 gn2 4.608000f
XXOR22_10 o2_10 o1_10 s_rk10 rail2 gn2 sg13g2_xor2_1
CL2_10 o2_10 gn2 2f
CW2_10 o2_10 gn2 4.608000f
XXOR22_11 o2_11 o1_11 s_rk11 rail2 gn2 sg13g2_xor2_1
CL2_11 o2_11 gn2 2f
CW2_11 o2_11 gn2 4.608000f
XXOR22_12 o2_12 o1_12 s_rk12 rail2 gn2 sg13g2_xor2_1
CL2_12 o2_12 gn2 2f
CW2_12 o2_12 gn2 4.608000f
XXOR22_13 o2_13 o1_13 s_rk13 rail2 gn2 sg13g2_xor2_1
CL2_13 o2_13 gn2 2f
CW2_13 o2_13 gn2 4.608000f
XXOR22_14 o2_14 o1_14 s_rk14 rail2 gn2 sg13g2_xor2_1
CL2_14 o2_14 gn2 2f
CW2_14 o2_14 gn2 4.608000f
XXOR22_15 o2_15 o1_15 s_rk15 rail2 gn2 sg13g2_xor2_1
CL2_15 o2_15 gn2 2f
CW2_15 o2_15 gn2 4.608000f
XXOR22_16 o2_16 o1_16 s_rk16 rail2 gn2 sg13g2_xor2_1
CL2_16 o2_16 gn2 2f
CW2_16 o2_16 gn2 9.216000f
XXOR22_17 o2_17 o1_17 s_rk17 rail2 gn2 sg13g2_xor2_1
CL2_17 o2_17 gn2 2f
CW2_17 o2_17 gn2 9.216000f
XXOR22_18 o2_18 o1_18 s_rk18 rail2 gn2 sg13g2_xor2_1
CL2_18 o2_18 gn2 2f
CW2_18 o2_18 gn2 9.216000f
XXOR22_19 o2_19 o1_19 s_rk19 rail2 gn2 sg13g2_xor2_1
CL2_19 o2_19 gn2 2f
CW2_19 o2_19 gn2 9.216000f
XXOR22_20 o2_20 o1_20 s_rk20 rail2 gn2 sg13g2_xor2_1
CL2_20 o2_20 gn2 2f
CW2_20 o2_20 gn2 9.216000f
XXOR22_21 o2_21 o1_21 s_rk21 rail2 gn2 sg13g2_xor2_1
CL2_21 o2_21 gn2 2f
CW2_21 o2_21 gn2 9.216000f
XXOR22_22 o2_22 o1_22 s_rk22 rail2 gn2 sg13g2_xor2_1
CL2_22 o2_22 gn2 2f
CW2_22 o2_22 gn2 9.216000f
XXOR22_23 o2_23 o1_23 s_rk23 rail2 gn2 sg13g2_xor2_1
CL2_23 o2_23 gn2 2f
CW2_23 o2_23 gn2 9.216000f
XXOR22_24 o2_24 o1_24 s_rk24 rail2 gn2 sg13g2_xor2_1
CL2_24 o2_24 gn2 2f
CW2_24 o2_24 gn2 4.608000f
XXOR22_25 o2_25 o1_25 s_rk25 rail2 gn2 sg13g2_xor2_1
CL2_25 o2_25 gn2 2f
CW2_25 o2_25 gn2 4.608000f
XXOR22_26 o2_26 o1_26 s_rk26 rail2 gn2 sg13g2_xor2_1
CL2_26 o2_26 gn2 2f
CW2_26 o2_26 gn2 4.608000f
XXOR22_27 o2_27 o1_27 s_rk27 rail2 gn2 sg13g2_xor2_1
CL2_27 o2_27 gn2 2f
CW2_27 o2_27 gn2 4.608000f
XXOR22_28 o2_28 o1_28 s_rk28 rail2 gn2 sg13g2_xor2_1
CL2_28 o2_28 gn2 2f
CW2_28 o2_28 gn2 4.608000f
XXOR22_29 o2_29 o1_29 s_rk29 rail2 gn2 sg13g2_xor2_1
CL2_29 o2_29 gn2 2f
CW2_29 o2_29 gn2 4.608000f
XXOR22_30 o2_30 o1_30 s_rk30 rail2 gn2 sg13g2_xor2_1
CL2_30 o2_30 gn2 2f
CW2_30 o2_30 gn2 4.608000f
XXOR22_31 o2_31 o1_31 s_rk31 rail2 gn2 sg13g2_xor2_1
CL2_31 o2_31 gn2 2f
CW2_31 o2_31 gn2 4.608000f
XXOR22_32 o2_32 o1_32 s_rk32 rail2 gn2 sg13g2_xor2_1
CL2_32 o2_32 gn2 2f
XXOR22_33 o2_33 o1_33 s_rk33 rail2 gn2 sg13g2_xor2_1
CL2_33 o2_33 gn2 2f
XXOR22_34 o2_34 o1_34 s_rk34 rail2 gn2 sg13g2_xor2_1
CL2_34 o2_34 gn2 2f
XXOR22_35 o2_35 o1_35 s_rk35 rail2 gn2 sg13g2_xor2_1
CL2_35 o2_35 gn2 2f
XXOR22_36 o2_36 o1_36 s_rk36 rail2 gn2 sg13g2_xor2_1
CL2_36 o2_36 gn2 2f
XXOR22_37 o2_37 o1_37 s_rk37 rail2 gn2 sg13g2_xor2_1
CL2_37 o2_37 gn2 2f
XXOR22_38 o2_38 o1_38 s_rk38 rail2 gn2 sg13g2_xor2_1
CL2_38 o2_38 gn2 2f
XXOR22_39 o2_39 o1_39 s_rk39 rail2 gn2 sg13g2_xor2_1
CL2_39 o2_39 gn2 2f
XXOR22_40 o2_40 o1_40 s_rk40 rail2 gn2 sg13g2_xor2_1
CL2_40 o2_40 gn2 2f
CW2_40 o2_40 gn2 4.608000f
XXOR22_41 o2_41 o1_41 s_rk41 rail2 gn2 sg13g2_xor2_1
CL2_41 o2_41 gn2 2f
CW2_41 o2_41 gn2 4.608000f
XXOR22_42 o2_42 o1_42 s_rk42 rail2 gn2 sg13g2_xor2_1
CL2_42 o2_42 gn2 2f
CW2_42 o2_42 gn2 4.608000f
XXOR22_43 o2_43 o1_43 s_rk43 rail2 gn2 sg13g2_xor2_1
CL2_43 o2_43 gn2 2f
CW2_43 o2_43 gn2 4.608000f
XXOR22_44 o2_44 o1_44 s_rk44 rail2 gn2 sg13g2_xor2_1
CL2_44 o2_44 gn2 2f
CW2_44 o2_44 gn2 4.608000f
XXOR22_45 o2_45 o1_45 s_rk45 rail2 gn2 sg13g2_xor2_1
CL2_45 o2_45 gn2 2f
CW2_45 o2_45 gn2 4.608000f
XXOR22_46 o2_46 o1_46 s_rk46 rail2 gn2 sg13g2_xor2_1
CL2_46 o2_46 gn2 2f
CW2_46 o2_46 gn2 4.608000f
XXOR22_47 o2_47 o1_47 s_rk47 rail2 gn2 sg13g2_xor2_1
CL2_47 o2_47 gn2 2f
CW2_47 o2_47 gn2 4.608000f
XXOR22_48 o2_48 o1_48 s_rk48 rail2 gn2 sg13g2_xor2_1
CL2_48 o2_48 gn2 2f
CW2_48 o2_48 gn2 9.216000f
XXOR22_49 o2_49 o1_49 s_rk49 rail2 gn2 sg13g2_xor2_1
CL2_49 o2_49 gn2 2f
CW2_49 o2_49 gn2 9.216000f
XXOR22_50 o2_50 o1_50 s_rk50 rail2 gn2 sg13g2_xor2_1
CL2_50 o2_50 gn2 2f
CW2_50 o2_50 gn2 9.216000f
XXOR22_51 o2_51 o1_51 s_rk51 rail2 gn2 sg13g2_xor2_1
CL2_51 o2_51 gn2 2f
CW2_51 o2_51 gn2 9.216000f
XXOR22_52 o2_52 o1_52 s_rk52 rail2 gn2 sg13g2_xor2_1
CL2_52 o2_52 gn2 2f
CW2_52 o2_52 gn2 9.216000f
XXOR22_53 o2_53 o1_53 s_rk53 rail2 gn2 sg13g2_xor2_1
CL2_53 o2_53 gn2 2f
CW2_53 o2_53 gn2 9.216000f
XXOR22_54 o2_54 o1_54 s_rk54 rail2 gn2 sg13g2_xor2_1
CL2_54 o2_54 gn2 2f
CW2_54 o2_54 gn2 9.216000f
XXOR22_55 o2_55 o1_55 s_rk55 rail2 gn2 sg13g2_xor2_1
CL2_55 o2_55 gn2 2f
CW2_55 o2_55 gn2 9.216000f
XXOR22_56 o2_56 o1_56 s_rk56 rail2 gn2 sg13g2_xor2_1
CL2_56 o2_56 gn2 2f
CW2_56 o2_56 gn2 4.608000f
XXOR22_57 o2_57 o1_57 s_rk57 rail2 gn2 sg13g2_xor2_1
CL2_57 o2_57 gn2 2f
CW2_57 o2_57 gn2 4.608000f
XXOR22_58 o2_58 o1_58 s_rk58 rail2 gn2 sg13g2_xor2_1
CL2_58 o2_58 gn2 2f
CW2_58 o2_58 gn2 4.608000f
XXOR22_59 o2_59 o1_59 s_rk59 rail2 gn2 sg13g2_xor2_1
CL2_59 o2_59 gn2 2f
CW2_59 o2_59 gn2 4.608000f
XXOR22_60 o2_60 o1_60 s_rk60 rail2 gn2 sg13g2_xor2_1
CL2_60 o2_60 gn2 2f
CW2_60 o2_60 gn2 4.608000f
XXOR22_61 o2_61 o1_61 s_rk61 rail2 gn2 sg13g2_xor2_1
CL2_61 o2_61 gn2 2f
CW2_61 o2_61 gn2 4.608000f
XXOR22_62 o2_62 o1_62 s_rk62 rail2 gn2 sg13g2_xor2_1
CL2_62 o2_62 gn2 2f
CW2_62 o2_62 gn2 4.608000f
XXOR22_63 o2_63 o1_63 s_rk63 rail2 gn2 sg13g2_xor2_1
CL2_63 o2_63 gn2 2f
CW2_63 o2_63 gn2 4.608000f
XXOR22_64 o2_64 o1_64 s_rk64 rail2 gn2 sg13g2_xor2_1
CL2_64 o2_64 gn2 2f
XXOR22_65 o2_65 o1_65 s_rk65 rail2 gn2 sg13g2_xor2_1
CL2_65 o2_65 gn2 2f
XXOR22_66 o2_66 o1_66 s_rk66 rail2 gn2 sg13g2_xor2_1
CL2_66 o2_66 gn2 2f
XXOR22_67 o2_67 o1_67 s_rk67 rail2 gn2 sg13g2_xor2_1
CL2_67 o2_67 gn2 2f
XXOR22_68 o2_68 o1_68 s_rk68 rail2 gn2 sg13g2_xor2_1
CL2_68 o2_68 gn2 2f
XXOR22_69 o2_69 o1_69 s_rk69 rail2 gn2 sg13g2_xor2_1
CL2_69 o2_69 gn2 2f
XXOR22_70 o2_70 o1_70 s_rk70 rail2 gn2 sg13g2_xor2_1
CL2_70 o2_70 gn2 2f
XXOR22_71 o2_71 o1_71 s_rk71 rail2 gn2 sg13g2_xor2_1
CL2_71 o2_71 gn2 2f
XXOR22_72 o2_72 o1_72 s_rk72 rail2 gn2 sg13g2_xor2_1
CL2_72 o2_72 gn2 2f
CW2_72 o2_72 gn2 4.608000f
XXOR22_73 o2_73 o1_73 s_rk73 rail2 gn2 sg13g2_xor2_1
CL2_73 o2_73 gn2 2f
CW2_73 o2_73 gn2 4.608000f
XXOR22_74 o2_74 o1_74 s_rk74 rail2 gn2 sg13g2_xor2_1
CL2_74 o2_74 gn2 2f
CW2_74 o2_74 gn2 4.608000f
XXOR22_75 o2_75 o1_75 s_rk75 rail2 gn2 sg13g2_xor2_1
CL2_75 o2_75 gn2 2f
CW2_75 o2_75 gn2 4.608000f
XXOR22_76 o2_76 o1_76 s_rk76 rail2 gn2 sg13g2_xor2_1
CL2_76 o2_76 gn2 2f
CW2_76 o2_76 gn2 4.608000f
XXOR22_77 o2_77 o1_77 s_rk77 rail2 gn2 sg13g2_xor2_1
CL2_77 o2_77 gn2 2f
CW2_77 o2_77 gn2 4.608000f
XXOR22_78 o2_78 o1_78 s_rk78 rail2 gn2 sg13g2_xor2_1
CL2_78 o2_78 gn2 2f
CW2_78 o2_78 gn2 4.608000f
XXOR22_79 o2_79 o1_79 s_rk79 rail2 gn2 sg13g2_xor2_1
CL2_79 o2_79 gn2 2f
CW2_79 o2_79 gn2 4.608000f
XXOR22_80 o2_80 o1_80 s_rk80 rail2 gn2 sg13g2_xor2_1
CL2_80 o2_80 gn2 2f
CW2_80 o2_80 gn2 9.216000f
XXOR22_81 o2_81 o1_81 s_rk81 rail2 gn2 sg13g2_xor2_1
CL2_81 o2_81 gn2 2f
CW2_81 o2_81 gn2 9.216000f
XXOR22_82 o2_82 o1_82 s_rk82 rail2 gn2 sg13g2_xor2_1
CL2_82 o2_82 gn2 2f
CW2_82 o2_82 gn2 9.216000f
XXOR22_83 o2_83 o1_83 s_rk83 rail2 gn2 sg13g2_xor2_1
CL2_83 o2_83 gn2 2f
CW2_83 o2_83 gn2 9.216000f
XXOR22_84 o2_84 o1_84 s_rk84 rail2 gn2 sg13g2_xor2_1
CL2_84 o2_84 gn2 2f
CW2_84 o2_84 gn2 9.216000f
XXOR22_85 o2_85 o1_85 s_rk85 rail2 gn2 sg13g2_xor2_1
CL2_85 o2_85 gn2 2f
CW2_85 o2_85 gn2 9.216000f
XXOR22_86 o2_86 o1_86 s_rk86 rail2 gn2 sg13g2_xor2_1
CL2_86 o2_86 gn2 2f
CW2_86 o2_86 gn2 9.216000f
XXOR22_87 o2_87 o1_87 s_rk87 rail2 gn2 sg13g2_xor2_1
CL2_87 o2_87 gn2 2f
CW2_87 o2_87 gn2 9.216000f
XXOR22_88 o2_88 o1_88 s_rk88 rail2 gn2 sg13g2_xor2_1
CL2_88 o2_88 gn2 2f
CW2_88 o2_88 gn2 4.608000f
XXOR22_89 o2_89 o1_89 s_rk89 rail2 gn2 sg13g2_xor2_1
CL2_89 o2_89 gn2 2f
CW2_89 o2_89 gn2 4.608000f
XXOR22_90 o2_90 o1_90 s_rk90 rail2 gn2 sg13g2_xor2_1
CL2_90 o2_90 gn2 2f
CW2_90 o2_90 gn2 4.608000f
XXOR22_91 o2_91 o1_91 s_rk91 rail2 gn2 sg13g2_xor2_1
CL2_91 o2_91 gn2 2f
CW2_91 o2_91 gn2 4.608000f
XXOR22_92 o2_92 o1_92 s_rk92 rail2 gn2 sg13g2_xor2_1
CL2_92 o2_92 gn2 2f
CW2_92 o2_92 gn2 4.608000f
XXOR22_93 o2_93 o1_93 s_rk93 rail2 gn2 sg13g2_xor2_1
CL2_93 o2_93 gn2 2f
CW2_93 o2_93 gn2 4.608000f
XXOR22_94 o2_94 o1_94 s_rk94 rail2 gn2 sg13g2_xor2_1
CL2_94 o2_94 gn2 2f
CW2_94 o2_94 gn2 4.608000f
XXOR22_95 o2_95 o1_95 s_rk95 rail2 gn2 sg13g2_xor2_1
CL2_95 o2_95 gn2 2f
CW2_95 o2_95 gn2 4.608000f
XXOR22_96 o2_96 o1_96 s_rk96 rail2 gn2 sg13g2_xor2_1
CL2_96 o2_96 gn2 2f
XXOR22_97 o2_97 o1_97 s_rk97 rail2 gn2 sg13g2_xor2_1
CL2_97 o2_97 gn2 2f
XXOR22_98 o2_98 o1_98 s_rk98 rail2 gn2 sg13g2_xor2_1
CL2_98 o2_98 gn2 2f
XXOR22_99 o2_99 o1_99 s_rk99 rail2 gn2 sg13g2_xor2_1
CL2_99 o2_99 gn2 2f
XXOR22_100 o2_100 o1_100 s_rk100 rail2 gn2 sg13g2_xor2_1
CL2_100 o2_100 gn2 2f
XXOR22_101 o2_101 o1_101 s_rk101 rail2 gn2 sg13g2_xor2_1
CL2_101 o2_101 gn2 2f
XXOR22_102 o2_102 o1_102 s_rk102 rail2 gn2 sg13g2_xor2_1
CL2_102 o2_102 gn2 2f
XXOR22_103 o2_103 o1_103 s_rk103 rail2 gn2 sg13g2_xor2_1
CL2_103 o2_103 gn2 2f
XXOR22_104 o2_104 o1_104 s_rk104 rail2 gn2 sg13g2_xor2_1
CL2_104 o2_104 gn2 2f
CW2_104 o2_104 gn2 4.608000f
XXOR22_105 o2_105 o1_105 s_rk105 rail2 gn2 sg13g2_xor2_1
CL2_105 o2_105 gn2 2f
CW2_105 o2_105 gn2 4.608000f
XXOR22_106 o2_106 o1_106 s_rk106 rail2 gn2 sg13g2_xor2_1
CL2_106 o2_106 gn2 2f
CW2_106 o2_106 gn2 4.608000f
XXOR22_107 o2_107 o1_107 s_rk107 rail2 gn2 sg13g2_xor2_1
CL2_107 o2_107 gn2 2f
CW2_107 o2_107 gn2 4.608000f
XXOR22_108 o2_108 o1_108 s_rk108 rail2 gn2 sg13g2_xor2_1
CL2_108 o2_108 gn2 2f
CW2_108 o2_108 gn2 4.608000f
XXOR22_109 o2_109 o1_109 s_rk109 rail2 gn2 sg13g2_xor2_1
CL2_109 o2_109 gn2 2f
CW2_109 o2_109 gn2 4.608000f
XXOR22_110 o2_110 o1_110 s_rk110 rail2 gn2 sg13g2_xor2_1
CL2_110 o2_110 gn2 2f
CW2_110 o2_110 gn2 4.608000f
XXOR22_111 o2_111 o1_111 s_rk111 rail2 gn2 sg13g2_xor2_1
CL2_111 o2_111 gn2 2f
CW2_111 o2_111 gn2 4.608000f
XXOR22_112 o2_112 o1_112 s_rk112 rail2 gn2 sg13g2_xor2_1
CL2_112 o2_112 gn2 2f
CW2_112 o2_112 gn2 9.216000f
XXOR22_113 o2_113 o1_113 s_rk113 rail2 gn2 sg13g2_xor2_1
CL2_113 o2_113 gn2 2f
CW2_113 o2_113 gn2 9.216000f
XXOR22_114 o2_114 o1_114 s_rk114 rail2 gn2 sg13g2_xor2_1
CL2_114 o2_114 gn2 2f
CW2_114 o2_114 gn2 9.216000f
XXOR22_115 o2_115 o1_115 s_rk115 rail2 gn2 sg13g2_xor2_1
CL2_115 o2_115 gn2 2f
CW2_115 o2_115 gn2 9.216000f
XXOR22_116 o2_116 o1_116 s_rk116 rail2 gn2 sg13g2_xor2_1
CL2_116 o2_116 gn2 2f
CW2_116 o2_116 gn2 9.216000f
XXOR22_117 o2_117 o1_117 s_rk117 rail2 gn2 sg13g2_xor2_1
CL2_117 o2_117 gn2 2f
CW2_117 o2_117 gn2 9.216000f
XXOR22_118 o2_118 o1_118 s_rk118 rail2 gn2 sg13g2_xor2_1
CL2_118 o2_118 gn2 2f
CW2_118 o2_118 gn2 9.216000f
XXOR22_119 o2_119 o1_119 s_rk119 rail2 gn2 sg13g2_xor2_1
CL2_119 o2_119 gn2 2f
CW2_119 o2_119 gn2 9.216000f
XXOR22_120 o2_120 o1_120 s_rk120 rail2 gn2 sg13g2_xor2_1
CL2_120 o2_120 gn2 2f
CW2_120 o2_120 gn2 4.608000f
XXOR22_121 o2_121 o1_121 s_rk121 rail2 gn2 sg13g2_xor2_1
CL2_121 o2_121 gn2 2f
CW2_121 o2_121 gn2 4.608000f
XXOR22_122 o2_122 o1_122 s_rk122 rail2 gn2 sg13g2_xor2_1
CL2_122 o2_122 gn2 2f
CW2_122 o2_122 gn2 4.608000f
XXOR22_123 o2_123 o1_123 s_rk123 rail2 gn2 sg13g2_xor2_1
CL2_123 o2_123 gn2 2f
CW2_123 o2_123 gn2 4.608000f
XXOR22_124 o2_124 o1_124 s_rk124 rail2 gn2 sg13g2_xor2_1
CL2_124 o2_124 gn2 2f
CW2_124 o2_124 gn2 4.608000f
XXOR22_125 o2_125 o1_125 s_rk125 rail2 gn2 sg13g2_xor2_1
CL2_125 o2_125 gn2 2f
CW2_125 o2_125 gn2 4.608000f
XXOR22_126 o2_126 o1_126 s_rk126 rail2 gn2 sg13g2_xor2_1
CL2_126 o2_126 gn2 2f
CW2_126 o2_126 gn2 4.608000f
XXOR22_127 o2_127 o1_127 s_rk127 rail2 gn2 sg13g2_xor2_1
CL2_127 o2_127 gn2 2f
CW2_127 o2_127 gn2 4.608000f
VMG3 gn3 0 0
XINV3_0 o3_0 o2_0 rail3 gn3 sg13g2_inv_1
CL3_0 o3_0 gn3 2f
XINV3_1 o3_1 o2_1 rail3 gn3 sg13g2_inv_1
CL3_1 o3_1 gn3 2f
XINV3_2 o3_2 o2_2 rail3 gn3 sg13g2_inv_1
CL3_2 o3_2 gn3 2f
XINV3_3 o3_3 o2_3 rail3 gn3 sg13g2_inv_1
CL3_3 o3_3 gn3 2f
XINV3_4 o3_4 o2_4 rail3 gn3 sg13g2_inv_1
CL3_4 o3_4 gn3 2f
XINV3_5 o3_5 o2_5 rail3 gn3 sg13g2_inv_1
CL3_5 o3_5 gn3 2f
XINV3_6 o3_6 o2_6 rail3 gn3 sg13g2_inv_1
CL3_6 o3_6 gn3 2f
XINV3_7 o3_7 o2_7 rail3 gn3 sg13g2_inv_1
CL3_7 o3_7 gn3 2f
XINV3_8 o3_8 o2_40 rail3 gn3 sg13g2_inv_1
CL3_8 o3_8 gn3 2f
XINV3_9 o3_9 o2_41 rail3 gn3 sg13g2_inv_1
CL3_9 o3_9 gn3 2f
XINV3_10 o3_10 o2_42 rail3 gn3 sg13g2_inv_1
CL3_10 o3_10 gn3 2f
XINV3_11 o3_11 o2_43 rail3 gn3 sg13g2_inv_1
CL3_11 o3_11 gn3 2f
XINV3_12 o3_12 o2_44 rail3 gn3 sg13g2_inv_1
CL3_12 o3_12 gn3 2f
XINV3_13 o3_13 o2_45 rail3 gn3 sg13g2_inv_1
CL3_13 o3_13 gn3 2f
XINV3_14 o3_14 o2_46 rail3 gn3 sg13g2_inv_1
CL3_14 o3_14 gn3 2f
XINV3_15 o3_15 o2_47 rail3 gn3 sg13g2_inv_1
CL3_15 o3_15 gn3 2f
XINV3_16 o3_16 o2_80 rail3 gn3 sg13g2_inv_1
CL3_16 o3_16 gn3 2f
XINV3_17 o3_17 o2_81 rail3 gn3 sg13g2_inv_1
CL3_17 o3_17 gn3 2f
XINV3_18 o3_18 o2_82 rail3 gn3 sg13g2_inv_1
CL3_18 o3_18 gn3 2f
XINV3_19 o3_19 o2_83 rail3 gn3 sg13g2_inv_1
CL3_19 o3_19 gn3 2f
XINV3_20 o3_20 o2_84 rail3 gn3 sg13g2_inv_1
CL3_20 o3_20 gn3 2f
XINV3_21 o3_21 o2_85 rail3 gn3 sg13g2_inv_1
CL3_21 o3_21 gn3 2f
XINV3_22 o3_22 o2_86 rail3 gn3 sg13g2_inv_1
CL3_22 o3_22 gn3 2f
XINV3_23 o3_23 o2_87 rail3 gn3 sg13g2_inv_1
CL3_23 o3_23 gn3 2f
XINV3_24 o3_24 o2_120 rail3 gn3 sg13g2_inv_1
CL3_24 o3_24 gn3 2f
XINV3_25 o3_25 o2_121 rail3 gn3 sg13g2_inv_1
CL3_25 o3_25 gn3 2f
XINV3_26 o3_26 o2_122 rail3 gn3 sg13g2_inv_1
CL3_26 o3_26 gn3 2f
XINV3_27 o3_27 o2_123 rail3 gn3 sg13g2_inv_1
CL3_27 o3_27 gn3 2f
XINV3_28 o3_28 o2_124 rail3 gn3 sg13g2_inv_1
CL3_28 o3_28 gn3 2f
XINV3_29 o3_29 o2_125 rail3 gn3 sg13g2_inv_1
CL3_29 o3_29 gn3 2f
XINV3_30 o3_30 o2_126 rail3 gn3 sg13g2_inv_1
CL3_30 o3_30 gn3 2f
XINV3_31 o3_31 o2_127 rail3 gn3 sg13g2_inv_1
CL3_31 o3_31 gn3 2f
XINV3_32 o3_32 o2_32 rail3 gn3 sg13g2_inv_1
CL3_32 o3_32 gn3 2f
XINV3_33 o3_33 o2_33 rail3 gn3 sg13g2_inv_1
CL3_33 o3_33 gn3 2f
XINV3_34 o3_34 o2_34 rail3 gn3 sg13g2_inv_1
CL3_34 o3_34 gn3 2f
XINV3_35 o3_35 o2_35 rail3 gn3 sg13g2_inv_1
CL3_35 o3_35 gn3 2f
XINV3_36 o3_36 o2_36 rail3 gn3 sg13g2_inv_1
CL3_36 o3_36 gn3 2f
XINV3_37 o3_37 o2_37 rail3 gn3 sg13g2_inv_1
CL3_37 o3_37 gn3 2f
XINV3_38 o3_38 o2_38 rail3 gn3 sg13g2_inv_1
CL3_38 o3_38 gn3 2f
XINV3_39 o3_39 o2_39 rail3 gn3 sg13g2_inv_1
CL3_39 o3_39 gn3 2f
XINV3_40 o3_40 o2_72 rail3 gn3 sg13g2_inv_1
CL3_40 o3_40 gn3 2f
XINV3_41 o3_41 o2_73 rail3 gn3 sg13g2_inv_1
CL3_41 o3_41 gn3 2f
XINV3_42 o3_42 o2_74 rail3 gn3 sg13g2_inv_1
CL3_42 o3_42 gn3 2f
XINV3_43 o3_43 o2_75 rail3 gn3 sg13g2_inv_1
CL3_43 o3_43 gn3 2f
XINV3_44 o3_44 o2_76 rail3 gn3 sg13g2_inv_1
CL3_44 o3_44 gn3 2f
XINV3_45 o3_45 o2_77 rail3 gn3 sg13g2_inv_1
CL3_45 o3_45 gn3 2f
XINV3_46 o3_46 o2_78 rail3 gn3 sg13g2_inv_1
CL3_46 o3_46 gn3 2f
XINV3_47 o3_47 o2_79 rail3 gn3 sg13g2_inv_1
CL3_47 o3_47 gn3 2f
XINV3_48 o3_48 o2_112 rail3 gn3 sg13g2_inv_1
CL3_48 o3_48 gn3 2f
XINV3_49 o3_49 o2_113 rail3 gn3 sg13g2_inv_1
CL3_49 o3_49 gn3 2f
XINV3_50 o3_50 o2_114 rail3 gn3 sg13g2_inv_1
CL3_50 o3_50 gn3 2f
XINV3_51 o3_51 o2_115 rail3 gn3 sg13g2_inv_1
CL3_51 o3_51 gn3 2f
XINV3_52 o3_52 o2_116 rail3 gn3 sg13g2_inv_1
CL3_52 o3_52 gn3 2f
XINV3_53 o3_53 o2_117 rail3 gn3 sg13g2_inv_1
CL3_53 o3_53 gn3 2f
XINV3_54 o3_54 o2_118 rail3 gn3 sg13g2_inv_1
CL3_54 o3_54 gn3 2f
XINV3_55 o3_55 o2_119 rail3 gn3 sg13g2_inv_1
CL3_55 o3_55 gn3 2f
XINV3_56 o3_56 o2_24 rail3 gn3 sg13g2_inv_1
CL3_56 o3_56 gn3 2f
XINV3_57 o3_57 o2_25 rail3 gn3 sg13g2_inv_1
CL3_57 o3_57 gn3 2f
XINV3_58 o3_58 o2_26 rail3 gn3 sg13g2_inv_1
CL3_58 o3_58 gn3 2f
XINV3_59 o3_59 o2_27 rail3 gn3 sg13g2_inv_1
CL3_59 o3_59 gn3 2f
XINV3_60 o3_60 o2_28 rail3 gn3 sg13g2_inv_1
CL3_60 o3_60 gn3 2f
XINV3_61 o3_61 o2_29 rail3 gn3 sg13g2_inv_1
CL3_61 o3_61 gn3 2f
XINV3_62 o3_62 o2_30 rail3 gn3 sg13g2_inv_1
CL3_62 o3_62 gn3 2f
XINV3_63 o3_63 o2_31 rail3 gn3 sg13g2_inv_1
CL3_63 o3_63 gn3 2f
XINV3_64 o3_64 o2_64 rail3 gn3 sg13g2_inv_1
CL3_64 o3_64 gn3 2f
XINV3_65 o3_65 o2_65 rail3 gn3 sg13g2_inv_1
CL3_65 o3_65 gn3 2f
XINV3_66 o3_66 o2_66 rail3 gn3 sg13g2_inv_1
CL3_66 o3_66 gn3 2f
XINV3_67 o3_67 o2_67 rail3 gn3 sg13g2_inv_1
CL3_67 o3_67 gn3 2f
XINV3_68 o3_68 o2_68 rail3 gn3 sg13g2_inv_1
CL3_68 o3_68 gn3 2f
XINV3_69 o3_69 o2_69 rail3 gn3 sg13g2_inv_1
CL3_69 o3_69 gn3 2f
XINV3_70 o3_70 o2_70 rail3 gn3 sg13g2_inv_1
CL3_70 o3_70 gn3 2f
XINV3_71 o3_71 o2_71 rail3 gn3 sg13g2_inv_1
CL3_71 o3_71 gn3 2f
XINV3_72 o3_72 o2_104 rail3 gn3 sg13g2_inv_1
CL3_72 o3_72 gn3 2f
XINV3_73 o3_73 o2_105 rail3 gn3 sg13g2_inv_1
CL3_73 o3_73 gn3 2f
XINV3_74 o3_74 o2_106 rail3 gn3 sg13g2_inv_1
CL3_74 o3_74 gn3 2f
XINV3_75 o3_75 o2_107 rail3 gn3 sg13g2_inv_1
CL3_75 o3_75 gn3 2f
XINV3_76 o3_76 o2_108 rail3 gn3 sg13g2_inv_1
CL3_76 o3_76 gn3 2f
XINV3_77 o3_77 o2_109 rail3 gn3 sg13g2_inv_1
CL3_77 o3_77 gn3 2f
XINV3_78 o3_78 o2_110 rail3 gn3 sg13g2_inv_1
CL3_78 o3_78 gn3 2f
XINV3_79 o3_79 o2_111 rail3 gn3 sg13g2_inv_1
CL3_79 o3_79 gn3 2f
XINV3_80 o3_80 o2_16 rail3 gn3 sg13g2_inv_1
CL3_80 o3_80 gn3 2f
XINV3_81 o3_81 o2_17 rail3 gn3 sg13g2_inv_1
CL3_81 o3_81 gn3 2f
XINV3_82 o3_82 o2_18 rail3 gn3 sg13g2_inv_1
CL3_82 o3_82 gn3 2f
XINV3_83 o3_83 o2_19 rail3 gn3 sg13g2_inv_1
CL3_83 o3_83 gn3 2f
XINV3_84 o3_84 o2_20 rail3 gn3 sg13g2_inv_1
CL3_84 o3_84 gn3 2f
XINV3_85 o3_85 o2_21 rail3 gn3 sg13g2_inv_1
CL3_85 o3_85 gn3 2f
XINV3_86 o3_86 o2_22 rail3 gn3 sg13g2_inv_1
CL3_86 o3_86 gn3 2f
XINV3_87 o3_87 o2_23 rail3 gn3 sg13g2_inv_1
CL3_87 o3_87 gn3 2f
XINV3_88 o3_88 o2_56 rail3 gn3 sg13g2_inv_1
CL3_88 o3_88 gn3 2f
XINV3_89 o3_89 o2_57 rail3 gn3 sg13g2_inv_1
CL3_89 o3_89 gn3 2f
XINV3_90 o3_90 o2_58 rail3 gn3 sg13g2_inv_1
CL3_90 o3_90 gn3 2f
XINV3_91 o3_91 o2_59 rail3 gn3 sg13g2_inv_1
CL3_91 o3_91 gn3 2f
XINV3_92 o3_92 o2_60 rail3 gn3 sg13g2_inv_1
CL3_92 o3_92 gn3 2f
XINV3_93 o3_93 o2_61 rail3 gn3 sg13g2_inv_1
CL3_93 o3_93 gn3 2f
XINV3_94 o3_94 o2_62 rail3 gn3 sg13g2_inv_1
CL3_94 o3_94 gn3 2f
XINV3_95 o3_95 o2_63 rail3 gn3 sg13g2_inv_1
CL3_95 o3_95 gn3 2f
XINV3_96 o3_96 o2_96 rail3 gn3 sg13g2_inv_1
CL3_96 o3_96 gn3 2f
XINV3_97 o3_97 o2_97 rail3 gn3 sg13g2_inv_1
CL3_97 o3_97 gn3 2f
XINV3_98 o3_98 o2_98 rail3 gn3 sg13g2_inv_1
CL3_98 o3_98 gn3 2f
XINV3_99 o3_99 o2_99 rail3 gn3 sg13g2_inv_1
CL3_99 o3_99 gn3 2f
XINV3_100 o3_100 o2_100 rail3 gn3 sg13g2_inv_1
CL3_100 o3_100 gn3 2f
XINV3_101 o3_101 o2_101 rail3 gn3 sg13g2_inv_1
CL3_101 o3_101 gn3 2f
XINV3_102 o3_102 o2_102 rail3 gn3 sg13g2_inv_1
CL3_102 o3_102 gn3 2f
XINV3_103 o3_103 o2_103 rail3 gn3 sg13g2_inv_1
CL3_103 o3_103 gn3 2f
XINV3_104 o3_104 o2_8 rail3 gn3 sg13g2_inv_1
CL3_104 o3_104 gn3 2f
XINV3_105 o3_105 o2_9 rail3 gn3 sg13g2_inv_1
CL3_105 o3_105 gn3 2f
XINV3_106 o3_106 o2_10 rail3 gn3 sg13g2_inv_1
CL3_106 o3_106 gn3 2f
XINV3_107 o3_107 o2_11 rail3 gn3 sg13g2_inv_1
CL3_107 o3_107 gn3 2f
XINV3_108 o3_108 o2_12 rail3 gn3 sg13g2_inv_1
CL3_108 o3_108 gn3 2f
XINV3_109 o3_109 o2_13 rail3 gn3 sg13g2_inv_1
CL3_109 o3_109 gn3 2f
XINV3_110 o3_110 o2_14 rail3 gn3 sg13g2_inv_1
CL3_110 o3_110 gn3 2f
XINV3_111 o3_111 o2_15 rail3 gn3 sg13g2_inv_1
CL3_111 o3_111 gn3 2f
XINV3_112 o3_112 o2_48 rail3 gn3 sg13g2_inv_1
CL3_112 o3_112 gn3 2f
XINV3_113 o3_113 o2_49 rail3 gn3 sg13g2_inv_1
CL3_113 o3_113 gn3 2f
XINV3_114 o3_114 o2_50 rail3 gn3 sg13g2_inv_1
CL3_114 o3_114 gn3 2f
XINV3_115 o3_115 o2_51 rail3 gn3 sg13g2_inv_1
CL3_115 o3_115 gn3 2f
XINV3_116 o3_116 o2_52 rail3 gn3 sg13g2_inv_1
CL3_116 o3_116 gn3 2f
XINV3_117 o3_117 o2_53 rail3 gn3 sg13g2_inv_1
CL3_117 o3_117 gn3 2f
XINV3_118 o3_118 o2_54 rail3 gn3 sg13g2_inv_1
CL3_118 o3_118 gn3 2f
XINV3_119 o3_119 o2_55 rail3 gn3 sg13g2_inv_1
CL3_119 o3_119 gn3 2f
XINV3_120 o3_120 o2_88 rail3 gn3 sg13g2_inv_1
CL3_120 o3_120 gn3 2f
XINV3_121 o3_121 o2_89 rail3 gn3 sg13g2_inv_1
CL3_121 o3_121 gn3 2f
XINV3_122 o3_122 o2_90 rail3 gn3 sg13g2_inv_1
CL3_122 o3_122 gn3 2f
XINV3_123 o3_123 o2_91 rail3 gn3 sg13g2_inv_1
CL3_123 o3_123 gn3 2f
XINV3_124 o3_124 o2_92 rail3 gn3 sg13g2_inv_1
CL3_124 o3_124 gn3 2f
XINV3_125 o3_125 o2_93 rail3 gn3 sg13g2_inv_1
CL3_125 o3_125 gn3 2f
XINV3_126 o3_126 o2_94 rail3 gn3 sg13g2_inv_1
CL3_126 o3_126 gn3 2f
XINV3_127 o3_127 o2_95 rail3 gn3 sg13g2_inv_1
CL3_127 o3_127 gn3 2f
CT1 tnk1 0 5756.64f
L1 tnk1 mid1 15n
R1 mid1 sw1 10
XSWN1 sw1 gt1 rail1 0 sg13_lv_nmos w=40u l=0.13u
XSWP1 sw1 gtp1 rail1 vhi sg13_lv_pmos w=80u l=0.13u
XPK1 sw1 pk1 tnk1 tnk1 sg13_lv_nmos w=8u l=0.13u
CT2 tnk2 0 24441.4f
L2 tnk2 mid2 15n
R2 mid2 sw2 10
XSWN2 sw2 gt2 rail2 0 sg13_lv_nmos w=80u l=0.13u
XSWP2 sw2 gtp2 rail2 vhi sg13_lv_pmos w=160u l=0.13u
XPK2 sw2 pk2 tnk2 tnk2 sg13_lv_nmos w=16u l=0.13u
CT3 tnk3 0 5756.64f
L3 tnk3 mid3 15n
R3 mid3 sw3 10
XSWN3 sw3 gt3 rail3 0 sg13_lv_nmos w=40u l=0.13u
XSWP3 sw3 gtp3 rail3 vhi sg13_lv_pmos w=80u l=0.13u
XPK3 sw3 pk3 tnk3 tnk3 sg13_lv_nmos w=8u l=0.13u
VGT1 gt1 0 PWL(0 0 198p 0 200p 1.5 585.844p 1.5 587.844p 0 4798p 0 4800p 1.5 5228.44p 1.5 5230.44p 0)
VGTP1 gtp1 0 PWL(0 1.5 198p 1.5 200p 0 585.844p 0 587.844p 1.5 4798p 1.5 4800p 0 5228.44p 0 5230.44p 1.5)
VPK1 pk1 0 PWL(0 1.5 198p 1.5 200p 0 585.844p 0 587.844p 1.5 4798p 1.5 4800p 0 5228.44p 0 5230.44p 1.5)
VGT2 gt2 0 PWL(0 0 1348p 0 1350p 1.5 2018.03p 1.5 2020.03p 0 5948p 0 5950p 1.5 30662p 1.5)
VGTP2 gtp2 0 PWL(0 1.5 1348p 1.5 1350p 0 2018.03p 0 2020.03p 1.5 5948p 1.5 5950p 0 30662p 0)
VPK2 pk2 0 PWL(0 1.5 1348p 1.5 1350p 0 2018.03p 0 2020.03p 1.5 5948p 1.5 5950p 0 30662p 0)
VGT3 gt3 0 PWL(0 0 2498p 0 2500p 1.5 2856.03p 1.5 2858.03p 0)
VGTP3 gtp3 0 PWL(0 1.5 2498p 1.5 2500p 0 2856.03p 0 2858.03p 1.5)
VPK3 pk3 0 PWL(0 1.5 2498p 1.5 2500p 0 2856.03p 0 2858.03p 1.5)
.ic V(tnk1)=0.9075 V(rail1)=0 V(sw1)=0.9075 V(tnk2)=0.9075 V(rail2)=0 V(sw2)=0.9075 V(tnk3)=0.9075 V(rail3)=0 V(sw3)=0.9075
.tran 0.1p 7893.34p 0 1p
.print tran I(L1) I(L2) I(L3) V(rail1) V(rail2) V(rail3) V(tnk1) V(tnk2) V(tnk3)
.end
