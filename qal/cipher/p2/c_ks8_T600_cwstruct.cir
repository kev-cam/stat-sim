.hdl "/usr/local/share/xyce/verilog-a/psp103/psp103.va"
.include "/usr/local/src/kestrel/sim/models/sg13g2_psp103_tt.lib"
.include "/usr/local/src/stat-sim/qal/sg13lv_compat.sp"
.OPTIONS TIMEINT METHOD=GEAR RELTOL=1e-6 ABSTOL=1e-15 CHGTOL=1e-17
.include "/usr/local/src/IHP-Open-PDK/ihp-sg13g2/libs.ref/sg13g2_stdcell/spice/sg13g2_stdcell.spice"
VHI vhi 0 1.5
VMG1 gn1 0 0
VS_s_a0 s_a0 0 1.65
VS_s_a1 s_a1 0 1.65
VS_s_a2 s_a2 0 1.65
VS_s_a3 s_a3 0 1.65
VS_s_a4 s_a4 0 1.65
VS_s_a5 s_a5 0 1.65
VS_s_a6 s_a6 0 0
VS_s_a7 s_a7 0 0
VS_s_b0 s_b0 0 1.65
VS_s_b1 s_b1 0 0
VS_s_b2 s_b2 0 0
VS_s_b3 s_b3 0 0
VS_s_b4 s_b4 0 0
VS_s_b5 s_b5 0 0
VS_s_b6 s_b6 0 1.65
VS_s_b7 s_b7 0 1.65
XXOR21_0 o1_0 s_a0 s_b0 rail1 gn1 sg13g2_xor2_1
CL1_0 o1_0 gn1 2f
CW1_0 o1_0 gn1 0.360000f
XAND21_1 o1_1 s_a0 s_b0 rail1 gn1 sg13g2_and2_1
CL1_1 o1_1 gn1 2f
CW1_1 o1_1 gn1 0.360000f
XXOR21_2 o1_2 s_a1 s_b1 rail1 gn1 sg13g2_xor2_1
CL1_2 o1_2 gn1 2f
CW1_2 o1_2 gn1 0.360000f
XAND21_3 o1_3 s_a1 s_b1 rail1 gn1 sg13g2_and2_1
CL1_3 o1_3 gn1 2f
CW1_3 o1_3 gn1 0.360000f
XXOR21_4 o1_4 s_a2 s_b2 rail1 gn1 sg13g2_xor2_1
CL1_4 o1_4 gn1 2f
CW1_4 o1_4 gn1 0.360000f
XAND21_5 o1_5 s_a2 s_b2 rail1 gn1 sg13g2_and2_1
CL1_5 o1_5 gn1 2f
CW1_5 o1_5 gn1 0.360000f
XXOR21_6 o1_6 s_a3 s_b3 rail1 gn1 sg13g2_xor2_1
CL1_6 o1_6 gn1 2f
CW1_6 o1_6 gn1 0.360000f
XAND21_7 o1_7 s_a3 s_b3 rail1 gn1 sg13g2_and2_1
CL1_7 o1_7 gn1 2f
CW1_7 o1_7 gn1 0.360000f
XXOR21_8 o1_8 s_a4 s_b4 rail1 gn1 sg13g2_xor2_1
CL1_8 o1_8 gn1 2f
CW1_8 o1_8 gn1 0.360000f
XAND21_9 o1_9 s_a4 s_b4 rail1 gn1 sg13g2_and2_1
CL1_9 o1_9 gn1 2f
CW1_9 o1_9 gn1 0.360000f
XXOR21_10 o1_10 s_a5 s_b5 rail1 gn1 sg13g2_xor2_1
CL1_10 o1_10 gn1 2f
CW1_10 o1_10 gn1 0.360000f
XAND21_11 o1_11 s_a5 s_b5 rail1 gn1 sg13g2_and2_1
CL1_11 o1_11 gn1 2f
CW1_11 o1_11 gn1 0.360000f
XXOR21_12 o1_12 s_a6 s_b6 rail1 gn1 sg13g2_xor2_1
CL1_12 o1_12 gn1 2f
CW1_12 o1_12 gn1 0.360000f
XAND21_13 o1_13 s_a6 s_b6 rail1 gn1 sg13g2_and2_1
CL1_13 o1_13 gn1 2f
CW1_13 o1_13 gn1 0.360000f
XXOR21_14 o1_14 s_a7 s_b7 rail1 gn1 sg13g2_xor2_1
CL1_14 o1_14 gn1 2f
CW1_14 o1_14 gn1 0.360000f
VMG2 gn2 0 0
XINV2_0 o2_0 o1_1 rail2 gn2 sg13g2_inv_1
CL2_0 o2_0 gn2 2f
CW2_0 o2_0 gn2 0.720000f
XINV2_1 o2_1 o1_0 rail2 gn2 sg13g2_inv_1
CL2_1 o2_1 gn2 2f
CW2_1 o2_1 gn2 0.360000f
XA21OI2_2 o2_2 o1_2 o1_1 o1_3 rail2 gn2 sg13g2_a21oi_1
CL2_2 o2_2 gn2 2f
CW2_2 o2_2 gn2 0.720000f
XINV2_3 o2_3 o1_2 rail2 gn2 sg13g2_inv_1
CL2_3 o2_3 gn2 2f
CW2_3 o2_3 gn2 0.360000f
XA21OI2_4 o2_4 o1_4 o1_3 o1_5 rail2 gn2 sg13g2_a21oi_1
CL2_4 o2_4 gn2 2f
CW2_4 o2_4 gn2 0.720000f
XNAND22_5 o2_5 o1_4 o1_2 rail2 gn2 sg13g2_nand2_1
CL2_5 o2_5 gn2 2f
CW2_5 o2_5 gn2 0.720000f
XINV2_6 o2_6 o1_4 rail2 gn2 sg13g2_inv_1
CL2_6 o2_6 gn2 2f
CW2_6 o2_6 gn2 0.360000f
XA21OI2_7 o2_7 o1_6 o1_5 o1_7 rail2 gn2 sg13g2_a21oi_1
CL2_7 o2_7 gn2 2f
CW2_7 o2_7 gn2 0.720000f
XNAND22_8 o2_8 o1_6 o1_4 rail2 gn2 sg13g2_nand2_1
CL2_8 o2_8 gn2 2f
CW2_8 o2_8 gn2 0.720000f
XINV2_9 o2_9 o1_6 rail2 gn2 sg13g2_inv_1
CL2_9 o2_9 gn2 2f
CW2_9 o2_9 gn2 0.360000f
XA21OI2_10 o2_10 o1_8 o1_7 o1_9 rail2 gn2 sg13g2_a21oi_1
CL2_10 o2_10 gn2 2f
CW2_10 o2_10 gn2 0.720000f
XNAND22_11 o2_11 o1_8 o1_6 rail2 gn2 sg13g2_nand2_1
CL2_11 o2_11 gn2 2f
CW2_11 o2_11 gn2 0.720000f
XINV2_12 o2_12 o1_8 rail2 gn2 sg13g2_inv_1
CL2_12 o2_12 gn2 2f
CW2_12 o2_12 gn2 0.360000f
XA21OI2_13 o2_13 o1_10 o1_9 o1_11 rail2 gn2 sg13g2_a21oi_1
CL2_13 o2_13 gn2 2f
CW2_13 o2_13 gn2 0.360000f
XNAND22_14 o2_14 o1_10 o1_8 rail2 gn2 sg13g2_nand2_1
CL2_14 o2_14 gn2 2f
CW2_14 o2_14 gn2 0.360000f
XINV2_15 o2_15 o1_10 rail2 gn2 sg13g2_inv_1
CL2_15 o2_15 gn2 2f
CW2_15 o2_15 gn2 0.360000f
XA21OI2_16 o2_16 o1_12 o1_11 o1_13 rail2 gn2 sg13g2_a21oi_1
CL2_16 o2_16 gn2 2f
CW2_16 o2_16 gn2 0.360000f
XNAND22_17 o2_17 o1_12 o1_10 rail2 gn2 sg13g2_nand2_1
CL2_17 o2_17 gn2 2f
CW2_17 o2_17 gn2 0.360000f
XINV2_18 o2_18 o1_12 rail2 gn2 sg13g2_inv_1
CL2_18 o2_18 gn2 2f
CW2_18 o2_18 gn2 0.360000f
XINV2_19 o2_19 o1_14 rail2 gn2 sg13g2_inv_1
CL2_19 o2_19 gn2 2f
CW2_19 o2_19 gn2 0.360000f
VMG3 gn3 0 0
XINV3_0 o3_0 o2_0 rail3 gn3 sg13g2_inv_1
CL3_0 o3_0 gn3 2f
CW3_0 o3_0 gn3 1.440000f
XINV3_1 o3_1 o2_1 rail3 gn3 sg13g2_inv_1
CL3_1 o3_1 gn3 2f
CW3_1 o3_1 gn3 0.360000f
XINV3_2 o3_2 o2_2 rail3 gn3 sg13g2_inv_1
CL3_2 o3_2 gn3 2f
CW3_2 o3_2 gn3 1.440000f
XINV3_3 o3_3 o2_3 rail3 gn3 sg13g2_inv_1
CL3_3 o3_3 gn3 2f
CW3_3 o3_3 gn3 0.360000f
XO21AI3_4 o3_4 o2_5 o2_0 o2_4 rail3 gn3 sg13g2_o21ai_1
CL3_4 o3_4 gn3 2f
CW3_4 o3_4 gn3 1.440000f
XINV3_5 o3_5 o2_6 rail3 gn3 sg13g2_inv_1
CL3_5 o3_5 gn3 2f
CW3_5 o3_5 gn3 0.360000f
XO21AI3_6 o3_6 o2_8 o2_2 o2_7 rail3 gn3 sg13g2_o21ai_1
CL3_6 o3_6 gn3 2f
CW3_6 o3_6 gn3 0.360000f
XINV3_7 o3_7 o2_9 rail3 gn3 sg13g2_inv_1
CL3_7 o3_7 gn3 2f
CW3_7 o3_7 gn3 0.360000f
XO21AI3_8 o3_8 o2_11 o2_4 o2_10 rail3 gn3 sg13g2_o21ai_1
CL3_8 o3_8 gn3 2f
CW3_8 o3_8 gn3 0.360000f
XNOR23_9 o3_9 o2_11 o2_5 rail3 gn3 sg13g2_nor2_1
CL3_9 o3_9 gn3 2f
CW3_9 o3_9 gn3 0.360000f
XINV3_10 o3_10 o2_12 rail3 gn3 sg13g2_inv_1
CL3_10 o3_10 gn3 2f
CW3_10 o3_10 gn3 0.360000f
XO21AI3_11 o3_11 o2_14 o2_7 o2_13 rail3 gn3 sg13g2_o21ai_1
CL3_11 o3_11 gn3 2f
CW3_11 o3_11 gn3 0.360000f
XNOR23_12 o3_12 o2_14 o2_8 rail3 gn3 sg13g2_nor2_1
CL3_12 o3_12 gn3 2f
CW3_12 o3_12 gn3 0.360000f
XINV3_13 o3_13 o2_15 rail3 gn3 sg13g2_inv_1
CL3_13 o3_13 gn3 2f
CW3_13 o3_13 gn3 0.360000f
XO21AI3_14 o3_14 o2_17 o2_10 o2_16 rail3 gn3 sg13g2_o21ai_1
CL3_14 o3_14 gn3 2f
CW3_14 o3_14 gn3 0.360000f
XNOR23_15 o3_15 o2_17 o2_11 rail3 gn3 sg13g2_nor2_1
CL3_15 o3_15 gn3 2f
CW3_15 o3_15 gn3 0.360000f
XINV3_16 o3_16 o2_18 rail3 gn3 sg13g2_inv_1
CL3_16 o3_16 gn3 2f
CW3_16 o3_16 gn3 0.360000f
XINV3_17 o3_17 o2_19 rail3 gn3 sg13g2_inv_1
CL3_17 o3_17 gn3 2f
CW3_17 o3_17 gn3 0.360000f
VMG4 gn4 0 0
XINV4_0 o4_0 o3_0 rail4 gn4 sg13g2_inv_1
CL4_0 o4_0 gn4 2f
CW4_0 o4_0 gn4 0.360000f
XINV4_1 o4_1 o3_1 rail4 gn4 sg13g2_inv_1
CL4_1 o4_1 gn4 2f
CW4_1 o4_1 gn4 0.360000f
XINV4_2 o4_2 o3_2 rail4 gn4 sg13g2_inv_1
CL4_2 o4_2 gn4 2f
CW4_2 o4_2 gn4 0.360000f
XINV4_3 o4_3 o3_3 rail4 gn4 sg13g2_inv_1
CL4_3 o4_3 gn4 2f
CW4_3 o4_3 gn4 0.360000f
XINV4_4 o4_4 o3_4 rail4 gn4 sg13g2_inv_1
CL4_4 o4_4 gn4 2f
CW4_4 o4_4 gn4 0.360000f
XINV4_5 o4_5 o3_5 rail4 gn4 sg13g2_inv_1
CL4_5 o4_5 gn4 2f
CW4_5 o4_5 gn4 0.360000f
XINV4_6 o4_6 o3_6 rail4 gn4 sg13g2_inv_1
CL4_6 o4_6 gn4 2f
CW4_6 o4_6 gn4 0.360000f
XINV4_7 o4_7 o3_7 rail4 gn4 sg13g2_inv_1
CL4_7 o4_7 gn4 2f
CW4_7 o4_7 gn4 0.360000f
XA21OI4_8 o4_8 o3_9 o3_0 o3_8 rail4 gn4 sg13g2_a21oi_1
CL4_8 o4_8 gn4 2f
CW4_8 o4_8 gn4 0.360000f
XINV4_9 o4_9 o3_10 rail4 gn4 sg13g2_inv_1
CL4_9 o4_9 gn4 2f
CW4_9 o4_9 gn4 0.360000f
XA21OI4_10 o4_10 o3_12 o3_2 o3_11 rail4 gn4 sg13g2_a21oi_1
CL4_10 o4_10 gn4 2f
CW4_10 o4_10 gn4 0.360000f
XINV4_11 o4_11 o3_13 rail4 gn4 sg13g2_inv_1
CL4_11 o4_11 gn4 2f
CW4_11 o4_11 gn4 0.360000f
XA21OI4_12 o4_12 o3_15 o3_4 o3_14 rail4 gn4 sg13g2_a21oi_1
CL4_12 o4_12 gn4 2f
CW4_12 o4_12 gn4 0.360000f
XINV4_13 o4_13 o3_16 rail4 gn4 sg13g2_inv_1
CL4_13 o4_13 gn4 2f
CW4_13 o4_13 gn4 0.360000f
XINV4_14 o4_14 o3_17 rail4 gn4 sg13g2_inv_1
CL4_14 o4_14 gn4 2f
CW4_14 o4_14 gn4 0.360000f
VMG5 gn5 0 0
XINV5_0 o5_0 o4_1 rail5 gn5 sg13g2_inv_1
CL5_0 o5_0 gn5 2f
CW5_0 o5_0 gn5 0.360000f
XXOR25_1 o5_1 o4_3 o4_0 rail5 gn5 sg13g2_xor2_1
CL5_1 o5_1 gn5 2f
CW5_1 o5_1 gn5 0.360000f
XXOR25_2 o5_2 o4_5 o4_2 rail5 gn5 sg13g2_xor2_1
CL5_2 o5_2 gn5 2f
CW5_2 o5_2 gn5 0.360000f
XXOR25_3 o5_3 o4_7 o4_4 rail5 gn5 sg13g2_xor2_1
CL5_3 o5_3 gn5 2f
CW5_3 o5_3 gn5 0.360000f
XXOR25_4 o5_4 o4_9 o4_6 rail5 gn5 sg13g2_xor2_1
CL5_4 o5_4 gn5 2f
CW5_4 o5_4 gn5 0.360000f
XXOR25_5 o5_5 o4_11 o4_8 rail5 gn5 sg13g2_xor2_1
CL5_5 o5_5 gn5 2f
CW5_5 o5_5 gn5 0.360000f
XXOR25_6 o5_6 o4_13 o4_10 rail5 gn5 sg13g2_xor2_1
CL5_6 o5_6 gn5 2f
CW5_6 o5_6 gn5 0.360000f
XXOR25_7 o5_7 o4_14 o4_12 rail5 gn5 sg13g2_xor2_1
CL5_7 o5_7 gn5 2f
CW5_7 o5_7 gn5 0.360000f
CT1 tnk1 0 1877.4f
L1 tnk1 mid1 15n
R1 mid1 sw1 10
XSWN1 sw1 gt1 rail1 0 sg13_lv_nmos w=20u l=0.13u
XSWP1 sw1 gtp1 rail1 vhi sg13_lv_pmos w=40u l=0.13u
XPK1 sw1 pk1 tnk1 tnk1 sg13_lv_nmos w=4u l=0.13u
CT2 tnk2 0 1424.83f
L2 tnk2 mid2 15n
R2 mid2 sw2 10
XSWN2 sw2 gt2 rail2 0 sg13_lv_nmos w=20u l=0.13u
XSWP2 sw2 gtp2 rail2 vhi sg13_lv_pmos w=40u l=0.13u
XPK2 sw2 pk2 tnk2 tnk2 sg13_lv_nmos w=4u l=0.13u
CT3 tnk3 0 1231.39f
L3 tnk3 mid3 15n
R3 mid3 sw3 10
XSWN3 sw3 gt3 rail3 0 sg13_lv_nmos w=20u l=0.13u
XSWP3 sw3 gtp3 rail3 vhi sg13_lv_pmos w=40u l=0.13u
XPK3 sw3 pk3 tnk3 tnk3 sg13_lv_nmos w=4u l=0.13u
CT4 tnk4 0 878.449f
L4 tnk4 mid4 15n
R4 mid4 sw4 10
XSWN4 sw4 gt4 rail4 0 sg13_lv_nmos w=14.1421u l=0.13u
XSWP4 sw4 gtp4 rail4 vhi sg13_lv_pmos w=28.2843u l=0.13u
XPK4 sw4 pk4 tnk4 tnk4 sg13_lv_nmos w=2.82843u l=0.13u
CT5 tnk5 0 1087.85f
L5 tnk5 mid5 15n
R5 mid5 sw5 10
XSWN5 sw5 gt5 rail5 0 sg13_lv_nmos w=20u l=0.13u
XSWP5 sw5 gtp5 rail5 vhi sg13_lv_pmos w=40u l=0.13u
XPK5 sw5 pk5 tnk5 tnk5 sg13_lv_nmos w=4u l=0.13u
VGT1 gt1 0 PWL(0 0 198p 0 200p 1.5 415.308p 1.5 417.308p 0 2598p 0 2600p 1.5 2887.4p 1.5 2889.4p 0)
VGTP1 gtp1 0 PWL(0 1.5 198p 1.5 200p 0 415.308p 0 417.308p 1.5 2598p 1.5 2600p 0 2887.4p 0 2889.4p 1.5)
VPK1 pk1 0 PWL(0 1.5 198p 1.5 200p 0 415.308p 0 417.308p 1.5 2598p 1.5 2600p 0 2887.4p 0 2889.4p 1.5)
VGT2 gt2 0 PWL(0 0 798p 0 800p 1.5 991.526p 1.5 993.526p 0 3198p 0 3200p 1.5 3467.14p 1.5 3469.14p 0)
VGTP2 gtp2 0 PWL(0 1.5 798p 1.5 800p 0 991.526p 0 993.526p 1.5 3198p 1.5 3200p 0 3467.14p 0 3469.14p 1.5)
VPK2 pk2 0 PWL(0 1.5 798p 1.5 800p 0 991.526p 0 993.526p 1.5 3198p 1.5 3200p 0 3467.14p 0 3469.14p 1.5)
VGT3 gt3 0 PWL(0 0 1398p 0 1400p 1.5 1596.47p 1.5 1598.47p 0 3798p 0 3800p 1.5 4058.21p 1.5 4060.21p 0)
VGTP3 gtp3 0 PWL(0 1.5 1398p 1.5 1400p 0 1596.47p 0 1598.47p 1.5 3798p 1.5 3800p 0 4058.21p 0 4060.21p 1.5)
VPK3 pk3 0 PWL(0 1.5 1398p 1.5 1400p 0 1596.47p 0 1598.47p 1.5 3798p 1.5 3800p 0 4058.21p 0 4060.21p 1.5)
VGT4 gt4 0 PWL(0 0 1998p 0 2000p 1.5 2156.3p 1.5 2158.3p 0 4398p 0 4400p 1.5 4584.3p 1.5 4586.3p 0)
VGTP4 gtp4 0 PWL(0 1.5 1998p 1.5 2000p 0 2156.3p 0 2158.3p 1.5 4398p 1.5 4400p 0 4584.3p 0 4586.3p 1.5)
VPK4 pk4 0 PWL(0 1.5 1998p 1.5 2000p 0 2156.3p 0 2158.3p 1.5 4398p 1.5 4400p 0 4584.3p 0 4586.3p 1.5)
VGT5 gt5 0 PWL(0 0 2598p 0 2600p 1.5 2782.18p 1.5 2784.18p 0 4998p 0 5000p 1.5 5224.37p 1.5 5226.37p 0)
VGTP5 gtp5 0 PWL(0 1.5 2598p 1.5 2600p 0 2782.18p 0 2784.18p 1.5 4998p 1.5 5000p 0 5224.37p 0 5226.37p 1.5)
VPK5 pk5 0 PWL(0 1.5 2598p 1.5 2600p 0 2782.18p 0 2784.18p 1.5 4998p 1.5 5000p 0 5224.37p 0 5226.37p 1.5)
CXqlt1 xqlt1 0 1
BXqlt1 0 xqlt1 I={ I(L1) }
RXqlt1 xqlt1 0 0.01
CXea1 xea1 0 1
BXea1 0 xea1 I={ V(tnk1)*I(L1) }
RXea1 xea1 0 0.01
CXeb1 xeb1 0 1
BXeb1 0 xeb1 I={ V(rail1)*I(L1) }
RXeb1 xeb1 0 0.01
CXesw1 xesw1 0 1
BXesw1 0 xesw1 I={ V(sw1)*I(L1) }
RXesw1 xesw1 0 0.01
CXer1 xer1 0 1
BXer1 0 xer1 I={ I(L1)*I(L1)*10 }
RXer1 xer1 0 0.01
CXqg1 xqg1 0 1
BXqg1 0 xqg1 I={ I(VMG1) }
RXqg1 xqg1 0 0.01
CXqlt2 xqlt2 0 1
BXqlt2 0 xqlt2 I={ I(L2) }
RXqlt2 xqlt2 0 0.01
CXea2 xea2 0 1
BXea2 0 xea2 I={ V(tnk2)*I(L2) }
RXea2 xea2 0 0.01
CXeb2 xeb2 0 1
BXeb2 0 xeb2 I={ V(rail2)*I(L2) }
RXeb2 xeb2 0 0.01
CXesw2 xesw2 0 1
BXesw2 0 xesw2 I={ V(sw2)*I(L2) }
RXesw2 xesw2 0 0.01
CXer2 xer2 0 1
BXer2 0 xer2 I={ I(L2)*I(L2)*10 }
RXer2 xer2 0 0.01
CXqg2 xqg2 0 1
BXqg2 0 xqg2 I={ I(VMG2) }
RXqg2 xqg2 0 0.01
CXqlt3 xqlt3 0 1
BXqlt3 0 xqlt3 I={ I(L3) }
RXqlt3 xqlt3 0 0.01
CXea3 xea3 0 1
BXea3 0 xea3 I={ V(tnk3)*I(L3) }
RXea3 xea3 0 0.01
CXeb3 xeb3 0 1
BXeb3 0 xeb3 I={ V(rail3)*I(L3) }
RXeb3 xeb3 0 0.01
CXesw3 xesw3 0 1
BXesw3 0 xesw3 I={ V(sw3)*I(L3) }
RXesw3 xesw3 0 0.01
CXer3 xer3 0 1
BXer3 0 xer3 I={ I(L3)*I(L3)*10 }
RXer3 xer3 0 0.01
CXqg3 xqg3 0 1
BXqg3 0 xqg3 I={ I(VMG3) }
RXqg3 xqg3 0 0.01
CXqlt4 xqlt4 0 1
BXqlt4 0 xqlt4 I={ I(L4) }
RXqlt4 xqlt4 0 0.01
CXea4 xea4 0 1
BXea4 0 xea4 I={ V(tnk4)*I(L4) }
RXea4 xea4 0 0.01
CXeb4 xeb4 0 1
BXeb4 0 xeb4 I={ V(rail4)*I(L4) }
RXeb4 xeb4 0 0.01
CXesw4 xesw4 0 1
BXesw4 0 xesw4 I={ V(sw4)*I(L4) }
RXesw4 xesw4 0 0.01
CXer4 xer4 0 1
BXer4 0 xer4 I={ I(L4)*I(L4)*10 }
RXer4 xer4 0 0.01
CXqg4 xqg4 0 1
BXqg4 0 xqg4 I={ I(VMG4) }
RXqg4 xqg4 0 0.01
CXqlt5 xqlt5 0 1
BXqlt5 0 xqlt5 I={ I(L5) }
RXqlt5 xqlt5 0 0.01
CXea5 xea5 0 1
BXea5 0 xea5 I={ V(tnk5)*I(L5) }
RXea5 xea5 0 0.01
CXeb5 xeb5 0 1
BXeb5 0 xeb5 I={ V(rail5)*I(L5) }
RXeb5 xeb5 0 0.01
CXesw5 xesw5 0 1
BXesw5 0 xesw5 I={ V(sw5)*I(L5) }
RXesw5 xesw5 0 0.01
CXer5 xer5 0 1
BXer5 0 xer5 I={ I(L5)*I(L5)*10 }
RXer5 xer5 0 0.01
CXqg5 xqg5 0 1
BXqg5 0 xqg5 I={ I(VMG5) }
RXqg5 xqg5 0 0.01
CXqi1 xqi1 0 1
BXqi1 0 xqi1 I={ -(I(VS_s_a0)+I(VS_s_a1)+I(VS_s_a2)+I(VS_s_a3)+I(VS_s_a4)+I(VS_s_a5)+I(VS_s_a6)+I(VS_s_a7)+I(VS_s_b0)+I(VS_s_b1)+I(VS_s_b2)+I(VS_s_b3)+I(VS_s_b4)+I(VS_s_b5)+I(VS_s_b6)+I(VS_s_b7)) }
RXqi1 xqi1 0 0.01
CXei1 xei1 0 1
BXei1 0 xei1 I={ -(V(s_a0)*I(VS_s_a0)+V(s_a1)*I(VS_s_a1)+V(s_a2)*I(VS_s_a2)+V(s_a3)*I(VS_s_a3)+V(s_a4)*I(VS_s_a4)+V(s_a5)*I(VS_s_a5)+V(s_a6)*I(VS_s_a6)+V(s_a7)*I(VS_s_a7)+V(s_b0)*I(VS_s_b0)+V(s_b1)*I(VS_s_b1)+V(s_b2)*I(VS_s_b2)+V(s_b3)*I(VS_s_b3)+V(s_b4)*I(VS_s_b4)+V(s_b5)*I(VS_s_b5)+V(s_b6)*I(VS_s_b6)+V(s_b7)*I(VS_s_b7)) }
RXei1 xei1 0 0.01
CXegt xegt 0 1
BXegt 0 xegt I={ -V(gt1)*I(VGT1)-V(gtp1)*I(VGTP1)-V(pk1)*I(VPK1)-V(gt2)*I(VGT2)-V(gtp2)*I(VGTP2)-V(pk2)*I(VPK2)-V(gt3)*I(VGT3)-V(gtp3)*I(VGTP3)-V(pk3)*I(VPK3)-V(gt4)*I(VGT4)-V(gtp4)*I(VGTP4)-V(pk4)*I(VPK4)-V(gt5)*I(VGT5)-V(gtp5)*I(VGTP5)-V(pk5)*I(VPK5) }
RXegt xegt 0 0.01
CXehi xehi 0 1
BXehi 0 xehi I={ -1.5*I(VHI) }
RXehi xehi 0 0.01
.ic V(tnk1)=0.9075 V(rail1)=0 V(sw1)=0.9075 V(tnk2)=0.9075 V(rail2)=0 V(sw2)=0.9075 V(tnk3)=0.9075 V(rail3)=0 V(sw3)=0.9075 V(tnk4)=0.9075 V(rail4)=0 V(sw4)=0.9075 V(tnk5)=0.9075 V(rail5)=0 V(sw5)=0.9075
.tran 0.1p 5724.37p 0 0.25p
.measure tran QLT1_Z FIND V(xqlt1) AT=1.500000p
.measure tran QLT1_O1 FIND V(xqlt1) AT=416.307972p
.measure tran QLT1_B1 FIND V(xqlt1) AT=801.000000p
.measure tran QLT1_R1 FIND V(xqlt1) AT=2599.000000p
.measure tran QLT1_Q1 FIND V(xqlt1) AT=2888.402596p
.measure tran QLT1_D FIND V(xqlt1) AT=5720.371102p
.measure tran EA1_Z FIND V(xea1) AT=1.500000p
.measure tran EA1_O1 FIND V(xea1) AT=416.307972p
.measure tran EA1_B1 FIND V(xea1) AT=801.000000p
.measure tran EA1_R1 FIND V(xea1) AT=2599.000000p
.measure tran EA1_Q1 FIND V(xea1) AT=2888.402596p
.measure tran EA1_D FIND V(xea1) AT=5720.371102p
.measure tran EB1_Z FIND V(xeb1) AT=1.500000p
.measure tran EB1_O1 FIND V(xeb1) AT=416.307972p
.measure tran EB1_B1 FIND V(xeb1) AT=801.000000p
.measure tran EB1_R1 FIND V(xeb1) AT=2599.000000p
.measure tran EB1_Q1 FIND V(xeb1) AT=2888.402596p
.measure tran EB1_D FIND V(xeb1) AT=5720.371102p
.measure tran ESW1_Z FIND V(xesw1) AT=1.500000p
.measure tran ESW1_O1 FIND V(xesw1) AT=416.307972p
.measure tran ESW1_B1 FIND V(xesw1) AT=801.000000p
.measure tran ESW1_R1 FIND V(xesw1) AT=2599.000000p
.measure tran ESW1_Q1 FIND V(xesw1) AT=2888.402596p
.measure tran ESW1_D FIND V(xesw1) AT=5720.371102p
.measure tran ER1_Z FIND V(xer1) AT=1.500000p
.measure tran ER1_O1 FIND V(xer1) AT=416.307972p
.measure tran ER1_B1 FIND V(xer1) AT=801.000000p
.measure tran ER1_R1 FIND V(xer1) AT=2599.000000p
.measure tran ER1_Q1 FIND V(xer1) AT=2888.402596p
.measure tran ER1_D FIND V(xer1) AT=5720.371102p
.measure tran QG1_Z FIND V(xqg1) AT=1.500000p
.measure tran QG1_O1 FIND V(xqg1) AT=416.307972p
.measure tran QG1_B1 FIND V(xqg1) AT=801.000000p
.measure tran QG1_R1 FIND V(xqg1) AT=2599.000000p
.measure tran QG1_Q1 FIND V(xqg1) AT=2888.402596p
.measure tran QG1_D FIND V(xqg1) AT=5720.371102p
.measure tran QLT2_Z FIND V(xqlt2) AT=1.500000p
.measure tran QLT2_O2 FIND V(xqlt2) AT=992.526079p
.measure tran QLT2_B2 FIND V(xqlt2) AT=1401.000000p
.measure tran QLT2_R2 FIND V(xqlt2) AT=3199.000000p
.measure tran QLT2_Q2 FIND V(xqlt2) AT=3468.143108p
.measure tran QLT2_D FIND V(xqlt2) AT=5720.371102p
.measure tran EA2_Z FIND V(xea2) AT=1.500000p
.measure tran EA2_O2 FIND V(xea2) AT=992.526079p
.measure tran EA2_B2 FIND V(xea2) AT=1401.000000p
.measure tran EA2_R2 FIND V(xea2) AT=3199.000000p
.measure tran EA2_Q2 FIND V(xea2) AT=3468.143108p
.measure tran EA2_D FIND V(xea2) AT=5720.371102p
.measure tran EB2_Z FIND V(xeb2) AT=1.500000p
.measure tran EB2_O2 FIND V(xeb2) AT=992.526079p
.measure tran EB2_B2 FIND V(xeb2) AT=1401.000000p
.measure tran EB2_R2 FIND V(xeb2) AT=3199.000000p
.measure tran EB2_Q2 FIND V(xeb2) AT=3468.143108p
.measure tran EB2_D FIND V(xeb2) AT=5720.371102p
.measure tran ESW2_Z FIND V(xesw2) AT=1.500000p
.measure tran ESW2_O2 FIND V(xesw2) AT=992.526079p
.measure tran ESW2_B2 FIND V(xesw2) AT=1401.000000p
.measure tran ESW2_R2 FIND V(xesw2) AT=3199.000000p
.measure tran ESW2_Q2 FIND V(xesw2) AT=3468.143108p
.measure tran ESW2_D FIND V(xesw2) AT=5720.371102p
.measure tran ER2_Z FIND V(xer2) AT=1.500000p
.measure tran ER2_O2 FIND V(xer2) AT=992.526079p
.measure tran ER2_B2 FIND V(xer2) AT=1401.000000p
.measure tran ER2_R2 FIND V(xer2) AT=3199.000000p
.measure tran ER2_Q2 FIND V(xer2) AT=3468.143108p
.measure tran ER2_D FIND V(xer2) AT=5720.371102p
.measure tran QG2_Z FIND V(xqg2) AT=1.500000p
.measure tran QG2_O2 FIND V(xqg2) AT=992.526079p
.measure tran QG2_B2 FIND V(xqg2) AT=1401.000000p
.measure tran QG2_R2 FIND V(xqg2) AT=3199.000000p
.measure tran QG2_Q2 FIND V(xqg2) AT=3468.143108p
.measure tran QG2_D FIND V(xqg2) AT=5720.371102p
.measure tran QLT3_Z FIND V(xqlt3) AT=1.500000p
.measure tran QLT3_O3 FIND V(xqlt3) AT=1597.470959p
.measure tran QLT3_B3 FIND V(xqlt3) AT=2001.000000p
.measure tran QLT3_R3 FIND V(xqlt3) AT=3799.000000p
.measure tran QLT3_Q3 FIND V(xqlt3) AT=4059.206053p
.measure tran QLT3_D FIND V(xqlt3) AT=5720.371102p
.measure tran EA3_Z FIND V(xea3) AT=1.500000p
.measure tran EA3_O3 FIND V(xea3) AT=1597.470959p
.measure tran EA3_B3 FIND V(xea3) AT=2001.000000p
.measure tran EA3_R3 FIND V(xea3) AT=3799.000000p
.measure tran EA3_Q3 FIND V(xea3) AT=4059.206053p
.measure tran EA3_D FIND V(xea3) AT=5720.371102p
.measure tran EB3_Z FIND V(xeb3) AT=1.500000p
.measure tran EB3_O3 FIND V(xeb3) AT=1597.470959p
.measure tran EB3_B3 FIND V(xeb3) AT=2001.000000p
.measure tran EB3_R3 FIND V(xeb3) AT=3799.000000p
.measure tran EB3_Q3 FIND V(xeb3) AT=4059.206053p
.measure tran EB3_D FIND V(xeb3) AT=5720.371102p
.measure tran ESW3_Z FIND V(xesw3) AT=1.500000p
.measure tran ESW3_O3 FIND V(xesw3) AT=1597.470959p
.measure tran ESW3_B3 FIND V(xesw3) AT=2001.000000p
.measure tran ESW3_R3 FIND V(xesw3) AT=3799.000000p
.measure tran ESW3_Q3 FIND V(xesw3) AT=4059.206053p
.measure tran ESW3_D FIND V(xesw3) AT=5720.371102p
.measure tran ER3_Z FIND V(xer3) AT=1.500000p
.measure tran ER3_O3 FIND V(xer3) AT=1597.470959p
.measure tran ER3_B3 FIND V(xer3) AT=2001.000000p
.measure tran ER3_R3 FIND V(xer3) AT=3799.000000p
.measure tran ER3_Q3 FIND V(xer3) AT=4059.206053p
.measure tran ER3_D FIND V(xer3) AT=5720.371102p
.measure tran QG3_Z FIND V(xqg3) AT=1.500000p
.measure tran QG3_O3 FIND V(xqg3) AT=1597.470959p
.measure tran QG3_B3 FIND V(xqg3) AT=2001.000000p
.measure tran QG3_R3 FIND V(xqg3) AT=3799.000000p
.measure tran QG3_Q3 FIND V(xqg3) AT=4059.206053p
.measure tran QG3_D FIND V(xqg3) AT=5720.371102p
.measure tran QLT4_Z FIND V(xqlt4) AT=1.500000p
.measure tran QLT4_O4 FIND V(xqlt4) AT=2157.297620p
.measure tran QLT4_B4 FIND V(xqlt4) AT=2601.000000p
.measure tran QLT4_R4 FIND V(xqlt4) AT=4399.000000p
.measure tran QLT4_Q4 FIND V(xqlt4) AT=4585.296703p
.measure tran QLT4_D FIND V(xqlt4) AT=5720.371102p
.measure tran EA4_Z FIND V(xea4) AT=1.500000p
.measure tran EA4_O4 FIND V(xea4) AT=2157.297620p
.measure tran EA4_B4 FIND V(xea4) AT=2601.000000p
.measure tran EA4_R4 FIND V(xea4) AT=4399.000000p
.measure tran EA4_Q4 FIND V(xea4) AT=4585.296703p
.measure tran EA4_D FIND V(xea4) AT=5720.371102p
.measure tran EB4_Z FIND V(xeb4) AT=1.500000p
.measure tran EB4_O4 FIND V(xeb4) AT=2157.297620p
.measure tran EB4_B4 FIND V(xeb4) AT=2601.000000p
.measure tran EB4_R4 FIND V(xeb4) AT=4399.000000p
.measure tran EB4_Q4 FIND V(xeb4) AT=4585.296703p
.measure tran EB4_D FIND V(xeb4) AT=5720.371102p
.measure tran ESW4_Z FIND V(xesw4) AT=1.500000p
.measure tran ESW4_O4 FIND V(xesw4) AT=2157.297620p
.measure tran ESW4_B4 FIND V(xesw4) AT=2601.000000p
.measure tran ESW4_R4 FIND V(xesw4) AT=4399.000000p
.measure tran ESW4_Q4 FIND V(xesw4) AT=4585.296703p
.measure tran ESW4_D FIND V(xesw4) AT=5720.371102p
.measure tran ER4_Z FIND V(xer4) AT=1.500000p
.measure tran ER4_O4 FIND V(xer4) AT=2157.297620p
.measure tran ER4_B4 FIND V(xer4) AT=2601.000000p
.measure tran ER4_R4 FIND V(xer4) AT=4399.000000p
.measure tran ER4_Q4 FIND V(xer4) AT=4585.296703p
.measure tran ER4_D FIND V(xer4) AT=5720.371102p
.measure tran QG4_Z FIND V(xqg4) AT=1.500000p
.measure tran QG4_O4 FIND V(xqg4) AT=2157.297620p
.measure tran QG4_B4 FIND V(xqg4) AT=2601.000000p
.measure tran QG4_R4 FIND V(xqg4) AT=4399.000000p
.measure tran QG4_Q4 FIND V(xqg4) AT=4585.296703p
.measure tran QG4_D FIND V(xqg4) AT=5720.371102p
.measure tran QLT5_Z FIND V(xqlt5) AT=1.500000p
.measure tran QLT5_O5 FIND V(xqlt5) AT=2783.175540p
.measure tran QLT5_B5 FIND V(xqlt5) AT=3201.000000p
.measure tran QLT5_R5 FIND V(xqlt5) AT=4999.000000p
.measure tran QLT5_Q5 FIND V(xqlt5) AT=5225.371102p
.measure tran QLT5_D FIND V(xqlt5) AT=5720.371102p
.measure tran EA5_Z FIND V(xea5) AT=1.500000p
.measure tran EA5_O5 FIND V(xea5) AT=2783.175540p
.measure tran EA5_B5 FIND V(xea5) AT=3201.000000p
.measure tran EA5_R5 FIND V(xea5) AT=4999.000000p
.measure tran EA5_Q5 FIND V(xea5) AT=5225.371102p
.measure tran EA5_D FIND V(xea5) AT=5720.371102p
.measure tran EB5_Z FIND V(xeb5) AT=1.500000p
.measure tran EB5_O5 FIND V(xeb5) AT=2783.175540p
.measure tran EB5_B5 FIND V(xeb5) AT=3201.000000p
.measure tran EB5_R5 FIND V(xeb5) AT=4999.000000p
.measure tran EB5_Q5 FIND V(xeb5) AT=5225.371102p
.measure tran EB5_D FIND V(xeb5) AT=5720.371102p
.measure tran ESW5_Z FIND V(xesw5) AT=1.500000p
.measure tran ESW5_O5 FIND V(xesw5) AT=2783.175540p
.measure tran ESW5_B5 FIND V(xesw5) AT=3201.000000p
.measure tran ESW5_R5 FIND V(xesw5) AT=4999.000000p
.measure tran ESW5_Q5 FIND V(xesw5) AT=5225.371102p
.measure tran ESW5_D FIND V(xesw5) AT=5720.371102p
.measure tran ER5_Z FIND V(xer5) AT=1.500000p
.measure tran ER5_O5 FIND V(xer5) AT=2783.175540p
.measure tran ER5_B5 FIND V(xer5) AT=3201.000000p
.measure tran ER5_R5 FIND V(xer5) AT=4999.000000p
.measure tran ER5_Q5 FIND V(xer5) AT=5225.371102p
.measure tran ER5_D FIND V(xer5) AT=5720.371102p
.measure tran QG5_Z FIND V(xqg5) AT=1.500000p
.measure tran QG5_O5 FIND V(xqg5) AT=2783.175540p
.measure tran QG5_B5 FIND V(xqg5) AT=3201.000000p
.measure tran QG5_R5 FIND V(xqg5) AT=4999.000000p
.measure tran QG5_Q5 FIND V(xqg5) AT=5225.371102p
.measure tran QG5_D FIND V(xqg5) AT=5720.371102p
.measure tran QI1_Z FIND V(xqi1) AT=1.500000p
.measure tran QI1_O1 FIND V(xqi1) AT=416.307972p
.measure tran QI1_B1 FIND V(xqi1) AT=801.000000p
.measure tran QI1_R1 FIND V(xqi1) AT=2599.000000p
.measure tran QI1_Q1 FIND V(xqi1) AT=2888.402596p
.measure tran QI1_D FIND V(xqi1) AT=5720.371102p
.measure tran EI1_Z FIND V(xei1) AT=1.500000p
.measure tran EI1_O1 FIND V(xei1) AT=416.307972p
.measure tran EI1_B1 FIND V(xei1) AT=801.000000p
.measure tran EI1_R1 FIND V(xei1) AT=2599.000000p
.measure tran EI1_Q1 FIND V(xei1) AT=2888.402596p
.measure tran EI1_D FIND V(xei1) AT=5720.371102p
.measure tran EGT_Z FIND V(xegt) AT=1.500000p
.measure tran EGT_O1 FIND V(xegt) AT=416.307972p
.measure tran EGT_B1 FIND V(xegt) AT=801.000000p
.measure tran EGT_R1 FIND V(xegt) AT=2599.000000p
.measure tran EGT_Q1 FIND V(xegt) AT=2888.402596p
.measure tran EGT_O2 FIND V(xegt) AT=992.526079p
.measure tran EGT_B2 FIND V(xegt) AT=1401.000000p
.measure tran EGT_R2 FIND V(xegt) AT=3199.000000p
.measure tran EGT_Q2 FIND V(xegt) AT=3468.143108p
.measure tran EGT_O3 FIND V(xegt) AT=1597.470959p
.measure tran EGT_B3 FIND V(xegt) AT=2001.000000p
.measure tran EGT_R3 FIND V(xegt) AT=3799.000000p
.measure tran EGT_Q3 FIND V(xegt) AT=4059.206053p
.measure tran EGT_O4 FIND V(xegt) AT=2157.297620p
.measure tran EGT_B4 FIND V(xegt) AT=2601.000000p
.measure tran EGT_R4 FIND V(xegt) AT=4399.000000p
.measure tran EGT_Q4 FIND V(xegt) AT=4585.296703p
.measure tran EGT_O5 FIND V(xegt) AT=2783.175540p
.measure tran EGT_B5 FIND V(xegt) AT=3201.000000p
.measure tran EGT_R5 FIND V(xegt) AT=4999.000000p
.measure tran EGT_Q5 FIND V(xegt) AT=5225.371102p
.measure tran EGT_D FIND V(xegt) AT=5720.371102p
.measure tran EHI_Z FIND V(xehi) AT=1.500000p
.measure tran EHI_O1 FIND V(xehi) AT=416.307972p
.measure tran EHI_B1 FIND V(xehi) AT=801.000000p
.measure tran EHI_R1 FIND V(xehi) AT=2599.000000p
.measure tran EHI_Q1 FIND V(xehi) AT=2888.402596p
.measure tran EHI_O2 FIND V(xehi) AT=992.526079p
.measure tran EHI_B2 FIND V(xehi) AT=1401.000000p
.measure tran EHI_R2 FIND V(xehi) AT=3199.000000p
.measure tran EHI_Q2 FIND V(xehi) AT=3468.143108p
.measure tran EHI_O3 FIND V(xehi) AT=1597.470959p
.measure tran EHI_B3 FIND V(xehi) AT=2001.000000p
.measure tran EHI_R3 FIND V(xehi) AT=3799.000000p
.measure tran EHI_Q3 FIND V(xehi) AT=4059.206053p
.measure tran EHI_O4 FIND V(xehi) AT=2157.297620p
.measure tran EHI_B4 FIND V(xehi) AT=2601.000000p
.measure tran EHI_R4 FIND V(xehi) AT=4399.000000p
.measure tran EHI_Q4 FIND V(xehi) AT=4585.296703p
.measure tran EHI_O5 FIND V(xehi) AT=2783.175540p
.measure tran EHI_B5 FIND V(xehi) AT=3201.000000p
.measure tran EHI_R5 FIND V(xehi) AT=4999.000000p
.measure tran EHI_Q5 FIND V(xehi) AT=5225.371102p
.measure tran EHI_D FIND V(xehi) AT=5720.371102p
.measure tran VR1Z FIND V(rail1) AT=1.500000p
.measure tran VT1Z FIND V(tnk1) AT=1.500000p
.measure tran VR1O1 FIND V(rail1) AT=416.307972p
.measure tran VT1O1 FIND V(tnk1) AT=416.307972p
.measure tran VR1B1 FIND V(rail1) AT=801.000000p
.measure tran VT1B1 FIND V(tnk1) AT=801.000000p
.measure tran VR1R1 FIND V(rail1) AT=2599.000000p
.measure tran VT1R1 FIND V(tnk1) AT=2599.000000p
.measure tran VR1Q1 FIND V(rail1) AT=2888.402596p
.measure tran VT1Q1 FIND V(tnk1) AT=2888.402596p
.measure tran VR1O2 FIND V(rail1) AT=992.526079p
.measure tran VT1O2 FIND V(tnk1) AT=992.526079p
.measure tran VR1B2 FIND V(rail1) AT=1401.000000p
.measure tran VT1B2 FIND V(tnk1) AT=1401.000000p
.measure tran VR1R2 FIND V(rail1) AT=3199.000000p
.measure tran VT1R2 FIND V(tnk1) AT=3199.000000p
.measure tran VR1Q2 FIND V(rail1) AT=3468.143108p
.measure tran VT1Q2 FIND V(tnk1) AT=3468.143108p
.measure tran VR1O3 FIND V(rail1) AT=1597.470959p
.measure tran VT1O3 FIND V(tnk1) AT=1597.470959p
.measure tran VR1B3 FIND V(rail1) AT=2001.000000p
.measure tran VT1B3 FIND V(tnk1) AT=2001.000000p
.measure tran VR1R3 FIND V(rail1) AT=3799.000000p
.measure tran VT1R3 FIND V(tnk1) AT=3799.000000p
.measure tran VR1Q3 FIND V(rail1) AT=4059.206053p
.measure tran VT1Q3 FIND V(tnk1) AT=4059.206053p
.measure tran VR1O4 FIND V(rail1) AT=2157.297620p
.measure tran VT1O4 FIND V(tnk1) AT=2157.297620p
.measure tran VR1B4 FIND V(rail1) AT=2601.000000p
.measure tran VT1B4 FIND V(tnk1) AT=2601.000000p
.measure tran VR1R4 FIND V(rail1) AT=4399.000000p
.measure tran VT1R4 FIND V(tnk1) AT=4399.000000p
.measure tran VR1Q4 FIND V(rail1) AT=4585.296703p
.measure tran VT1Q4 FIND V(tnk1) AT=4585.296703p
.measure tran VR1O5 FIND V(rail1) AT=2783.175540p
.measure tran VT1O5 FIND V(tnk1) AT=2783.175540p
.measure tran VR1B5 FIND V(rail1) AT=3201.000000p
.measure tran VT1B5 FIND V(tnk1) AT=3201.000000p
.measure tran VR1R5 FIND V(rail1) AT=4999.000000p
.measure tran VT1R5 FIND V(tnk1) AT=4999.000000p
.measure tran VR1Q5 FIND V(rail1) AT=5225.371102p
.measure tran VT1Q5 FIND V(tnk1) AT=5225.371102p
.measure tran VR1D FIND V(rail1) AT=5720.371102p
.measure tran VT1D FIND V(tnk1) AT=5720.371102p
.measure tran VR1PK MAX V(rail1) FROM=200p TO=5724.37p
.measure tran IZ1 FIND I(L1) AT=416.307972p
.measure tran IZQ1 FIND I(L1) AT=2888.402596p
.measure tran IPK1 MAX I(L1) FROM=200p TO=5724.37p
.measure tran O1_0B FIND V(o1_0) AT=801.000000p
.measure tran O1_0E FIND V(o1_0) AT=5720.371102p
.measure tran O1_0O FIND V(o1_0) AT=416.307972p
.measure tran O1_0Q FIND V(o1_0) AT=2888.402596p
.measure tran O1_1B FIND V(o1_1) AT=801.000000p
.measure tran O1_1E FIND V(o1_1) AT=5720.371102p
.measure tran O1_1O FIND V(o1_1) AT=416.307972p
.measure tran O1_1Q FIND V(o1_1) AT=2888.402596p
.measure tran O1_2B FIND V(o1_2) AT=801.000000p
.measure tran O1_2E FIND V(o1_2) AT=5720.371102p
.measure tran O1_2O FIND V(o1_2) AT=416.307972p
.measure tran O1_2Q FIND V(o1_2) AT=2888.402596p
.measure tran O1_3B FIND V(o1_3) AT=801.000000p
.measure tran O1_3E FIND V(o1_3) AT=5720.371102p
.measure tran O1_3O FIND V(o1_3) AT=416.307972p
.measure tran O1_3Q FIND V(o1_3) AT=2888.402596p
.measure tran O1_4B FIND V(o1_4) AT=801.000000p
.measure tran O1_4E FIND V(o1_4) AT=5720.371102p
.measure tran O1_4O FIND V(o1_4) AT=416.307972p
.measure tran O1_4Q FIND V(o1_4) AT=2888.402596p
.measure tran O1_5B FIND V(o1_5) AT=801.000000p
.measure tran O1_5E FIND V(o1_5) AT=5720.371102p
.measure tran O1_5O FIND V(o1_5) AT=416.307972p
.measure tran O1_5Q FIND V(o1_5) AT=2888.402596p
.measure tran O1_6B FIND V(o1_6) AT=801.000000p
.measure tran O1_6E FIND V(o1_6) AT=5720.371102p
.measure tran O1_6O FIND V(o1_6) AT=416.307972p
.measure tran O1_6Q FIND V(o1_6) AT=2888.402596p
.measure tran O1_7B FIND V(o1_7) AT=801.000000p
.measure tran O1_7E FIND V(o1_7) AT=5720.371102p
.measure tran O1_7O FIND V(o1_7) AT=416.307972p
.measure tran O1_7Q FIND V(o1_7) AT=2888.402596p
.measure tran O1_8B FIND V(o1_8) AT=801.000000p
.measure tran O1_8E FIND V(o1_8) AT=5720.371102p
.measure tran O1_8O FIND V(o1_8) AT=416.307972p
.measure tran O1_8Q FIND V(o1_8) AT=2888.402596p
.measure tran O1_9B FIND V(o1_9) AT=801.000000p
.measure tran O1_9E FIND V(o1_9) AT=5720.371102p
.measure tran O1_9O FIND V(o1_9) AT=416.307972p
.measure tran O1_9Q FIND V(o1_9) AT=2888.402596p
.measure tran O1_10B FIND V(o1_10) AT=801.000000p
.measure tran O1_10E FIND V(o1_10) AT=5720.371102p
.measure tran O1_10O FIND V(o1_10) AT=416.307972p
.measure tran O1_10Q FIND V(o1_10) AT=2888.402596p
.measure tran O1_11B FIND V(o1_11) AT=801.000000p
.measure tran O1_11E FIND V(o1_11) AT=5720.371102p
.measure tran O1_11O FIND V(o1_11) AT=416.307972p
.measure tran O1_11Q FIND V(o1_11) AT=2888.402596p
.measure tran O1_12B FIND V(o1_12) AT=801.000000p
.measure tran O1_12E FIND V(o1_12) AT=5720.371102p
.measure tran O1_12O FIND V(o1_12) AT=416.307972p
.measure tran O1_12Q FIND V(o1_12) AT=2888.402596p
.measure tran O1_13B FIND V(o1_13) AT=801.000000p
.measure tran O1_13E FIND V(o1_13) AT=5720.371102p
.measure tran O1_13O FIND V(o1_13) AT=416.307972p
.measure tran O1_13Q FIND V(o1_13) AT=2888.402596p
.measure tran O1_14B FIND V(o1_14) AT=801.000000p
.measure tran O1_14E FIND V(o1_14) AT=5720.371102p
.measure tran O1_14O FIND V(o1_14) AT=416.307972p
.measure tran O1_14Q FIND V(o1_14) AT=2888.402596p
.measure tran VR2Z FIND V(rail2) AT=1.500000p
.measure tran VT2Z FIND V(tnk2) AT=1.500000p
.measure tran VR2O1 FIND V(rail2) AT=416.307972p
.measure tran VT2O1 FIND V(tnk2) AT=416.307972p
.measure tran VR2B1 FIND V(rail2) AT=801.000000p
.measure tran VT2B1 FIND V(tnk2) AT=801.000000p
.measure tran VR2R1 FIND V(rail2) AT=2599.000000p
.measure tran VT2R1 FIND V(tnk2) AT=2599.000000p
.measure tran VR2Q1 FIND V(rail2) AT=2888.402596p
.measure tran VT2Q1 FIND V(tnk2) AT=2888.402596p
.measure tran VR2O2 FIND V(rail2) AT=992.526079p
.measure tran VT2O2 FIND V(tnk2) AT=992.526079p
.measure tran VR2B2 FIND V(rail2) AT=1401.000000p
.measure tran VT2B2 FIND V(tnk2) AT=1401.000000p
.measure tran VR2R2 FIND V(rail2) AT=3199.000000p
.measure tran VT2R2 FIND V(tnk2) AT=3199.000000p
.measure tran VR2Q2 FIND V(rail2) AT=3468.143108p
.measure tran VT2Q2 FIND V(tnk2) AT=3468.143108p
.measure tran VR2O3 FIND V(rail2) AT=1597.470959p
.measure tran VT2O3 FIND V(tnk2) AT=1597.470959p
.measure tran VR2B3 FIND V(rail2) AT=2001.000000p
.measure tran VT2B3 FIND V(tnk2) AT=2001.000000p
.measure tran VR2R3 FIND V(rail2) AT=3799.000000p
.measure tran VT2R3 FIND V(tnk2) AT=3799.000000p
.measure tran VR2Q3 FIND V(rail2) AT=4059.206053p
.measure tran VT2Q3 FIND V(tnk2) AT=4059.206053p
.measure tran VR2O4 FIND V(rail2) AT=2157.297620p
.measure tran VT2O4 FIND V(tnk2) AT=2157.297620p
.measure tran VR2B4 FIND V(rail2) AT=2601.000000p
.measure tran VT2B4 FIND V(tnk2) AT=2601.000000p
.measure tran VR2R4 FIND V(rail2) AT=4399.000000p
.measure tran VT2R4 FIND V(tnk2) AT=4399.000000p
.measure tran VR2Q4 FIND V(rail2) AT=4585.296703p
.measure tran VT2Q4 FIND V(tnk2) AT=4585.296703p
.measure tran VR2O5 FIND V(rail2) AT=2783.175540p
.measure tran VT2O5 FIND V(tnk2) AT=2783.175540p
.measure tran VR2B5 FIND V(rail2) AT=3201.000000p
.measure tran VT2B5 FIND V(tnk2) AT=3201.000000p
.measure tran VR2R5 FIND V(rail2) AT=4999.000000p
.measure tran VT2R5 FIND V(tnk2) AT=4999.000000p
.measure tran VR2Q5 FIND V(rail2) AT=5225.371102p
.measure tran VT2Q5 FIND V(tnk2) AT=5225.371102p
.measure tran VR2D FIND V(rail2) AT=5720.371102p
.measure tran VT2D FIND V(tnk2) AT=5720.371102p
.measure tran VR2PK MAX V(rail2) FROM=800p TO=5724.37p
.measure tran IZ2 FIND I(L2) AT=992.526079p
.measure tran IZQ2 FIND I(L2) AT=3468.143108p
.measure tran IPK2 MAX I(L2) FROM=800p TO=5724.37p
.measure tran O2_0B FIND V(o2_0) AT=1401.000000p
.measure tran O2_0E FIND V(o2_0) AT=5720.371102p
.measure tran O2_0O FIND V(o2_0) AT=992.526079p
.measure tran O2_0Q FIND V(o2_0) AT=3468.143108p
.measure tran O2_1B FIND V(o2_1) AT=1401.000000p
.measure tran O2_1E FIND V(o2_1) AT=5720.371102p
.measure tran O2_1O FIND V(o2_1) AT=992.526079p
.measure tran O2_1Q FIND V(o2_1) AT=3468.143108p
.measure tran O2_2B FIND V(o2_2) AT=1401.000000p
.measure tran O2_2E FIND V(o2_2) AT=5720.371102p
.measure tran O2_2O FIND V(o2_2) AT=992.526079p
.measure tran O2_2Q FIND V(o2_2) AT=3468.143108p
.measure tran O2_3B FIND V(o2_3) AT=1401.000000p
.measure tran O2_3E FIND V(o2_3) AT=5720.371102p
.measure tran O2_3O FIND V(o2_3) AT=992.526079p
.measure tran O2_3Q FIND V(o2_3) AT=3468.143108p
.measure tran O2_4B FIND V(o2_4) AT=1401.000000p
.measure tran O2_4E FIND V(o2_4) AT=5720.371102p
.measure tran O2_4O FIND V(o2_4) AT=992.526079p
.measure tran O2_4Q FIND V(o2_4) AT=3468.143108p
.measure tran O2_5B FIND V(o2_5) AT=1401.000000p
.measure tran O2_5E FIND V(o2_5) AT=5720.371102p
.measure tran O2_5O FIND V(o2_5) AT=992.526079p
.measure tran O2_5Q FIND V(o2_5) AT=3468.143108p
.measure tran O2_6B FIND V(o2_6) AT=1401.000000p
.measure tran O2_6E FIND V(o2_6) AT=5720.371102p
.measure tran O2_6O FIND V(o2_6) AT=992.526079p
.measure tran O2_6Q FIND V(o2_6) AT=3468.143108p
.measure tran O2_7B FIND V(o2_7) AT=1401.000000p
.measure tran O2_7E FIND V(o2_7) AT=5720.371102p
.measure tran O2_7O FIND V(o2_7) AT=992.526079p
.measure tran O2_7Q FIND V(o2_7) AT=3468.143108p
.measure tran O2_8B FIND V(o2_8) AT=1401.000000p
.measure tran O2_8E FIND V(o2_8) AT=5720.371102p
.measure tran O2_8O FIND V(o2_8) AT=992.526079p
.measure tran O2_8Q FIND V(o2_8) AT=3468.143108p
.measure tran O2_9B FIND V(o2_9) AT=1401.000000p
.measure tran O2_9E FIND V(o2_9) AT=5720.371102p
.measure tran O2_9O FIND V(o2_9) AT=992.526079p
.measure tran O2_9Q FIND V(o2_9) AT=3468.143108p
.measure tran O2_10B FIND V(o2_10) AT=1401.000000p
.measure tran O2_10E FIND V(o2_10) AT=5720.371102p
.measure tran O2_10O FIND V(o2_10) AT=992.526079p
.measure tran O2_10Q FIND V(o2_10) AT=3468.143108p
.measure tran O2_11B FIND V(o2_11) AT=1401.000000p
.measure tran O2_11E FIND V(o2_11) AT=5720.371102p
.measure tran O2_11O FIND V(o2_11) AT=992.526079p
.measure tran O2_11Q FIND V(o2_11) AT=3468.143108p
.measure tran O2_12B FIND V(o2_12) AT=1401.000000p
.measure tran O2_12E FIND V(o2_12) AT=5720.371102p
.measure tran O2_12O FIND V(o2_12) AT=992.526079p
.measure tran O2_12Q FIND V(o2_12) AT=3468.143108p
.measure tran O2_13B FIND V(o2_13) AT=1401.000000p
.measure tran O2_13E FIND V(o2_13) AT=5720.371102p
.measure tran O2_13O FIND V(o2_13) AT=992.526079p
.measure tran O2_13Q FIND V(o2_13) AT=3468.143108p
.measure tran O2_14B FIND V(o2_14) AT=1401.000000p
.measure tran O2_14E FIND V(o2_14) AT=5720.371102p
.measure tran O2_14O FIND V(o2_14) AT=992.526079p
.measure tran O2_14Q FIND V(o2_14) AT=3468.143108p
.measure tran O2_15B FIND V(o2_15) AT=1401.000000p
.measure tran O2_15E FIND V(o2_15) AT=5720.371102p
.measure tran O2_15O FIND V(o2_15) AT=992.526079p
.measure tran O2_15Q FIND V(o2_15) AT=3468.143108p
.measure tran O2_16B FIND V(o2_16) AT=1401.000000p
.measure tran O2_16E FIND V(o2_16) AT=5720.371102p
.measure tran O2_16O FIND V(o2_16) AT=992.526079p
.measure tran O2_16Q FIND V(o2_16) AT=3468.143108p
.measure tran O2_17B FIND V(o2_17) AT=1401.000000p
.measure tran O2_17E FIND V(o2_17) AT=5720.371102p
.measure tran O2_17O FIND V(o2_17) AT=992.526079p
.measure tran O2_17Q FIND V(o2_17) AT=3468.143108p
.measure tran O2_18B FIND V(o2_18) AT=1401.000000p
.measure tran O2_18E FIND V(o2_18) AT=5720.371102p
.measure tran O2_18O FIND V(o2_18) AT=992.526079p
.measure tran O2_18Q FIND V(o2_18) AT=3468.143108p
.measure tran O2_19B FIND V(o2_19) AT=1401.000000p
.measure tran O2_19E FIND V(o2_19) AT=5720.371102p
.measure tran O2_19O FIND V(o2_19) AT=992.526079p
.measure tran O2_19Q FIND V(o2_19) AT=3468.143108p
.measure tran VR3Z FIND V(rail3) AT=1.500000p
.measure tran VT3Z FIND V(tnk3) AT=1.500000p
.measure tran VR3O1 FIND V(rail3) AT=416.307972p
.measure tran VT3O1 FIND V(tnk3) AT=416.307972p
.measure tran VR3B1 FIND V(rail3) AT=801.000000p
.measure tran VT3B1 FIND V(tnk3) AT=801.000000p
.measure tran VR3R1 FIND V(rail3) AT=2599.000000p
.measure tran VT3R1 FIND V(tnk3) AT=2599.000000p
.measure tran VR3Q1 FIND V(rail3) AT=2888.402596p
.measure tran VT3Q1 FIND V(tnk3) AT=2888.402596p
.measure tran VR3O2 FIND V(rail3) AT=992.526079p
.measure tran VT3O2 FIND V(tnk3) AT=992.526079p
.measure tran VR3B2 FIND V(rail3) AT=1401.000000p
.measure tran VT3B2 FIND V(tnk3) AT=1401.000000p
.measure tran VR3R2 FIND V(rail3) AT=3199.000000p
.measure tran VT3R2 FIND V(tnk3) AT=3199.000000p
.measure tran VR3Q2 FIND V(rail3) AT=3468.143108p
.measure tran VT3Q2 FIND V(tnk3) AT=3468.143108p
.measure tran VR3O3 FIND V(rail3) AT=1597.470959p
.measure tran VT3O3 FIND V(tnk3) AT=1597.470959p
.measure tran VR3B3 FIND V(rail3) AT=2001.000000p
.measure tran VT3B3 FIND V(tnk3) AT=2001.000000p
.measure tran VR3R3 FIND V(rail3) AT=3799.000000p
.measure tran VT3R3 FIND V(tnk3) AT=3799.000000p
.measure tran VR3Q3 FIND V(rail3) AT=4059.206053p
.measure tran VT3Q3 FIND V(tnk3) AT=4059.206053p
.measure tran VR3O4 FIND V(rail3) AT=2157.297620p
.measure tran VT3O4 FIND V(tnk3) AT=2157.297620p
.measure tran VR3B4 FIND V(rail3) AT=2601.000000p
.measure tran VT3B4 FIND V(tnk3) AT=2601.000000p
.measure tran VR3R4 FIND V(rail3) AT=4399.000000p
.measure tran VT3R4 FIND V(tnk3) AT=4399.000000p
.measure tran VR3Q4 FIND V(rail3) AT=4585.296703p
.measure tran VT3Q4 FIND V(tnk3) AT=4585.296703p
.measure tran VR3O5 FIND V(rail3) AT=2783.175540p
.measure tran VT3O5 FIND V(tnk3) AT=2783.175540p
.measure tran VR3B5 FIND V(rail3) AT=3201.000000p
.measure tran VT3B5 FIND V(tnk3) AT=3201.000000p
.measure tran VR3R5 FIND V(rail3) AT=4999.000000p
.measure tran VT3R5 FIND V(tnk3) AT=4999.000000p
.measure tran VR3Q5 FIND V(rail3) AT=5225.371102p
.measure tran VT3Q5 FIND V(tnk3) AT=5225.371102p
.measure tran VR3D FIND V(rail3) AT=5720.371102p
.measure tran VT3D FIND V(tnk3) AT=5720.371102p
.measure tran VR3PK MAX V(rail3) FROM=1400p TO=5724.37p
.measure tran IZ3 FIND I(L3) AT=1597.470959p
.measure tran IZQ3 FIND I(L3) AT=4059.206053p
.measure tran IPK3 MAX I(L3) FROM=1400p TO=5724.37p
.measure tran O3_0B FIND V(o3_0) AT=2001.000000p
.measure tran O3_0E FIND V(o3_0) AT=5720.371102p
.measure tran O3_0O FIND V(o3_0) AT=1597.470959p
.measure tran O3_0Q FIND V(o3_0) AT=4059.206053p
.measure tran O3_1B FIND V(o3_1) AT=2001.000000p
.measure tran O3_1E FIND V(o3_1) AT=5720.371102p
.measure tran O3_1O FIND V(o3_1) AT=1597.470959p
.measure tran O3_1Q FIND V(o3_1) AT=4059.206053p
.measure tran O3_2B FIND V(o3_2) AT=2001.000000p
.measure tran O3_2E FIND V(o3_2) AT=5720.371102p
.measure tran O3_2O FIND V(o3_2) AT=1597.470959p
.measure tran O3_2Q FIND V(o3_2) AT=4059.206053p
.measure tran O3_3B FIND V(o3_3) AT=2001.000000p
.measure tran O3_3E FIND V(o3_3) AT=5720.371102p
.measure tran O3_3O FIND V(o3_3) AT=1597.470959p
.measure tran O3_3Q FIND V(o3_3) AT=4059.206053p
.measure tran O3_4B FIND V(o3_4) AT=2001.000000p
.measure tran O3_4E FIND V(o3_4) AT=5720.371102p
.measure tran O3_4O FIND V(o3_4) AT=1597.470959p
.measure tran O3_4Q FIND V(o3_4) AT=4059.206053p
.measure tran O3_5B FIND V(o3_5) AT=2001.000000p
.measure tran O3_5E FIND V(o3_5) AT=5720.371102p
.measure tran O3_5O FIND V(o3_5) AT=1597.470959p
.measure tran O3_5Q FIND V(o3_5) AT=4059.206053p
.measure tran O3_6B FIND V(o3_6) AT=2001.000000p
.measure tran O3_6E FIND V(o3_6) AT=5720.371102p
.measure tran O3_6O FIND V(o3_6) AT=1597.470959p
.measure tran O3_6Q FIND V(o3_6) AT=4059.206053p
.measure tran O3_7B FIND V(o3_7) AT=2001.000000p
.measure tran O3_7E FIND V(o3_7) AT=5720.371102p
.measure tran O3_7O FIND V(o3_7) AT=1597.470959p
.measure tran O3_7Q FIND V(o3_7) AT=4059.206053p
.measure tran O3_8B FIND V(o3_8) AT=2001.000000p
.measure tran O3_8E FIND V(o3_8) AT=5720.371102p
.measure tran O3_8O FIND V(o3_8) AT=1597.470959p
.measure tran O3_8Q FIND V(o3_8) AT=4059.206053p
.measure tran O3_9B FIND V(o3_9) AT=2001.000000p
.measure tran O3_9E FIND V(o3_9) AT=5720.371102p
.measure tran O3_9O FIND V(o3_9) AT=1597.470959p
.measure tran O3_9Q FIND V(o3_9) AT=4059.206053p
.measure tran O3_10B FIND V(o3_10) AT=2001.000000p
.measure tran O3_10E FIND V(o3_10) AT=5720.371102p
.measure tran O3_10O FIND V(o3_10) AT=1597.470959p
.measure tran O3_10Q FIND V(o3_10) AT=4059.206053p
.measure tran O3_11B FIND V(o3_11) AT=2001.000000p
.measure tran O3_11E FIND V(o3_11) AT=5720.371102p
.measure tran O3_11O FIND V(o3_11) AT=1597.470959p
.measure tran O3_11Q FIND V(o3_11) AT=4059.206053p
.measure tran O3_12B FIND V(o3_12) AT=2001.000000p
.measure tran O3_12E FIND V(o3_12) AT=5720.371102p
.measure tran O3_12O FIND V(o3_12) AT=1597.470959p
.measure tran O3_12Q FIND V(o3_12) AT=4059.206053p
.measure tran O3_13B FIND V(o3_13) AT=2001.000000p
.measure tran O3_13E FIND V(o3_13) AT=5720.371102p
.measure tran O3_13O FIND V(o3_13) AT=1597.470959p
.measure tran O3_13Q FIND V(o3_13) AT=4059.206053p
.measure tran O3_14B FIND V(o3_14) AT=2001.000000p
.measure tran O3_14E FIND V(o3_14) AT=5720.371102p
.measure tran O3_14O FIND V(o3_14) AT=1597.470959p
.measure tran O3_14Q FIND V(o3_14) AT=4059.206053p
.measure tran O3_15B FIND V(o3_15) AT=2001.000000p
.measure tran O3_15E FIND V(o3_15) AT=5720.371102p
.measure tran O3_15O FIND V(o3_15) AT=1597.470959p
.measure tran O3_15Q FIND V(o3_15) AT=4059.206053p
.measure tran O3_16B FIND V(o3_16) AT=2001.000000p
.measure tran O3_16E FIND V(o3_16) AT=5720.371102p
.measure tran O3_16O FIND V(o3_16) AT=1597.470959p
.measure tran O3_16Q FIND V(o3_16) AT=4059.206053p
.measure tran O3_17B FIND V(o3_17) AT=2001.000000p
.measure tran O3_17E FIND V(o3_17) AT=5720.371102p
.measure tran O3_17O FIND V(o3_17) AT=1597.470959p
.measure tran O3_17Q FIND V(o3_17) AT=4059.206053p
.measure tran VR4Z FIND V(rail4) AT=1.500000p
.measure tran VT4Z FIND V(tnk4) AT=1.500000p
.measure tran VR4O1 FIND V(rail4) AT=416.307972p
.measure tran VT4O1 FIND V(tnk4) AT=416.307972p
.measure tran VR4B1 FIND V(rail4) AT=801.000000p
.measure tran VT4B1 FIND V(tnk4) AT=801.000000p
.measure tran VR4R1 FIND V(rail4) AT=2599.000000p
.measure tran VT4R1 FIND V(tnk4) AT=2599.000000p
.measure tran VR4Q1 FIND V(rail4) AT=2888.402596p
.measure tran VT4Q1 FIND V(tnk4) AT=2888.402596p
.measure tran VR4O2 FIND V(rail4) AT=992.526079p
.measure tran VT4O2 FIND V(tnk4) AT=992.526079p
.measure tran VR4B2 FIND V(rail4) AT=1401.000000p
.measure tran VT4B2 FIND V(tnk4) AT=1401.000000p
.measure tran VR4R2 FIND V(rail4) AT=3199.000000p
.measure tran VT4R2 FIND V(tnk4) AT=3199.000000p
.measure tran VR4Q2 FIND V(rail4) AT=3468.143108p
.measure tran VT4Q2 FIND V(tnk4) AT=3468.143108p
.measure tran VR4O3 FIND V(rail4) AT=1597.470959p
.measure tran VT4O3 FIND V(tnk4) AT=1597.470959p
.measure tran VR4B3 FIND V(rail4) AT=2001.000000p
.measure tran VT4B3 FIND V(tnk4) AT=2001.000000p
.measure tran VR4R3 FIND V(rail4) AT=3799.000000p
.measure tran VT4R3 FIND V(tnk4) AT=3799.000000p
.measure tran VR4Q3 FIND V(rail4) AT=4059.206053p
.measure tran VT4Q3 FIND V(tnk4) AT=4059.206053p
.measure tran VR4O4 FIND V(rail4) AT=2157.297620p
.measure tran VT4O4 FIND V(tnk4) AT=2157.297620p
.measure tran VR4B4 FIND V(rail4) AT=2601.000000p
.measure tran VT4B4 FIND V(tnk4) AT=2601.000000p
.measure tran VR4R4 FIND V(rail4) AT=4399.000000p
.measure tran VT4R4 FIND V(tnk4) AT=4399.000000p
.measure tran VR4Q4 FIND V(rail4) AT=4585.296703p
.measure tran VT4Q4 FIND V(tnk4) AT=4585.296703p
.measure tran VR4O5 FIND V(rail4) AT=2783.175540p
.measure tran VT4O5 FIND V(tnk4) AT=2783.175540p
.measure tran VR4B5 FIND V(rail4) AT=3201.000000p
.measure tran VT4B5 FIND V(tnk4) AT=3201.000000p
.measure tran VR4R5 FIND V(rail4) AT=4999.000000p
.measure tran VT4R5 FIND V(tnk4) AT=4999.000000p
.measure tran VR4Q5 FIND V(rail4) AT=5225.371102p
.measure tran VT4Q5 FIND V(tnk4) AT=5225.371102p
.measure tran VR4D FIND V(rail4) AT=5720.371102p
.measure tran VT4D FIND V(tnk4) AT=5720.371102p
.measure tran VR4PK MAX V(rail4) FROM=2000p TO=5724.37p
.measure tran IZ4 FIND I(L4) AT=2157.297620p
.measure tran IZQ4 FIND I(L4) AT=4585.296703p
.measure tran IPK4 MAX I(L4) FROM=2000p TO=5724.37p
.measure tran O4_0B FIND V(o4_0) AT=2601.000000p
.measure tran O4_0E FIND V(o4_0) AT=5720.371102p
.measure tran O4_0O FIND V(o4_0) AT=2157.297620p
.measure tran O4_0Q FIND V(o4_0) AT=4585.296703p
.measure tran O4_1B FIND V(o4_1) AT=2601.000000p
.measure tran O4_1E FIND V(o4_1) AT=5720.371102p
.measure tran O4_1O FIND V(o4_1) AT=2157.297620p
.measure tran O4_1Q FIND V(o4_1) AT=4585.296703p
.measure tran O4_2B FIND V(o4_2) AT=2601.000000p
.measure tran O4_2E FIND V(o4_2) AT=5720.371102p
.measure tran O4_2O FIND V(o4_2) AT=2157.297620p
.measure tran O4_2Q FIND V(o4_2) AT=4585.296703p
.measure tran O4_3B FIND V(o4_3) AT=2601.000000p
.measure tran O4_3E FIND V(o4_3) AT=5720.371102p
.measure tran O4_3O FIND V(o4_3) AT=2157.297620p
.measure tran O4_3Q FIND V(o4_3) AT=4585.296703p
.measure tran O4_4B FIND V(o4_4) AT=2601.000000p
.measure tran O4_4E FIND V(o4_4) AT=5720.371102p
.measure tran O4_4O FIND V(o4_4) AT=2157.297620p
.measure tran O4_4Q FIND V(o4_4) AT=4585.296703p
.measure tran O4_5B FIND V(o4_5) AT=2601.000000p
.measure tran O4_5E FIND V(o4_5) AT=5720.371102p
.measure tran O4_5O FIND V(o4_5) AT=2157.297620p
.measure tran O4_5Q FIND V(o4_5) AT=4585.296703p
.measure tran O4_6B FIND V(o4_6) AT=2601.000000p
.measure tran O4_6E FIND V(o4_6) AT=5720.371102p
.measure tran O4_6O FIND V(o4_6) AT=2157.297620p
.measure tran O4_6Q FIND V(o4_6) AT=4585.296703p
.measure tran O4_7B FIND V(o4_7) AT=2601.000000p
.measure tran O4_7E FIND V(o4_7) AT=5720.371102p
.measure tran O4_7O FIND V(o4_7) AT=2157.297620p
.measure tran O4_7Q FIND V(o4_7) AT=4585.296703p
.measure tran O4_8B FIND V(o4_8) AT=2601.000000p
.measure tran O4_8E FIND V(o4_8) AT=5720.371102p
.measure tran O4_8O FIND V(o4_8) AT=2157.297620p
.measure tran O4_8Q FIND V(o4_8) AT=4585.296703p
.measure tran O4_9B FIND V(o4_9) AT=2601.000000p
.measure tran O4_9E FIND V(o4_9) AT=5720.371102p
.measure tran O4_9O FIND V(o4_9) AT=2157.297620p
.measure tran O4_9Q FIND V(o4_9) AT=4585.296703p
.measure tran O4_10B FIND V(o4_10) AT=2601.000000p
.measure tran O4_10E FIND V(o4_10) AT=5720.371102p
.measure tran O4_10O FIND V(o4_10) AT=2157.297620p
.measure tran O4_10Q FIND V(o4_10) AT=4585.296703p
.measure tran O4_11B FIND V(o4_11) AT=2601.000000p
.measure tran O4_11E FIND V(o4_11) AT=5720.371102p
.measure tran O4_11O FIND V(o4_11) AT=2157.297620p
.measure tran O4_11Q FIND V(o4_11) AT=4585.296703p
.measure tran O4_12B FIND V(o4_12) AT=2601.000000p
.measure tran O4_12E FIND V(o4_12) AT=5720.371102p
.measure tran O4_12O FIND V(o4_12) AT=2157.297620p
.measure tran O4_12Q FIND V(o4_12) AT=4585.296703p
.measure tran O4_13B FIND V(o4_13) AT=2601.000000p
.measure tran O4_13E FIND V(o4_13) AT=5720.371102p
.measure tran O4_13O FIND V(o4_13) AT=2157.297620p
.measure tran O4_13Q FIND V(o4_13) AT=4585.296703p
.measure tran O4_14B FIND V(o4_14) AT=2601.000000p
.measure tran O4_14E FIND V(o4_14) AT=5720.371102p
.measure tran O4_14O FIND V(o4_14) AT=2157.297620p
.measure tran O4_14Q FIND V(o4_14) AT=4585.296703p
.measure tran VR5Z FIND V(rail5) AT=1.500000p
.measure tran VT5Z FIND V(tnk5) AT=1.500000p
.measure tran VR5O1 FIND V(rail5) AT=416.307972p
.measure tran VT5O1 FIND V(tnk5) AT=416.307972p
.measure tran VR5B1 FIND V(rail5) AT=801.000000p
.measure tran VT5B1 FIND V(tnk5) AT=801.000000p
.measure tran VR5R1 FIND V(rail5) AT=2599.000000p
.measure tran VT5R1 FIND V(tnk5) AT=2599.000000p
.measure tran VR5Q1 FIND V(rail5) AT=2888.402596p
.measure tran VT5Q1 FIND V(tnk5) AT=2888.402596p
.measure tran VR5O2 FIND V(rail5) AT=992.526079p
.measure tran VT5O2 FIND V(tnk5) AT=992.526079p
.measure tran VR5B2 FIND V(rail5) AT=1401.000000p
.measure tran VT5B2 FIND V(tnk5) AT=1401.000000p
.measure tran VR5R2 FIND V(rail5) AT=3199.000000p
.measure tran VT5R2 FIND V(tnk5) AT=3199.000000p
.measure tran VR5Q2 FIND V(rail5) AT=3468.143108p
.measure tran VT5Q2 FIND V(tnk5) AT=3468.143108p
.measure tran VR5O3 FIND V(rail5) AT=1597.470959p
.measure tran VT5O3 FIND V(tnk5) AT=1597.470959p
.measure tran VR5B3 FIND V(rail5) AT=2001.000000p
.measure tran VT5B3 FIND V(tnk5) AT=2001.000000p
.measure tran VR5R3 FIND V(rail5) AT=3799.000000p
.measure tran VT5R3 FIND V(tnk5) AT=3799.000000p
.measure tran VR5Q3 FIND V(rail5) AT=4059.206053p
.measure tran VT5Q3 FIND V(tnk5) AT=4059.206053p
.measure tran VR5O4 FIND V(rail5) AT=2157.297620p
.measure tran VT5O4 FIND V(tnk5) AT=2157.297620p
.measure tran VR5B4 FIND V(rail5) AT=2601.000000p
.measure tran VT5B4 FIND V(tnk5) AT=2601.000000p
.measure tran VR5R4 FIND V(rail5) AT=4399.000000p
.measure tran VT5R4 FIND V(tnk5) AT=4399.000000p
.measure tran VR5Q4 FIND V(rail5) AT=4585.296703p
.measure tran VT5Q4 FIND V(tnk5) AT=4585.296703p
.measure tran VR5O5 FIND V(rail5) AT=2783.175540p
.measure tran VT5O5 FIND V(tnk5) AT=2783.175540p
.measure tran VR5B5 FIND V(rail5) AT=3201.000000p
.measure tran VT5B5 FIND V(tnk5) AT=3201.000000p
.measure tran VR5R5 FIND V(rail5) AT=4999.000000p
.measure tran VT5R5 FIND V(tnk5) AT=4999.000000p
.measure tran VR5Q5 FIND V(rail5) AT=5225.371102p
.measure tran VT5Q5 FIND V(tnk5) AT=5225.371102p
.measure tran VR5D FIND V(rail5) AT=5720.371102p
.measure tran VT5D FIND V(tnk5) AT=5720.371102p
.measure tran VR5PK MAX V(rail5) FROM=2600p TO=5724.37p
.measure tran IZ5 FIND I(L5) AT=2783.175540p
.measure tran IZQ5 FIND I(L5) AT=5225.371102p
.measure tran IPK5 MAX I(L5) FROM=2600p TO=5724.37p
.measure tran O5_0B FIND V(o5_0) AT=3201.000000p
.measure tran O5_0E FIND V(o5_0) AT=5720.371102p
.measure tran O5_0O FIND V(o5_0) AT=2783.175540p
.measure tran O5_0Q FIND V(o5_0) AT=5225.371102p
.measure tran O5_1B FIND V(o5_1) AT=3201.000000p
.measure tran O5_1E FIND V(o5_1) AT=5720.371102p
.measure tran O5_1O FIND V(o5_1) AT=2783.175540p
.measure tran O5_1Q FIND V(o5_1) AT=5225.371102p
.measure tran O5_2B FIND V(o5_2) AT=3201.000000p
.measure tran O5_2E FIND V(o5_2) AT=5720.371102p
.measure tran O5_2O FIND V(o5_2) AT=2783.175540p
.measure tran O5_2Q FIND V(o5_2) AT=5225.371102p
.measure tran O5_3B FIND V(o5_3) AT=3201.000000p
.measure tran O5_3E FIND V(o5_3) AT=5720.371102p
.measure tran O5_3O FIND V(o5_3) AT=2783.175540p
.measure tran O5_3Q FIND V(o5_3) AT=5225.371102p
.measure tran O5_4B FIND V(o5_4) AT=3201.000000p
.measure tran O5_4E FIND V(o5_4) AT=5720.371102p
.measure tran O5_4O FIND V(o5_4) AT=2783.175540p
.measure tran O5_4Q FIND V(o5_4) AT=5225.371102p
.measure tran O5_5B FIND V(o5_5) AT=3201.000000p
.measure tran O5_5E FIND V(o5_5) AT=5720.371102p
.measure tran O5_5O FIND V(o5_5) AT=2783.175540p
.measure tran O5_5Q FIND V(o5_5) AT=5225.371102p
.measure tran O5_6B FIND V(o5_6) AT=3201.000000p
.measure tran O5_6E FIND V(o5_6) AT=5720.371102p
.measure tran O5_6O FIND V(o5_6) AT=2783.175540p
.measure tran O5_6Q FIND V(o5_6) AT=5225.371102p
.measure tran O5_7B FIND V(o5_7) AT=3201.000000p
.measure tran O5_7E FIND V(o5_7) AT=5720.371102p
.measure tran O5_7O FIND V(o5_7) AT=2783.175540p
.measure tran O5_7Q FIND V(o5_7) AT=5225.371102p
.print tran V(rail1) V(rail2) V(rail3) V(rail4) V(rail5) V(tnk1) V(tnk2) V(tnk3) V(tnk4) V(tnk5) I(L1) I(L2) I(L3) I(L4) I(L5) V(sw1) V(sw2) V(sw3) V(sw4) V(sw5) V(o1_0) V(o1_1) V(o1_2) V(o1_3) V(o1_4) V(o1_5) V(o1_6) V(o1_7) V(o1_8) V(o1_9) V(o1_10) V(o1_11) V(o1_12) V(o1_13) V(o1_14) V(o2_0) V(o2_1) V(o2_2) V(o2_3) V(o2_4) V(o2_5) V(o2_6) V(o2_7) V(o2_8) V(o2_9) V(o2_10) V(o2_11) V(o2_12) V(o2_13) V(o2_14) V(o2_15) V(o2_16) V(o2_17) V(o2_18) V(o2_19) V(o3_0) V(o3_1) V(o3_2) V(o3_3) V(o3_4) V(o3_5) V(o3_6) V(o3_7) V(o3_8) V(o3_9) V(o3_10) V(o3_11) V(o3_12) V(o3_13) V(o3_14) V(o3_15) V(o3_16) V(o3_17) V(o4_0) V(o4_1) V(o4_2) V(o4_3) V(o4_4) V(o4_5) V(o4_6) V(o4_7) V(o4_8) V(o4_9) V(o4_10) V(o4_11) V(o4_12) V(o4_13) V(o4_14) V(o5_0) V(o5_1) V(o5_2) V(o5_3) V(o5_4) V(o5_5) V(o5_6) V(o5_7)
.end
