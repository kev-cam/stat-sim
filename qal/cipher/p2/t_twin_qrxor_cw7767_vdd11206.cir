.hdl "/usr/local/share/xyce/verilog-a/psp103/psp103.va"
.include "/usr/local/src/kestrel/sim/models/sg13g2_psp103_tt.lib"
.include "/usr/local/src/stat-sim/qal/sg13lv_compat.sp"
.OPTIONS TIMEINT METHOD=GEAR RELTOL=1e-6 ABSTOL=1e-15 CHGTOL=1e-17
.include "/usr/local/src/IHP-Open-PDK/ihp-sg13g2/libs.ref/sg13g2_stdcell/spice/sg13g2_stdcell.spice"
VDD vdd 0 1.12061
VGNDM gnm 0 0
VS_a0 s_a0 0 PWL(0 1.65 200p 1.65 202p 0 1700p 0 1702p 1.65)
VS_a1 s_a1 0 PWL(0 1.65 200p 1.65 202p 0 1700p 0 1702p 1.65)
VS_a10 s_a10 0 PWL(0 0 200p 0 202p 1.65 1700p 1.65 1702p 0)
VS_a11 s_a11 0 PWL(0 1.65 200p 1.65 202p 0 1700p 0 1702p 1.65)
VS_a12 s_a12 0 PWL(0 0 200p 0 202p 1.65 1700p 1.65 1702p 0)
VS_a13 s_a13 0 PWL(0 0 200p 0 202p 1.65 1700p 1.65 1702p 0)
VS_a14 s_a14 0 PWL(0 0 200p 0 202p 1.65 1700p 1.65 1702p 0)
VS_a15 s_a15 0 PWL(0 0 200p 0 202p 1.65 1700p 1.65 1702p 0)
VS_a16 s_a16 0 PWL(0 1.65 200p 1.65 202p 0 1700p 0 1702p 1.65)
VS_a17 s_a17 0 PWL(0 1.65 200p 1.65 202p 0 1700p 0 1702p 1.65)
VS_a18 s_a18 0 PWL(0 0 200p 0 202p 1.65 1700p 1.65 1702p 0)
VS_a19 s_a19 0 PWL(0 0 200p 0 202p 1.65 1700p 1.65 1702p 0)
VS_a2 s_a2 0 PWL(0 0 200p 0 202p 1.65 1700p 1.65 1702p 0)
VS_a20 s_a20 0 PWL(0 0 200p 0 202p 1.65 1700p 1.65 1702p 0)
VS_a21 s_a21 0 PWL(0 1.65 200p 1.65 202p 0 1700p 0 1702p 1.65)
VS_a22 s_a22 0 PWL(0 0 200p 0 202p 1.65 1700p 1.65 1702p 0)
VS_a23 s_a23 0 PWL(0 1.65 200p 1.65 202p 0 1700p 0 1702p 1.65)
VS_a24 s_a24 0 PWL(0 1.65 200p 1.65 202p 0 1700p 0 1702p 1.65)
VS_a25 s_a25 0 PWL(0 0 200p 0 202p 1.65 1700p 1.65 1702p 0)
VS_a26 s_a26 0 PWL(0 1.65 200p 1.65 202p 0 1700p 0 1702p 1.65)
VS_a27 s_a27 0 PWL(0 0 200p 0 202p 1.65 1700p 1.65 1702p 0)
VS_a28 s_a28 0 PWL(0 0 200p 0 202p 1.65 1700p 1.65 1702p 0)
VS_a29 s_a29 0 PWL(0 0 200p 0 202p 1.65 1700p 1.65 1702p 0)
VS_a3 s_a3 0 PWL(0 0 200p 0 202p 1.65 1700p 1.65 1702p 0)
VS_a30 s_a30 0 PWL(0 0 200p 0 202p 1.65 1700p 1.65 1702p 0)
VS_a31 s_a31 0 PWL(0 1.65 200p 1.65 202p 0 1700p 0 1702p 1.65)
VS_a4 s_a4 0 PWL(0 1.65 200p 1.65 202p 0 1700p 0 1702p 1.65)
VS_a5 s_a5 0 PWL(0 0 200p 0 202p 1.65 1700p 1.65 1702p 0)
VS_a6 s_a6 0 PWL(0 1.65 200p 1.65 202p 0 1700p 0 1702p 1.65)
VS_a7 s_a7 0 PWL(0 1.65 200p 1.65 202p 0 1700p 0 1702p 1.65)
VS_a8 s_a8 0 PWL(0 0 200p 0 202p 1.65 1700p 1.65 1702p 0)
VS_a9 s_a9 0 PWL(0 0 200p 0 202p 1.65 1700p 1.65 1702p 0)
VS_d0 s_d0 0 1.65
VS_d1 s_d1 0 1.65
VS_d10 s_d10 0 1.65
VS_d11 s_d11 0 0
VS_d12 s_d12 0 1.65
VS_d13 s_d13 0 0
VS_d14 s_d14 0 0
VS_d15 s_d15 0 1.65
VS_d16 s_d16 0 0
VS_d17 s_d17 0 0
VS_d18 s_d18 0 0
VS_d19 s_d19 0 0
VS_d2 s_d2 0 1.65
VS_d20 s_d20 0 0
VS_d21 s_d21 0 0
VS_d22 s_d22 0 1.65
VS_d23 s_d23 0 1.65
VS_d24 s_d24 0 1.65
VS_d25 s_d25 0 1.65
VS_d26 s_d26 0 0
VS_d27 s_d27 0 1.65
VS_d28 s_d28 0 1.65
VS_d29 s_d29 0 0
VS_d3 s_d3 0 0
VS_d30 s_d30 0 1.65
VS_d31 s_d31 0 1.65
VS_d4 s_d4 0 1.65
VS_d5 s_d5 0 1.65
VS_d6 s_d6 0 1.65
VS_d7 s_d7 0 0
VS_d8 s_d8 0 1.65
VS_d9 s_d9 0 0
XINV0 n0 s_d0 vdd gnm sg13g2_inv_1
CL0 n0 gnm 2f
XINV1 n1 s_d1 vdd gnm sg13g2_inv_1
CL1 n1 gnm 2f
XINV2 n2 s_d2 vdd gnm sg13g2_inv_1
CL2 n2 gnm 2f
XINV3 n3 s_d3 vdd gnm sg13g2_inv_1
CL3 n3 gnm 2f
XINV4 n4 s_d4 vdd gnm sg13g2_inv_1
CL4 n4 gnm 2f
XINV5 n5 s_d5 vdd gnm sg13g2_inv_1
CL5 n5 gnm 2f
XINV6 n6 s_d6 vdd gnm sg13g2_inv_1
CL6 n6 gnm 2f
XINV7 n7 s_d7 vdd gnm sg13g2_inv_1
CL7 n7 gnm 2f
XINV8 n8 s_d8 vdd gnm sg13g2_inv_1
CL8 n8 gnm 2f
XINV9 n9 s_d9 vdd gnm sg13g2_inv_1
CL9 n9 gnm 2f
XINV10 n10 s_d10 vdd gnm sg13g2_inv_1
CL10 n10 gnm 2f
XINV11 n11 s_d11 vdd gnm sg13g2_inv_1
CL11 n11 gnm 2f
XINV12 n12 s_d12 vdd gnm sg13g2_inv_1
CL12 n12 gnm 2f
XINV13 n13 s_d13 vdd gnm sg13g2_inv_1
CL13 n13 gnm 2f
XINV14 n14 s_d14 vdd gnm sg13g2_inv_1
CL14 n14 gnm 2f
XINV15 n15 s_d15 vdd gnm sg13g2_inv_1
CL15 n15 gnm 2f
XINV16 n16 s_d16 vdd gnm sg13g2_inv_1
CL16 n16 gnm 2f
XINV17 n17 s_d17 vdd gnm sg13g2_inv_1
CL17 n17 gnm 2f
XINV18 n18 s_d18 vdd gnm sg13g2_inv_1
CL18 n18 gnm 2f
XINV19 n19 s_d19 vdd gnm sg13g2_inv_1
CL19 n19 gnm 2f
XINV20 n20 s_d20 vdd gnm sg13g2_inv_1
CL20 n20 gnm 2f
XINV21 n21 s_d21 vdd gnm sg13g2_inv_1
CL21 n21 gnm 2f
XINV22 n22 s_d22 vdd gnm sg13g2_inv_1
CL22 n22 gnm 2f
XINV23 n23 s_d23 vdd gnm sg13g2_inv_1
CL23 n23 gnm 2f
XINV24 n24 s_d24 vdd gnm sg13g2_inv_1
CL24 n24 gnm 2f
XINV25 n25 s_d25 vdd gnm sg13g2_inv_1
CL25 n25 gnm 2f
XINV26 n26 s_d26 vdd gnm sg13g2_inv_1
CL26 n26 gnm 2f
XINV27 n27 s_d27 vdd gnm sg13g2_inv_1
CL27 n27 gnm 2f
XINV28 n28 s_d28 vdd gnm sg13g2_inv_1
CL28 n28 gnm 2f
XINV29 n29 s_d29 vdd gnm sg13g2_inv_1
CL29 n29 gnm 2f
XINV30 n30 s_d30 vdd gnm sg13g2_inv_1
CL30 n30 gnm 2f
XINV31 n31 s_d31 vdd gnm sg13g2_inv_1
CL31 n31 gnm 2f
XXOR232 n32 n0 s_a0 vdd gnm sg13g2_xor2_1
CL32 n32 gnm 2f
CW32 n32 gnm 7.767000f
XXOR233 n33 n1 s_a1 vdd gnm sg13g2_xor2_1
CL33 n33 gnm 2f
CW33 n33 gnm 7.767000f
XXOR234 n34 n2 s_a2 vdd gnm sg13g2_xor2_1
CL34 n34 gnm 2f
CW34 n34 gnm 7.767000f
XXOR235 n35 n3 s_a3 vdd gnm sg13g2_xor2_1
CL35 n35 gnm 2f
CW35 n35 gnm 7.767000f
XXOR236 n36 n4 s_a4 vdd gnm sg13g2_xor2_1
CL36 n36 gnm 2f
CW36 n36 gnm 7.767000f
XXOR237 n37 n5 s_a5 vdd gnm sg13g2_xor2_1
CL37 n37 gnm 2f
CW37 n37 gnm 7.767000f
XXOR238 n38 n6 s_a6 vdd gnm sg13g2_xor2_1
CL38 n38 gnm 2f
CW38 n38 gnm 7.767000f
XXOR239 n39 n7 s_a7 vdd gnm sg13g2_xor2_1
CL39 n39 gnm 2f
CW39 n39 gnm 7.767000f
XXOR240 n40 n8 s_a8 vdd gnm sg13g2_xor2_1
CL40 n40 gnm 2f
CW40 n40 gnm 7.767000f
XXOR241 n41 n9 s_a9 vdd gnm sg13g2_xor2_1
CL41 n41 gnm 2f
CW41 n41 gnm 7.767000f
XXOR242 n42 n10 s_a10 vdd gnm sg13g2_xor2_1
CL42 n42 gnm 2f
CW42 n42 gnm 7.767000f
XXOR243 n43 n11 s_a11 vdd gnm sg13g2_xor2_1
CL43 n43 gnm 2f
CW43 n43 gnm 7.767000f
XXOR244 n44 n12 s_a12 vdd gnm sg13g2_xor2_1
CL44 n44 gnm 2f
CW44 n44 gnm 7.767000f
XXOR245 n45 n13 s_a13 vdd gnm sg13g2_xor2_1
CL45 n45 gnm 2f
CW45 n45 gnm 7.767000f
XXOR246 n46 n14 s_a14 vdd gnm sg13g2_xor2_1
CL46 n46 gnm 2f
CW46 n46 gnm 7.767000f
XXOR247 n47 n15 s_a15 vdd gnm sg13g2_xor2_1
CL47 n47 gnm 2f
CW47 n47 gnm 7.767000f
XXOR248 n48 n16 s_a16 vdd gnm sg13g2_xor2_1
CL48 n48 gnm 2f
CW48 n48 gnm 7.767000f
XXOR249 n49 n17 s_a17 vdd gnm sg13g2_xor2_1
CL49 n49 gnm 2f
CW49 n49 gnm 7.767000f
XXOR250 n50 n18 s_a18 vdd gnm sg13g2_xor2_1
CL50 n50 gnm 2f
CW50 n50 gnm 7.767000f
XXOR251 n51 n19 s_a19 vdd gnm sg13g2_xor2_1
CL51 n51 gnm 2f
CW51 n51 gnm 7.767000f
XXOR252 n52 n20 s_a20 vdd gnm sg13g2_xor2_1
CL52 n52 gnm 2f
CW52 n52 gnm 7.767000f
XXOR253 n53 n21 s_a21 vdd gnm sg13g2_xor2_1
CL53 n53 gnm 2f
CW53 n53 gnm 7.767000f
XXOR254 n54 n22 s_a22 vdd gnm sg13g2_xor2_1
CL54 n54 gnm 2f
CW54 n54 gnm 7.767000f
XXOR255 n55 n23 s_a23 vdd gnm sg13g2_xor2_1
CL55 n55 gnm 2f
CW55 n55 gnm 7.767000f
XXOR256 n56 n24 s_a24 vdd gnm sg13g2_xor2_1
CL56 n56 gnm 2f
CW56 n56 gnm 7.767000f
XXOR257 n57 n25 s_a25 vdd gnm sg13g2_xor2_1
CL57 n57 gnm 2f
CW57 n57 gnm 7.767000f
XXOR258 n58 n26 s_a26 vdd gnm sg13g2_xor2_1
CL58 n58 gnm 2f
CW58 n58 gnm 7.767000f
XXOR259 n59 n27 s_a27 vdd gnm sg13g2_xor2_1
CL59 n59 gnm 2f
CW59 n59 gnm 7.767000f
XXOR260 n60 n28 s_a28 vdd gnm sg13g2_xor2_1
CL60 n60 gnm 2f
CW60 n60 gnm 7.767000f
XXOR261 n61 n29 s_a29 vdd gnm sg13g2_xor2_1
CL61 n61 gnm 2f
CW61 n61 gnm 7.767000f
XXOR262 n62 n30 s_a30 vdd gnm sg13g2_xor2_1
CL62 n62 gnm 2f
CW62 n62 gnm 7.767000f
XXOR263 n63 n31 s_a31 vdd gnm sg13g2_xor2_1
CL63 n63 gnm 2f
CW63 n63 gnm 7.767000f
XINV64 n64 n48 vdd gnm sg13g2_inv_1
CL64 n64 gnm 2f
XINV65 n65 n49 vdd gnm sg13g2_inv_1
CL65 n65 gnm 2f
XINV66 n66 n50 vdd gnm sg13g2_inv_1
CL66 n66 gnm 2f
XINV67 n67 n51 vdd gnm sg13g2_inv_1
CL67 n67 gnm 2f
XINV68 n68 n52 vdd gnm sg13g2_inv_1
CL68 n68 gnm 2f
XINV69 n69 n53 vdd gnm sg13g2_inv_1
CL69 n69 gnm 2f
XINV70 n70 n54 vdd gnm sg13g2_inv_1
CL70 n70 gnm 2f
XINV71 n71 n55 vdd gnm sg13g2_inv_1
CL71 n71 gnm 2f
XINV72 n72 n56 vdd gnm sg13g2_inv_1
CL72 n72 gnm 2f
XINV73 n73 n57 vdd gnm sg13g2_inv_1
CL73 n73 gnm 2f
XINV74 n74 n58 vdd gnm sg13g2_inv_1
CL74 n74 gnm 2f
XINV75 n75 n59 vdd gnm sg13g2_inv_1
CL75 n75 gnm 2f
XINV76 n76 n60 vdd gnm sg13g2_inv_1
CL76 n76 gnm 2f
XINV77 n77 n61 vdd gnm sg13g2_inv_1
CL77 n77 gnm 2f
XINV78 n78 n62 vdd gnm sg13g2_inv_1
CL78 n78 gnm 2f
XINV79 n79 n63 vdd gnm sg13g2_inv_1
CL79 n79 gnm 2f
XINV80 n80 n32 vdd gnm sg13g2_inv_1
CL80 n80 gnm 2f
XINV81 n81 n33 vdd gnm sg13g2_inv_1
CL81 n81 gnm 2f
XINV82 n82 n34 vdd gnm sg13g2_inv_1
CL82 n82 gnm 2f
XINV83 n83 n35 vdd gnm sg13g2_inv_1
CL83 n83 gnm 2f
XINV84 n84 n36 vdd gnm sg13g2_inv_1
CL84 n84 gnm 2f
XINV85 n85 n37 vdd gnm sg13g2_inv_1
CL85 n85 gnm 2f
XINV86 n86 n38 vdd gnm sg13g2_inv_1
CL86 n86 gnm 2f
XINV87 n87 n39 vdd gnm sg13g2_inv_1
CL87 n87 gnm 2f
XINV88 n88 n40 vdd gnm sg13g2_inv_1
CL88 n88 gnm 2f
XINV89 n89 n41 vdd gnm sg13g2_inv_1
CL89 n89 gnm 2f
XINV90 n90 n42 vdd gnm sg13g2_inv_1
CL90 n90 gnm 2f
XINV91 n91 n43 vdd gnm sg13g2_inv_1
CL91 n91 gnm 2f
XINV92 n92 n44 vdd gnm sg13g2_inv_1
CL92 n92 gnm 2f
XINV93 n93 n45 vdd gnm sg13g2_inv_1
CL93 n93 gnm 2f
XINV94 n94 n46 vdd gnm sg13g2_inv_1
CL94 n94 gnm 2f
XINV95 n95 n47 vdd gnm sg13g2_inv_1
CL95 n95 gnm 2f
CXqvdd xqvdd 0 1
BXqvdd 0 xqvdd I={ -I(VDD) }
RXqvdd xqvdd 0 0.01
.tran 0.1p 2202p 0 0.25p
.measure tran QVDD_Z FIND V(xqvdd) AT=1.500000p
.measure tran QVDD_A FIND V(xqvdd) AT=201.000000p
.measure tran QVDD_B FIND V(xqvdd) AT=1701.000000p
.measure tran QVDD_D FIND V(xqvdd) AT=2198.000000p
.measure tran M_n64 FIND V(n64) AT=2198.000000p
.measure tran C_n64 FIND V(n64) AT=1696.000000p
.measure tran M_n65 FIND V(n65) AT=2198.000000p
.measure tran C_n65 FIND V(n65) AT=1696.000000p
.measure tran M_n66 FIND V(n66) AT=2198.000000p
.measure tran C_n66 FIND V(n66) AT=1696.000000p
.measure tran M_n67 FIND V(n67) AT=2198.000000p
.measure tran C_n67 FIND V(n67) AT=1696.000000p
.measure tran M_n68 FIND V(n68) AT=2198.000000p
.measure tran C_n68 FIND V(n68) AT=1696.000000p
.measure tran M_n69 FIND V(n69) AT=2198.000000p
.measure tran C_n69 FIND V(n69) AT=1696.000000p
.measure tran M_n70 FIND V(n70) AT=2198.000000p
.measure tran C_n70 FIND V(n70) AT=1696.000000p
.measure tran M_n71 FIND V(n71) AT=2198.000000p
.measure tran C_n71 FIND V(n71) AT=1696.000000p
.measure tran M_n72 FIND V(n72) AT=2198.000000p
.measure tran C_n72 FIND V(n72) AT=1696.000000p
.measure tran M_n73 FIND V(n73) AT=2198.000000p
.measure tran C_n73 FIND V(n73) AT=1696.000000p
.measure tran M_n74 FIND V(n74) AT=2198.000000p
.measure tran C_n74 FIND V(n74) AT=1696.000000p
.measure tran M_n75 FIND V(n75) AT=2198.000000p
.measure tran C_n75 FIND V(n75) AT=1696.000000p
.measure tran M_n76 FIND V(n76) AT=2198.000000p
.measure tran C_n76 FIND V(n76) AT=1696.000000p
.measure tran M_n77 FIND V(n77) AT=2198.000000p
.measure tran C_n77 FIND V(n77) AT=1696.000000p
.measure tran M_n78 FIND V(n78) AT=2198.000000p
.measure tran C_n78 FIND V(n78) AT=1696.000000p
.measure tran M_n79 FIND V(n79) AT=2198.000000p
.measure tran C_n79 FIND V(n79) AT=1696.000000p
.measure tran M_n80 FIND V(n80) AT=2198.000000p
.measure tran C_n80 FIND V(n80) AT=1696.000000p
.measure tran M_n81 FIND V(n81) AT=2198.000000p
.measure tran C_n81 FIND V(n81) AT=1696.000000p
.measure tran M_n82 FIND V(n82) AT=2198.000000p
.measure tran C_n82 FIND V(n82) AT=1696.000000p
.measure tran M_n83 FIND V(n83) AT=2198.000000p
.measure tran C_n83 FIND V(n83) AT=1696.000000p
.measure tran M_n84 FIND V(n84) AT=2198.000000p
.measure tran C_n84 FIND V(n84) AT=1696.000000p
.measure tran M_n85 FIND V(n85) AT=2198.000000p
.measure tran C_n85 FIND V(n85) AT=1696.000000p
.measure tran M_n86 FIND V(n86) AT=2198.000000p
.measure tran C_n86 FIND V(n86) AT=1696.000000p
.measure tran M_n87 FIND V(n87) AT=2198.000000p
.measure tran C_n87 FIND V(n87) AT=1696.000000p
.measure tran M_n88 FIND V(n88) AT=2198.000000p
.measure tran C_n88 FIND V(n88) AT=1696.000000p
.measure tran M_n89 FIND V(n89) AT=2198.000000p
.measure tran C_n89 FIND V(n89) AT=1696.000000p
.measure tran M_n90 FIND V(n90) AT=2198.000000p
.measure tran C_n90 FIND V(n90) AT=1696.000000p
.measure tran M_n91 FIND V(n91) AT=2198.000000p
.measure tran C_n91 FIND V(n91) AT=1696.000000p
.measure tran M_n92 FIND V(n92) AT=2198.000000p
.measure tran C_n92 FIND V(n92) AT=1696.000000p
.measure tran M_n93 FIND V(n93) AT=2198.000000p
.measure tran C_n93 FIND V(n93) AT=1696.000000p
.measure tran M_n94 FIND V(n94) AT=2198.000000p
.measure tran C_n94 FIND V(n94) AT=1696.000000p
.measure tran M_n95 FIND V(n95) AT=2198.000000p
.measure tran C_n95 FIND V(n95) AT=1696.000000p
.print tran V(vdd) I(VDD) V(xqvdd) V(n64) V(n65) V(n66) V(n67) V(n68) V(n69) V(n70) V(n71) V(n72) V(n73) V(n74) V(n75) V(n76) V(n77) V(n78) V(n79) V(n80) V(n81) V(n82) V(n83) V(n84) V(n85) V(n86) V(n87) V(n88) V(n89) V(n90) V(n91) V(n92) V(n93) V(n94) V(n95)
.end
