.hdl "/usr/local/share/xyce/verilog-a/psp103/psp103.va"
.include "/usr/local/src/kestrel/sim/models/sg13g2_psp103_tt.lib"
.include "/usr/local/src/stat-sim/qal/sg13lv_compat.sp"
.OPTIONS TIMEINT METHOD=GEAR RELTOL=1e-6 ABSTOL=1e-15 CHGTOL=1e-17
.include "/usr/local/src/IHP-Open-PDK/ihp-sg13g2/libs.ref/sg13g2_stdcell/spice/sg13g2_stdcell.spice"
VDD vdd 0 0.944636
VGNDM gnm 0 0
VS_rk0 s_rk0 0 PWL(0 0 200p 0 202p 1.65 1700p 1.65 1702p 0)
VS_rk1 s_rk1 0 PWL(0 1.65 200p 1.65 202p 0 1700p 0 1702p 1.65)
VS_rk10 s_rk10 0 PWL(0 0 200p 0 202p 1.65 1700p 1.65 1702p 0)
VS_rk100 s_rk100 0 PWL(0 1.65 200p 1.65 202p 0 1700p 0 1702p 1.65)
VS_rk101 s_rk101 0 PWL(0 0 200p 0 202p 1.65 1700p 1.65 1702p 0)
VS_rk102 s_rk102 0 PWL(0 1.65 200p 1.65 202p 0 1700p 0 1702p 1.65)
VS_rk103 s_rk103 0 PWL(0 0 200p 0 202p 1.65 1700p 1.65 1702p 0)
VS_rk104 s_rk104 0 PWL(0 1.65 200p 1.65 202p 0 1700p 0 1702p 1.65)
VS_rk105 s_rk105 0 PWL(0 1.65 200p 1.65 202p 0 1700p 0 1702p 1.65)
VS_rk106 s_rk106 0 PWL(0 1.65 200p 1.65 202p 0 1700p 0 1702p 1.65)
VS_rk107 s_rk107 0 PWL(0 0 200p 0 202p 1.65 1700p 1.65 1702p 0)
VS_rk108 s_rk108 0 PWL(0 1.65 200p 1.65 202p 0 1700p 0 1702p 1.65)
VS_rk109 s_rk109 0 PWL(0 1.65 200p 1.65 202p 0 1700p 0 1702p 1.65)
VS_rk11 s_rk11 0 PWL(0 0 200p 0 202p 1.65 1700p 1.65 1702p 0)
VS_rk110 s_rk110 0 PWL(0 1.65 200p 1.65 202p 0 1700p 0 1702p 1.65)
VS_rk111 s_rk111 0 PWL(0 0 200p 0 202p 1.65 1700p 1.65 1702p 0)
VS_rk112 s_rk112 0 PWL(0 0 200p 0 202p 1.65 1700p 1.65 1702p 0)
VS_rk113 s_rk113 0 PWL(0 0 200p 0 202p 1.65 1700p 1.65 1702p 0)
VS_rk114 s_rk114 0 PWL(0 0 200p 0 202p 1.65 1700p 1.65 1702p 0)
VS_rk115 s_rk115 0 PWL(0 1.65 200p 1.65 202p 0 1700p 0 1702p 1.65)
VS_rk116 s_rk116 0 PWL(0 1.65 200p 1.65 202p 0 1700p 0 1702p 1.65)
VS_rk117 s_rk117 0 PWL(0 0 200p 0 202p 1.65 1700p 1.65 1702p 0)
VS_rk118 s_rk118 0 PWL(0 0 200p 0 202p 1.65 1700p 1.65 1702p 0)
VS_rk119 s_rk119 0 PWL(0 1.65 200p 1.65 202p 0 1700p 0 1702p 1.65)
VS_rk12 s_rk12 0 PWL(0 1.65 200p 1.65 202p 0 1700p 0 1702p 1.65)
VS_rk120 s_rk120 0 PWL(0 1.65 200p 1.65 202p 0 1700p 0 1702p 1.65)
VS_rk121 s_rk121 0 PWL(0 0 200p 0 202p 1.65 1700p 1.65 1702p 0)
VS_rk122 s_rk122 0 PWL(0 1.65 200p 1.65 202p 0 1700p 0 1702p 1.65)
VS_rk123 s_rk123 0 PWL(0 1.65 200p 1.65 202p 0 1700p 0 1702p 1.65)
VS_rk124 s_rk124 0 PWL(0 1.65 200p 1.65 202p 0 1700p 0 1702p 1.65)
VS_rk125 s_rk125 0 PWL(0 1.65 200p 1.65 202p 0 1700p 0 1702p 1.65)
VS_rk126 s_rk126 0 PWL(0 0 200p 0 202p 1.65 1700p 1.65 1702p 0)
VS_rk127 s_rk127 0 PWL(0 1.65 200p 1.65 202p 0 1700p 0 1702p 1.65)
VS_rk13 s_rk13 0 PWL(0 0 200p 0 202p 1.65 1700p 1.65 1702p 0)
VS_rk14 s_rk14 0 PWL(0 0 200p 0 202p 1.65 1700p 1.65 1702p 0)
VS_rk15 s_rk15 0 PWL(0 0 200p 0 202p 1.65 1700p 1.65 1702p 0)
VS_rk16 s_rk16 0 PWL(0 0 200p 0 202p 1.65 1700p 1.65 1702p 0)
VS_rk17 s_rk17 0 PWL(0 0 200p 0 202p 1.65 1700p 1.65 1702p 0)
VS_rk18 s_rk18 0 PWL(0 1.65 200p 1.65 202p 0 1700p 0 1702p 1.65)
VS_rk19 s_rk19 0 PWL(0 0 200p 0 202p 1.65 1700p 1.65 1702p 0)
VS_rk2 s_rk2 0 PWL(0 1.65 200p 1.65 202p 0 1700p 0 1702p 1.65)
VS_rk20 s_rk20 0 PWL(0 1.65 200p 1.65 202p 0 1700p 0 1702p 1.65)
VS_rk21 s_rk21 0 PWL(0 1.65 200p 1.65 202p 0 1700p 0 1702p 1.65)
VS_rk22 s_rk22 0 PWL(0 0 200p 0 202p 1.65 1700p 1.65 1702p 0)
VS_rk23 s_rk23 0 PWL(0 0 200p 0 202p 1.65 1700p 1.65 1702p 0)
VS_rk24 s_rk24 0 PWL(0 1.65 200p 1.65 202p 0 1700p 0 1702p 1.65)
VS_rk25 s_rk25 0 PWL(0 0 200p 0 202p 1.65 1700p 1.65 1702p 0)
VS_rk26 s_rk26 0 PWL(0 0 200p 0 202p 1.65 1700p 1.65 1702p 0)
VS_rk27 s_rk27 0 PWL(0 1.65 200p 1.65 202p 0 1700p 0 1702p 1.65)
VS_rk28 s_rk28 0 PWL(0 1.65 200p 1.65 202p 0 1700p 0 1702p 1.65)
VS_rk29 s_rk29 0 PWL(0 0 200p 0 202p 1.65 1700p 1.65 1702p 0)
VS_rk3 s_rk3 0 PWL(0 1.65 200p 1.65 202p 0 1700p 0 1702p 1.65)
VS_rk30 s_rk30 0 PWL(0 1.65 200p 1.65 202p 0 1700p 0 1702p 1.65)
VS_rk31 s_rk31 0 PWL(0 0 200p 0 202p 1.65 1700p 1.65 1702p 0)
VS_rk32 s_rk32 0 PWL(0 0 200p 0 202p 1.65 1700p 1.65 1702p 0)
VS_rk33 s_rk33 0 PWL(0 1.65 200p 1.65 202p 0 1700p 0 1702p 1.65)
VS_rk34 s_rk34 0 PWL(0 0 200p 0 202p 1.65 1700p 1.65 1702p 0)
VS_rk35 s_rk35 0 PWL(0 1.65 200p 1.65 202p 0 1700p 0 1702p 1.65)
VS_rk36 s_rk36 0 PWL(0 1.65 200p 1.65 202p 0 1700p 0 1702p 1.65)
VS_rk37 s_rk37 0 PWL(0 1.65 200p 1.65 202p 0 1700p 0 1702p 1.65)
VS_rk38 s_rk38 0 PWL(0 1.65 200p 1.65 202p 0 1700p 0 1702p 1.65)
VS_rk39 s_rk39 0 PWL(0 0 200p 0 202p 1.65 1700p 1.65 1702p 0)
VS_rk4 s_rk4 0 PWL(0 0 200p 0 202p 1.65 1700p 1.65 1702p 0)
VS_rk40 s_rk40 0 PWL(0 1.65 200p 1.65 202p 0 1700p 0 1702p 1.65)
VS_rk41 s_rk41 0 PWL(0 1.65 200p 1.65 202p 0 1700p 0 1702p 1.65)
VS_rk42 s_rk42 0 PWL(0 1.65 200p 1.65 202p 0 1700p 0 1702p 1.65)
VS_rk43 s_rk43 0 PWL(0 1.65 200p 1.65 202p 0 1700p 0 1702p 1.65)
VS_rk44 s_rk44 0 PWL(0 1.65 200p 1.65 202p 0 1700p 0 1702p 1.65)
VS_rk45 s_rk45 0 PWL(0 0 200p 0 202p 1.65 1700p 1.65 1702p 0)
VS_rk46 s_rk46 0 PWL(0 0 200p 0 202p 1.65 1700p 1.65 1702p 0)
VS_rk47 s_rk47 0 PWL(0 1.65 200p 1.65 202p 0 1700p 0 1702p 1.65)
VS_rk48 s_rk48 0 PWL(0 0 200p 0 202p 1.65 1700p 1.65 1702p 0)
VS_rk49 s_rk49 0 PWL(0 0 200p 0 202p 1.65 1700p 1.65 1702p 0)
VS_rk5 s_rk5 0 PWL(0 0 200p 0 202p 1.65 1700p 1.65 1702p 0)
VS_rk50 s_rk50 0 PWL(0 0 200p 0 202p 1.65 1700p 1.65 1702p 0)
VS_rk51 s_rk51 0 PWL(0 0 200p 0 202p 1.65 1700p 1.65 1702p 0)
VS_rk52 s_rk52 0 PWL(0 0 200p 0 202p 1.65 1700p 1.65 1702p 0)
VS_rk53 s_rk53 0 PWL(0 1.65 200p 1.65 202p 0 1700p 0 1702p 1.65)
VS_rk54 s_rk54 0 PWL(0 0 200p 0 202p 1.65 1700p 1.65 1702p 0)
VS_rk55 s_rk55 0 PWL(0 1.65 200p 1.65 202p 0 1700p 0 1702p 1.65)
VS_rk56 s_rk56 0 PWL(0 1.65 200p 1.65 202p 0 1700p 0 1702p 1.65)
VS_rk57 s_rk57 0 PWL(0 0 200p 0 202p 1.65 1700p 1.65 1702p 0)
VS_rk58 s_rk58 0 PWL(0 1.65 200p 1.65 202p 0 1700p 0 1702p 1.65)
VS_rk59 s_rk59 0 PWL(0 0 200p 0 202p 1.65 1700p 1.65 1702p 0)
VS_rk6 s_rk6 0 PWL(0 0 200p 0 202p 1.65 1700p 1.65 1702p 0)
VS_rk60 s_rk60 0 PWL(0 0 200p 0 202p 1.65 1700p 1.65 1702p 0)
VS_rk61 s_rk61 0 PWL(0 0 200p 0 202p 1.65 1700p 1.65 1702p 0)
VS_rk62 s_rk62 0 PWL(0 1.65 200p 1.65 202p 0 1700p 0 1702p 1.65)
VS_rk63 s_rk63 0 PWL(0 1.65 200p 1.65 202p 0 1700p 0 1702p 1.65)
VS_rk64 s_rk64 0 PWL(0 0 200p 0 202p 1.65 1700p 1.65 1702p 0)
VS_rk65 s_rk65 0 PWL(0 1.65 200p 1.65 202p 0 1700p 0 1702p 1.65)
VS_rk66 s_rk66 0 PWL(0 1.65 200p 1.65 202p 0 1700p 0 1702p 1.65)
VS_rk67 s_rk67 0 PWL(0 0 200p 0 202p 1.65 1700p 1.65 1702p 0)
VS_rk68 s_rk68 0 PWL(0 0 200p 0 202p 1.65 1700p 1.65 1702p 0)
VS_rk69 s_rk69 0 PWL(0 1.65 200p 1.65 202p 0 1700p 0 1702p 1.65)
VS_rk7 s_rk7 0 PWL(0 0 200p 0 202p 1.65 1700p 1.65 1702p 0)
VS_rk70 s_rk70 0 PWL(0 1.65 200p 1.65 202p 0 1700p 0 1702p 1.65)
VS_rk71 s_rk71 0 PWL(0 1.65 200p 1.65 202p 0 1700p 0 1702p 1.65)
VS_rk72 s_rk72 0 PWL(0 1.65 200p 1.65 202p 0 1700p 0 1702p 1.65)
VS_rk73 s_rk73 0 PWL(0 1.65 200p 1.65 202p 0 1700p 0 1702p 1.65)
VS_rk74 s_rk74 0 PWL(0 0 200p 0 202p 1.65 1700p 1.65 1702p 0)
VS_rk75 s_rk75 0 PWL(0 1.65 200p 1.65 202p 0 1700p 0 1702p 1.65)
VS_rk76 s_rk76 0 PWL(0 0 200p 0 202p 1.65 1700p 1.65 1702p 0)
VS_rk77 s_rk77 0 PWL(0 0 200p 0 202p 1.65 1700p 1.65 1702p 0)
VS_rk78 s_rk78 0 PWL(0 0 200p 0 202p 1.65 1700p 1.65 1702p 0)
VS_rk79 s_rk79 0 PWL(0 0 200p 0 202p 1.65 1700p 1.65 1702p 0)
VS_rk8 s_rk8 0 PWL(0 1.65 200p 1.65 202p 0 1700p 0 1702p 1.65)
VS_rk80 s_rk80 0 PWL(0 0 200p 0 202p 1.65 1700p 1.65 1702p 0)
VS_rk81 s_rk81 0 PWL(0 0 200p 0 202p 1.65 1700p 1.65 1702p 0)
VS_rk82 s_rk82 0 PWL(0 1.65 200p 1.65 202p 0 1700p 0 1702p 1.65)
VS_rk83 s_rk83 0 PWL(0 1.65 200p 1.65 202p 0 1700p 0 1702p 1.65)
VS_rk84 s_rk84 0 PWL(0 0 200p 0 202p 1.65 1700p 1.65 1702p 0)
VS_rk85 s_rk85 0 PWL(0 1.65 200p 1.65 202p 0 1700p 0 1702p 1.65)
VS_rk86 s_rk86 0 PWL(0 0 200p 0 202p 1.65 1700p 1.65 1702p 0)
VS_rk87 s_rk87 0 PWL(0 0 200p 0 202p 1.65 1700p 1.65 1702p 0)
VS_rk88 s_rk88 0 PWL(0 1.65 200p 1.65 202p 0 1700p 0 1702p 1.65)
VS_rk89 s_rk89 0 PWL(0 0 200p 0 202p 1.65 1700p 1.65 1702p 0)
VS_rk9 s_rk9 0 PWL(0 1.65 200p 1.65 202p 0 1700p 0 1702p 1.65)
VS_rk90 s_rk90 0 PWL(0 0 200p 0 202p 1.65 1700p 1.65 1702p 0)
VS_rk91 s_rk91 0 PWL(0 0 200p 0 202p 1.65 1700p 1.65 1702p 0)
VS_rk92 s_rk92 0 PWL(0 1.65 200p 1.65 202p 0 1700p 0 1702p 1.65)
VS_rk93 s_rk93 0 PWL(0 1.65 200p 1.65 202p 0 1700p 0 1702p 1.65)
VS_rk94 s_rk94 0 PWL(0 0 200p 0 202p 1.65 1700p 1.65 1702p 0)
VS_rk95 s_rk95 0 PWL(0 0 200p 0 202p 1.65 1700p 1.65 1702p 0)
VS_rk96 s_rk96 0 PWL(0 0 200p 0 202p 1.65 1700p 1.65 1702p 0)
VS_rk97 s_rk97 0 PWL(0 1.65 200p 1.65 202p 0 1700p 0 1702p 1.65)
VS_rk98 s_rk98 0 PWL(0 0 200p 0 202p 1.65 1700p 1.65 1702p 0)
VS_rk99 s_rk99 0 PWL(0 0 200p 0 202p 1.65 1700p 1.65 1702p 0)
VS_st0 s_st0 0 1.65
VS_st1 s_st1 0 0
VS_st10 s_st10 0 1.65
VS_st100 s_st100 0 0
VS_st101 s_st101 0 1.65
VS_st102 s_st102 0 0
VS_st103 s_st103 0 0
VS_st104 s_st104 0 1.65
VS_st105 s_st105 0 0
VS_st106 s_st106 0 1.65
VS_st107 s_st107 0 0
VS_st108 s_st108 0 0
VS_st109 s_st109 0 0
VS_st11 s_st11 0 0
VS_st110 s_st110 0 0
VS_st111 s_st111 0 0
VS_st112 s_st112 0 1.65
VS_st113 s_st113 0 0
VS_st114 s_st114 0 1.65
VS_st115 s_st115 0 0
VS_st116 s_st116 0 0
VS_st117 s_st117 0 1.65
VS_st118 s_st118 0 1.65
VS_st119 s_st119 0 1.65
VS_st12 s_st12 0 0
VS_st120 s_st120 0 1.65
VS_st121 s_st121 0 0
VS_st122 s_st122 0 1.65
VS_st123 s_st123 0 0
VS_st124 s_st124 0 0
VS_st125 s_st125 0 0
VS_st126 s_st126 0 1.65
VS_st127 s_st127 0 1.65
VS_st13 s_st13 0 0
VS_st14 s_st14 0 0
VS_st15 s_st15 0 1.65
VS_st16 s_st16 0 1.65
VS_st17 s_st17 0 0
VS_st18 s_st18 0 1.65
VS_st19 s_st19 0 0
VS_st2 s_st2 0 1.65
VS_st20 s_st20 0 0
VS_st21 s_st21 0 1.65
VS_st22 s_st22 0 1.65
VS_st23 s_st23 0 0
VS_st24 s_st24 0 1.65
VS_st25 s_st25 0 0
VS_st26 s_st26 0 1.65
VS_st27 s_st27 0 0
VS_st28 s_st28 0 0
VS_st29 s_st29 0 0
VS_st3 s_st3 0 0
VS_st30 s_st30 0 1.65
VS_st31 s_st31 0 0
VS_st32 s_st32 0 1.65
VS_st33 s_st33 0 0
VS_st34 s_st34 0 1.65
VS_st35 s_st35 0 0
VS_st36 s_st36 0 0
VS_st37 s_st37 0 1.65
VS_st38 s_st38 0 0
VS_st39 s_st39 0 0
VS_st4 s_st4 0 0
VS_st40 s_st40 0 1.65
VS_st41 s_st41 0 0
VS_st42 s_st42 0 1.65
VS_st43 s_st43 0 0
VS_st44 s_st44 0 0
VS_st45 s_st45 0 0
VS_st46 s_st46 0 0
VS_st47 s_st47 0 0
VS_st48 s_st48 0 1.65
VS_st49 s_st49 0 0
VS_st5 s_st5 0 1.65
VS_st50 s_st50 0 1.65
VS_st51 s_st51 0 0
VS_st52 s_st52 0 0
VS_st53 s_st53 0 1.65
VS_st54 s_st54 0 1.65
VS_st55 s_st55 0 1.65
VS_st56 s_st56 0 1.65
VS_st57 s_st57 0 0
VS_st58 s_st58 0 1.65
VS_st59 s_st59 0 0
VS_st6 s_st6 0 0
VS_st60 s_st60 0 0
VS_st61 s_st61 0 0
VS_st62 s_st62 0 1.65
VS_st63 s_st63 0 1.65
VS_st64 s_st64 0 1.65
VS_st65 s_st65 0 0
VS_st66 s_st66 0 1.65
VS_st67 s_st67 0 0
VS_st68 s_st68 0 0
VS_st69 s_st69 0 1.65
VS_st7 s_st7 0 1.65
VS_st70 s_st70 0 0
VS_st71 s_st71 0 1.65
VS_st72 s_st72 0 1.65
VS_st73 s_st73 0 0
VS_st74 s_st74 0 1.65
VS_st75 s_st75 0 0
VS_st76 s_st76 0 0
VS_st77 s_st77 0 0
VS_st78 s_st78 0 0
VS_st79 s_st79 0 1.65
VS_st8 s_st8 0 1.65
VS_st80 s_st80 0 1.65
VS_st81 s_st81 0 0
VS_st82 s_st82 0 1.65
VS_st83 s_st83 0 0
VS_st84 s_st84 0 0
VS_st85 s_st85 0 1.65
VS_st86 s_st86 0 1.65
VS_st87 s_st87 0 0
VS_st88 s_st88 0 1.65
VS_st89 s_st89 0 0
VS_st9 s_st9 0 0
VS_st90 s_st90 0 1.65
VS_st91 s_st91 0 0
VS_st92 s_st92 0 0
VS_st93 s_st93 0 0
VS_st94 s_st94 0 1.65
VS_st95 s_st95 0 0
VS_st96 s_st96 0 1.65
VS_st97 s_st97 0 0
VS_st98 s_st98 0 1.65
VS_st99 s_st99 0 0
XXOR20 n0 s_st0 s_rk0 vdd gnm sg13g2_xor2_1
CL0 n0 gnm 2f
CW0 n0 gnm 4.608000f
XXOR21 n1 s_st1 s_rk1 vdd gnm sg13g2_xor2_1
CL1 n1 gnm 2f
CW1 n1 gnm 4.608000f
XXOR22 n2 s_st2 s_rk2 vdd gnm sg13g2_xor2_1
CL2 n2 gnm 2f
CW2 n2 gnm 4.608000f
XXOR23 n3 s_st3 s_rk3 vdd gnm sg13g2_xor2_1
CL3 n3 gnm 2f
CW3 n3 gnm 4.608000f
XXOR24 n4 s_st4 s_rk4 vdd gnm sg13g2_xor2_1
CL4 n4 gnm 2f
CW4 n4 gnm 4.608000f
XXOR25 n5 s_st5 s_rk5 vdd gnm sg13g2_xor2_1
CL5 n5 gnm 2f
CW5 n5 gnm 4.608000f
XXOR26 n6 s_st6 s_rk6 vdd gnm sg13g2_xor2_1
CL6 n6 gnm 2f
CW6 n6 gnm 4.608000f
XXOR27 n7 s_st7 s_rk7 vdd gnm sg13g2_xor2_1
CL7 n7 gnm 2f
CW7 n7 gnm 4.608000f
XXOR28 n8 s_st8 s_rk8 vdd gnm sg13g2_xor2_1
CL8 n8 gnm 2f
CW8 n8 gnm 4.608000f
XXOR29 n9 s_st9 s_rk9 vdd gnm sg13g2_xor2_1
CL9 n9 gnm 2f
CW9 n9 gnm 4.608000f
XXOR210 n10 s_st10 s_rk10 vdd gnm sg13g2_xor2_1
CL10 n10 gnm 2f
CW10 n10 gnm 4.608000f
XXOR211 n11 s_st11 s_rk11 vdd gnm sg13g2_xor2_1
CL11 n11 gnm 2f
CW11 n11 gnm 4.608000f
XXOR212 n12 s_st12 s_rk12 vdd gnm sg13g2_xor2_1
CL12 n12 gnm 2f
CW12 n12 gnm 4.608000f
XXOR213 n13 s_st13 s_rk13 vdd gnm sg13g2_xor2_1
CL13 n13 gnm 2f
CW13 n13 gnm 4.608000f
XXOR214 n14 s_st14 s_rk14 vdd gnm sg13g2_xor2_1
CL14 n14 gnm 2f
CW14 n14 gnm 4.608000f
XXOR215 n15 s_st15 s_rk15 vdd gnm sg13g2_xor2_1
CL15 n15 gnm 2f
CW15 n15 gnm 4.608000f
XXOR216 n16 s_st16 s_rk16 vdd gnm sg13g2_xor2_1
CL16 n16 gnm 2f
CW16 n16 gnm 4.608000f
XXOR217 n17 s_st17 s_rk17 vdd gnm sg13g2_xor2_1
CL17 n17 gnm 2f
CW17 n17 gnm 4.608000f
XXOR218 n18 s_st18 s_rk18 vdd gnm sg13g2_xor2_1
CL18 n18 gnm 2f
CW18 n18 gnm 4.608000f
XXOR219 n19 s_st19 s_rk19 vdd gnm sg13g2_xor2_1
CL19 n19 gnm 2f
CW19 n19 gnm 4.608000f
XXOR220 n20 s_st20 s_rk20 vdd gnm sg13g2_xor2_1
CL20 n20 gnm 2f
CW20 n20 gnm 4.608000f
XXOR221 n21 s_st21 s_rk21 vdd gnm sg13g2_xor2_1
CL21 n21 gnm 2f
CW21 n21 gnm 4.608000f
XXOR222 n22 s_st22 s_rk22 vdd gnm sg13g2_xor2_1
CL22 n22 gnm 2f
CW22 n22 gnm 4.608000f
XXOR223 n23 s_st23 s_rk23 vdd gnm sg13g2_xor2_1
CL23 n23 gnm 2f
CW23 n23 gnm 4.608000f
XXOR224 n24 s_st24 s_rk24 vdd gnm sg13g2_xor2_1
CL24 n24 gnm 2f
CW24 n24 gnm 4.608000f
XXOR225 n25 s_st25 s_rk25 vdd gnm sg13g2_xor2_1
CL25 n25 gnm 2f
CW25 n25 gnm 4.608000f
XXOR226 n26 s_st26 s_rk26 vdd gnm sg13g2_xor2_1
CL26 n26 gnm 2f
CW26 n26 gnm 4.608000f
XXOR227 n27 s_st27 s_rk27 vdd gnm sg13g2_xor2_1
CL27 n27 gnm 2f
CW27 n27 gnm 4.608000f
XXOR228 n28 s_st28 s_rk28 vdd gnm sg13g2_xor2_1
CL28 n28 gnm 2f
CW28 n28 gnm 4.608000f
XXOR229 n29 s_st29 s_rk29 vdd gnm sg13g2_xor2_1
CL29 n29 gnm 2f
CW29 n29 gnm 4.608000f
XXOR230 n30 s_st30 s_rk30 vdd gnm sg13g2_xor2_1
CL30 n30 gnm 2f
CW30 n30 gnm 4.608000f
XXOR231 n31 s_st31 s_rk31 vdd gnm sg13g2_xor2_1
CL31 n31 gnm 2f
CW31 n31 gnm 4.608000f
XXOR232 n32 s_st32 s_rk32 vdd gnm sg13g2_xor2_1
CL32 n32 gnm 2f
CW32 n32 gnm 4.608000f
XXOR233 n33 s_st33 s_rk33 vdd gnm sg13g2_xor2_1
CL33 n33 gnm 2f
CW33 n33 gnm 4.608000f
XXOR234 n34 s_st34 s_rk34 vdd gnm sg13g2_xor2_1
CL34 n34 gnm 2f
CW34 n34 gnm 4.608000f
XXOR235 n35 s_st35 s_rk35 vdd gnm sg13g2_xor2_1
CL35 n35 gnm 2f
CW35 n35 gnm 4.608000f
XXOR236 n36 s_st36 s_rk36 vdd gnm sg13g2_xor2_1
CL36 n36 gnm 2f
CW36 n36 gnm 4.608000f
XXOR237 n37 s_st37 s_rk37 vdd gnm sg13g2_xor2_1
CL37 n37 gnm 2f
CW37 n37 gnm 4.608000f
XXOR238 n38 s_st38 s_rk38 vdd gnm sg13g2_xor2_1
CL38 n38 gnm 2f
CW38 n38 gnm 4.608000f
XXOR239 n39 s_st39 s_rk39 vdd gnm sg13g2_xor2_1
CL39 n39 gnm 2f
CW39 n39 gnm 4.608000f
XXOR240 n40 s_st40 s_rk40 vdd gnm sg13g2_xor2_1
CL40 n40 gnm 2f
CW40 n40 gnm 4.608000f
XXOR241 n41 s_st41 s_rk41 vdd gnm sg13g2_xor2_1
CL41 n41 gnm 2f
CW41 n41 gnm 4.608000f
XXOR242 n42 s_st42 s_rk42 vdd gnm sg13g2_xor2_1
CL42 n42 gnm 2f
CW42 n42 gnm 4.608000f
XXOR243 n43 s_st43 s_rk43 vdd gnm sg13g2_xor2_1
CL43 n43 gnm 2f
CW43 n43 gnm 4.608000f
XXOR244 n44 s_st44 s_rk44 vdd gnm sg13g2_xor2_1
CL44 n44 gnm 2f
CW44 n44 gnm 4.608000f
XXOR245 n45 s_st45 s_rk45 vdd gnm sg13g2_xor2_1
CL45 n45 gnm 2f
CW45 n45 gnm 4.608000f
XXOR246 n46 s_st46 s_rk46 vdd gnm sg13g2_xor2_1
CL46 n46 gnm 2f
CW46 n46 gnm 4.608000f
XXOR247 n47 s_st47 s_rk47 vdd gnm sg13g2_xor2_1
CL47 n47 gnm 2f
CW47 n47 gnm 4.608000f
XXOR248 n48 s_st48 s_rk48 vdd gnm sg13g2_xor2_1
CL48 n48 gnm 2f
CW48 n48 gnm 4.608000f
XXOR249 n49 s_st49 s_rk49 vdd gnm sg13g2_xor2_1
CL49 n49 gnm 2f
CW49 n49 gnm 4.608000f
XXOR250 n50 s_st50 s_rk50 vdd gnm sg13g2_xor2_1
CL50 n50 gnm 2f
CW50 n50 gnm 4.608000f
XXOR251 n51 s_st51 s_rk51 vdd gnm sg13g2_xor2_1
CL51 n51 gnm 2f
CW51 n51 gnm 4.608000f
XXOR252 n52 s_st52 s_rk52 vdd gnm sg13g2_xor2_1
CL52 n52 gnm 2f
CW52 n52 gnm 4.608000f
XXOR253 n53 s_st53 s_rk53 vdd gnm sg13g2_xor2_1
CL53 n53 gnm 2f
CW53 n53 gnm 4.608000f
XXOR254 n54 s_st54 s_rk54 vdd gnm sg13g2_xor2_1
CL54 n54 gnm 2f
CW54 n54 gnm 4.608000f
XXOR255 n55 s_st55 s_rk55 vdd gnm sg13g2_xor2_1
CL55 n55 gnm 2f
CW55 n55 gnm 4.608000f
XXOR256 n56 s_st56 s_rk56 vdd gnm sg13g2_xor2_1
CL56 n56 gnm 2f
CW56 n56 gnm 4.608000f
XXOR257 n57 s_st57 s_rk57 vdd gnm sg13g2_xor2_1
CL57 n57 gnm 2f
CW57 n57 gnm 4.608000f
XXOR258 n58 s_st58 s_rk58 vdd gnm sg13g2_xor2_1
CL58 n58 gnm 2f
CW58 n58 gnm 4.608000f
XXOR259 n59 s_st59 s_rk59 vdd gnm sg13g2_xor2_1
CL59 n59 gnm 2f
CW59 n59 gnm 4.608000f
XXOR260 n60 s_st60 s_rk60 vdd gnm sg13g2_xor2_1
CL60 n60 gnm 2f
CW60 n60 gnm 4.608000f
XXOR261 n61 s_st61 s_rk61 vdd gnm sg13g2_xor2_1
CL61 n61 gnm 2f
CW61 n61 gnm 4.608000f
XXOR262 n62 s_st62 s_rk62 vdd gnm sg13g2_xor2_1
CL62 n62 gnm 2f
CW62 n62 gnm 4.608000f
XXOR263 n63 s_st63 s_rk63 vdd gnm sg13g2_xor2_1
CL63 n63 gnm 2f
CW63 n63 gnm 4.608000f
XXOR264 n64 s_st64 s_rk64 vdd gnm sg13g2_xor2_1
CL64 n64 gnm 2f
CW64 n64 gnm 4.608000f
XXOR265 n65 s_st65 s_rk65 vdd gnm sg13g2_xor2_1
CL65 n65 gnm 2f
CW65 n65 gnm 4.608000f
XXOR266 n66 s_st66 s_rk66 vdd gnm sg13g2_xor2_1
CL66 n66 gnm 2f
CW66 n66 gnm 4.608000f
XXOR267 n67 s_st67 s_rk67 vdd gnm sg13g2_xor2_1
CL67 n67 gnm 2f
CW67 n67 gnm 4.608000f
XXOR268 n68 s_st68 s_rk68 vdd gnm sg13g2_xor2_1
CL68 n68 gnm 2f
CW68 n68 gnm 4.608000f
XXOR269 n69 s_st69 s_rk69 vdd gnm sg13g2_xor2_1
CL69 n69 gnm 2f
CW69 n69 gnm 4.608000f
XXOR270 n70 s_st70 s_rk70 vdd gnm sg13g2_xor2_1
CL70 n70 gnm 2f
CW70 n70 gnm 4.608000f
XXOR271 n71 s_st71 s_rk71 vdd gnm sg13g2_xor2_1
CL71 n71 gnm 2f
CW71 n71 gnm 4.608000f
XXOR272 n72 s_st72 s_rk72 vdd gnm sg13g2_xor2_1
CL72 n72 gnm 2f
CW72 n72 gnm 4.608000f
XXOR273 n73 s_st73 s_rk73 vdd gnm sg13g2_xor2_1
CL73 n73 gnm 2f
CW73 n73 gnm 4.608000f
XXOR274 n74 s_st74 s_rk74 vdd gnm sg13g2_xor2_1
CL74 n74 gnm 2f
CW74 n74 gnm 4.608000f
XXOR275 n75 s_st75 s_rk75 vdd gnm sg13g2_xor2_1
CL75 n75 gnm 2f
CW75 n75 gnm 4.608000f
XXOR276 n76 s_st76 s_rk76 vdd gnm sg13g2_xor2_1
CL76 n76 gnm 2f
CW76 n76 gnm 4.608000f
XXOR277 n77 s_st77 s_rk77 vdd gnm sg13g2_xor2_1
CL77 n77 gnm 2f
CW77 n77 gnm 4.608000f
XXOR278 n78 s_st78 s_rk78 vdd gnm sg13g2_xor2_1
CL78 n78 gnm 2f
CW78 n78 gnm 4.608000f
XXOR279 n79 s_st79 s_rk79 vdd gnm sg13g2_xor2_1
CL79 n79 gnm 2f
CW79 n79 gnm 4.608000f
XXOR280 n80 s_st80 s_rk80 vdd gnm sg13g2_xor2_1
CL80 n80 gnm 2f
CW80 n80 gnm 4.608000f
XXOR281 n81 s_st81 s_rk81 vdd gnm sg13g2_xor2_1
CL81 n81 gnm 2f
CW81 n81 gnm 4.608000f
XXOR282 n82 s_st82 s_rk82 vdd gnm sg13g2_xor2_1
CL82 n82 gnm 2f
CW82 n82 gnm 4.608000f
XXOR283 n83 s_st83 s_rk83 vdd gnm sg13g2_xor2_1
CL83 n83 gnm 2f
CW83 n83 gnm 4.608000f
XXOR284 n84 s_st84 s_rk84 vdd gnm sg13g2_xor2_1
CL84 n84 gnm 2f
CW84 n84 gnm 4.608000f
XXOR285 n85 s_st85 s_rk85 vdd gnm sg13g2_xor2_1
CL85 n85 gnm 2f
CW85 n85 gnm 4.608000f
XXOR286 n86 s_st86 s_rk86 vdd gnm sg13g2_xor2_1
CL86 n86 gnm 2f
CW86 n86 gnm 4.608000f
XXOR287 n87 s_st87 s_rk87 vdd gnm sg13g2_xor2_1
CL87 n87 gnm 2f
CW87 n87 gnm 4.608000f
XXOR288 n88 s_st88 s_rk88 vdd gnm sg13g2_xor2_1
CL88 n88 gnm 2f
CW88 n88 gnm 4.608000f
XXOR289 n89 s_st89 s_rk89 vdd gnm sg13g2_xor2_1
CL89 n89 gnm 2f
CW89 n89 gnm 4.608000f
XXOR290 n90 s_st90 s_rk90 vdd gnm sg13g2_xor2_1
CL90 n90 gnm 2f
CW90 n90 gnm 4.608000f
XXOR291 n91 s_st91 s_rk91 vdd gnm sg13g2_xor2_1
CL91 n91 gnm 2f
CW91 n91 gnm 4.608000f
XXOR292 n92 s_st92 s_rk92 vdd gnm sg13g2_xor2_1
CL92 n92 gnm 2f
CW92 n92 gnm 4.608000f
XXOR293 n93 s_st93 s_rk93 vdd gnm sg13g2_xor2_1
CL93 n93 gnm 2f
CW93 n93 gnm 4.608000f
XXOR294 n94 s_st94 s_rk94 vdd gnm sg13g2_xor2_1
CL94 n94 gnm 2f
CW94 n94 gnm 4.608000f
XXOR295 n95 s_st95 s_rk95 vdd gnm sg13g2_xor2_1
CL95 n95 gnm 2f
CW95 n95 gnm 4.608000f
XXOR296 n96 s_st96 s_rk96 vdd gnm sg13g2_xor2_1
CL96 n96 gnm 2f
CW96 n96 gnm 4.608000f
XXOR297 n97 s_st97 s_rk97 vdd gnm sg13g2_xor2_1
CL97 n97 gnm 2f
CW97 n97 gnm 4.608000f
XXOR298 n98 s_st98 s_rk98 vdd gnm sg13g2_xor2_1
CL98 n98 gnm 2f
CW98 n98 gnm 4.608000f
XXOR299 n99 s_st99 s_rk99 vdd gnm sg13g2_xor2_1
CL99 n99 gnm 2f
CW99 n99 gnm 4.608000f
XXOR2100 n100 s_st100 s_rk100 vdd gnm sg13g2_xor2_1
CL100 n100 gnm 2f
CW100 n100 gnm 4.608000f
XXOR2101 n101 s_st101 s_rk101 vdd gnm sg13g2_xor2_1
CL101 n101 gnm 2f
CW101 n101 gnm 4.608000f
XXOR2102 n102 s_st102 s_rk102 vdd gnm sg13g2_xor2_1
CL102 n102 gnm 2f
CW102 n102 gnm 4.608000f
XXOR2103 n103 s_st103 s_rk103 vdd gnm sg13g2_xor2_1
CL103 n103 gnm 2f
CW103 n103 gnm 4.608000f
XXOR2104 n104 s_st104 s_rk104 vdd gnm sg13g2_xor2_1
CL104 n104 gnm 2f
CW104 n104 gnm 4.608000f
XXOR2105 n105 s_st105 s_rk105 vdd gnm sg13g2_xor2_1
CL105 n105 gnm 2f
CW105 n105 gnm 4.608000f
XXOR2106 n106 s_st106 s_rk106 vdd gnm sg13g2_xor2_1
CL106 n106 gnm 2f
CW106 n106 gnm 4.608000f
XXOR2107 n107 s_st107 s_rk107 vdd gnm sg13g2_xor2_1
CL107 n107 gnm 2f
CW107 n107 gnm 4.608000f
XXOR2108 n108 s_st108 s_rk108 vdd gnm sg13g2_xor2_1
CL108 n108 gnm 2f
CW108 n108 gnm 4.608000f
XXOR2109 n109 s_st109 s_rk109 vdd gnm sg13g2_xor2_1
CL109 n109 gnm 2f
CW109 n109 gnm 4.608000f
XXOR2110 n110 s_st110 s_rk110 vdd gnm sg13g2_xor2_1
CL110 n110 gnm 2f
CW110 n110 gnm 4.608000f
XXOR2111 n111 s_st111 s_rk111 vdd gnm sg13g2_xor2_1
CL111 n111 gnm 2f
CW111 n111 gnm 4.608000f
XXOR2112 n112 s_st112 s_rk112 vdd gnm sg13g2_xor2_1
CL112 n112 gnm 2f
CW112 n112 gnm 4.608000f
XXOR2113 n113 s_st113 s_rk113 vdd gnm sg13g2_xor2_1
CL113 n113 gnm 2f
CW113 n113 gnm 4.608000f
XXOR2114 n114 s_st114 s_rk114 vdd gnm sg13g2_xor2_1
CL114 n114 gnm 2f
CW114 n114 gnm 4.608000f
XXOR2115 n115 s_st115 s_rk115 vdd gnm sg13g2_xor2_1
CL115 n115 gnm 2f
CW115 n115 gnm 4.608000f
XXOR2116 n116 s_st116 s_rk116 vdd gnm sg13g2_xor2_1
CL116 n116 gnm 2f
CW116 n116 gnm 4.608000f
XXOR2117 n117 s_st117 s_rk117 vdd gnm sg13g2_xor2_1
CL117 n117 gnm 2f
CW117 n117 gnm 4.608000f
XXOR2118 n118 s_st118 s_rk118 vdd gnm sg13g2_xor2_1
CL118 n118 gnm 2f
CW118 n118 gnm 4.608000f
XXOR2119 n119 s_st119 s_rk119 vdd gnm sg13g2_xor2_1
CL119 n119 gnm 2f
CW119 n119 gnm 4.608000f
XXOR2120 n120 s_st120 s_rk120 vdd gnm sg13g2_xor2_1
CL120 n120 gnm 2f
CW120 n120 gnm 4.608000f
XXOR2121 n121 s_st121 s_rk121 vdd gnm sg13g2_xor2_1
CL121 n121 gnm 2f
CW121 n121 gnm 4.608000f
XXOR2122 n122 s_st122 s_rk122 vdd gnm sg13g2_xor2_1
CL122 n122 gnm 2f
CW122 n122 gnm 4.608000f
XXOR2123 n123 s_st123 s_rk123 vdd gnm sg13g2_xor2_1
CL123 n123 gnm 2f
CW123 n123 gnm 4.608000f
XXOR2124 n124 s_st124 s_rk124 vdd gnm sg13g2_xor2_1
CL124 n124 gnm 2f
CW124 n124 gnm 4.608000f
XXOR2125 n125 s_st125 s_rk125 vdd gnm sg13g2_xor2_1
CL125 n125 gnm 2f
CW125 n125 gnm 4.608000f
XXOR2126 n126 s_st126 s_rk126 vdd gnm sg13g2_xor2_1
CL126 n126 gnm 2f
CW126 n126 gnm 4.608000f
XXOR2127 n127 s_st127 s_rk127 vdd gnm sg13g2_xor2_1
CL127 n127 gnm 2f
CW127 n127 gnm 4.608000f
CXqvdd xqvdd 0 1
BXqvdd 0 xqvdd I={ -I(VDD) }
RXqvdd xqvdd 0 0.01
.tran 0.1p 2202p 0 0.25p
.measure tran QVDD_Z FIND V(xqvdd) AT=1.500000p
.measure tran QVDD_A FIND V(xqvdd) AT=201.000000p
.measure tran QVDD_B FIND V(xqvdd) AT=1701.000000p
.measure tran QVDD_D FIND V(xqvdd) AT=2198.000000p
.measure tran M_n0 FIND V(n0) AT=2198.000000p
.measure tran C_n0 FIND V(n0) AT=1696.000000p
.measure tran M_n1 FIND V(n1) AT=2198.000000p
.measure tran C_n1 FIND V(n1) AT=1696.000000p
.measure tran M_n2 FIND V(n2) AT=2198.000000p
.measure tran C_n2 FIND V(n2) AT=1696.000000p
.measure tran M_n3 FIND V(n3) AT=2198.000000p
.measure tran C_n3 FIND V(n3) AT=1696.000000p
.measure tran M_n4 FIND V(n4) AT=2198.000000p
.measure tran C_n4 FIND V(n4) AT=1696.000000p
.measure tran M_n5 FIND V(n5) AT=2198.000000p
.measure tran C_n5 FIND V(n5) AT=1696.000000p
.measure tran M_n6 FIND V(n6) AT=2198.000000p
.measure tran C_n6 FIND V(n6) AT=1696.000000p
.measure tran M_n7 FIND V(n7) AT=2198.000000p
.measure tran C_n7 FIND V(n7) AT=1696.000000p
.measure tran M_n8 FIND V(n8) AT=2198.000000p
.measure tran C_n8 FIND V(n8) AT=1696.000000p
.measure tran M_n9 FIND V(n9) AT=2198.000000p
.measure tran C_n9 FIND V(n9) AT=1696.000000p
.measure tran M_n10 FIND V(n10) AT=2198.000000p
.measure tran C_n10 FIND V(n10) AT=1696.000000p
.measure tran M_n11 FIND V(n11) AT=2198.000000p
.measure tran C_n11 FIND V(n11) AT=1696.000000p
.measure tran M_n12 FIND V(n12) AT=2198.000000p
.measure tran C_n12 FIND V(n12) AT=1696.000000p
.measure tran M_n13 FIND V(n13) AT=2198.000000p
.measure tran C_n13 FIND V(n13) AT=1696.000000p
.measure tran M_n14 FIND V(n14) AT=2198.000000p
.measure tran C_n14 FIND V(n14) AT=1696.000000p
.measure tran M_n15 FIND V(n15) AT=2198.000000p
.measure tran C_n15 FIND V(n15) AT=1696.000000p
.measure tran M_n16 FIND V(n16) AT=2198.000000p
.measure tran C_n16 FIND V(n16) AT=1696.000000p
.measure tran M_n17 FIND V(n17) AT=2198.000000p
.measure tran C_n17 FIND V(n17) AT=1696.000000p
.measure tran M_n18 FIND V(n18) AT=2198.000000p
.measure tran C_n18 FIND V(n18) AT=1696.000000p
.measure tran M_n19 FIND V(n19) AT=2198.000000p
.measure tran C_n19 FIND V(n19) AT=1696.000000p
.measure tran M_n20 FIND V(n20) AT=2198.000000p
.measure tran C_n20 FIND V(n20) AT=1696.000000p
.measure tran M_n21 FIND V(n21) AT=2198.000000p
.measure tran C_n21 FIND V(n21) AT=1696.000000p
.measure tran M_n22 FIND V(n22) AT=2198.000000p
.measure tran C_n22 FIND V(n22) AT=1696.000000p
.measure tran M_n23 FIND V(n23) AT=2198.000000p
.measure tran C_n23 FIND V(n23) AT=1696.000000p
.measure tran M_n24 FIND V(n24) AT=2198.000000p
.measure tran C_n24 FIND V(n24) AT=1696.000000p
.measure tran M_n25 FIND V(n25) AT=2198.000000p
.measure tran C_n25 FIND V(n25) AT=1696.000000p
.measure tran M_n26 FIND V(n26) AT=2198.000000p
.measure tran C_n26 FIND V(n26) AT=1696.000000p
.measure tran M_n27 FIND V(n27) AT=2198.000000p
.measure tran C_n27 FIND V(n27) AT=1696.000000p
.measure tran M_n28 FIND V(n28) AT=2198.000000p
.measure tran C_n28 FIND V(n28) AT=1696.000000p
.measure tran M_n29 FIND V(n29) AT=2198.000000p
.measure tran C_n29 FIND V(n29) AT=1696.000000p
.measure tran M_n30 FIND V(n30) AT=2198.000000p
.measure tran C_n30 FIND V(n30) AT=1696.000000p
.measure tran M_n31 FIND V(n31) AT=2198.000000p
.measure tran C_n31 FIND V(n31) AT=1696.000000p
.measure tran M_n32 FIND V(n32) AT=2198.000000p
.measure tran C_n32 FIND V(n32) AT=1696.000000p
.measure tran M_n33 FIND V(n33) AT=2198.000000p
.measure tran C_n33 FIND V(n33) AT=1696.000000p
.measure tran M_n34 FIND V(n34) AT=2198.000000p
.measure tran C_n34 FIND V(n34) AT=1696.000000p
.measure tran M_n35 FIND V(n35) AT=2198.000000p
.measure tran C_n35 FIND V(n35) AT=1696.000000p
.measure tran M_n36 FIND V(n36) AT=2198.000000p
.measure tran C_n36 FIND V(n36) AT=1696.000000p
.measure tran M_n37 FIND V(n37) AT=2198.000000p
.measure tran C_n37 FIND V(n37) AT=1696.000000p
.measure tran M_n38 FIND V(n38) AT=2198.000000p
.measure tran C_n38 FIND V(n38) AT=1696.000000p
.measure tran M_n39 FIND V(n39) AT=2198.000000p
.measure tran C_n39 FIND V(n39) AT=1696.000000p
.measure tran M_n40 FIND V(n40) AT=2198.000000p
.measure tran C_n40 FIND V(n40) AT=1696.000000p
.measure tran M_n41 FIND V(n41) AT=2198.000000p
.measure tran C_n41 FIND V(n41) AT=1696.000000p
.measure tran M_n42 FIND V(n42) AT=2198.000000p
.measure tran C_n42 FIND V(n42) AT=1696.000000p
.measure tran M_n43 FIND V(n43) AT=2198.000000p
.measure tran C_n43 FIND V(n43) AT=1696.000000p
.measure tran M_n44 FIND V(n44) AT=2198.000000p
.measure tran C_n44 FIND V(n44) AT=1696.000000p
.measure tran M_n45 FIND V(n45) AT=2198.000000p
.measure tran C_n45 FIND V(n45) AT=1696.000000p
.measure tran M_n46 FIND V(n46) AT=2198.000000p
.measure tran C_n46 FIND V(n46) AT=1696.000000p
.measure tran M_n47 FIND V(n47) AT=2198.000000p
.measure tran C_n47 FIND V(n47) AT=1696.000000p
.measure tran M_n48 FIND V(n48) AT=2198.000000p
.measure tran C_n48 FIND V(n48) AT=1696.000000p
.measure tran M_n49 FIND V(n49) AT=2198.000000p
.measure tran C_n49 FIND V(n49) AT=1696.000000p
.measure tran M_n50 FIND V(n50) AT=2198.000000p
.measure tran C_n50 FIND V(n50) AT=1696.000000p
.measure tran M_n51 FIND V(n51) AT=2198.000000p
.measure tran C_n51 FIND V(n51) AT=1696.000000p
.measure tran M_n52 FIND V(n52) AT=2198.000000p
.measure tran C_n52 FIND V(n52) AT=1696.000000p
.measure tran M_n53 FIND V(n53) AT=2198.000000p
.measure tran C_n53 FIND V(n53) AT=1696.000000p
.measure tran M_n54 FIND V(n54) AT=2198.000000p
.measure tran C_n54 FIND V(n54) AT=1696.000000p
.measure tran M_n55 FIND V(n55) AT=2198.000000p
.measure tran C_n55 FIND V(n55) AT=1696.000000p
.measure tran M_n56 FIND V(n56) AT=2198.000000p
.measure tran C_n56 FIND V(n56) AT=1696.000000p
.measure tran M_n57 FIND V(n57) AT=2198.000000p
.measure tran C_n57 FIND V(n57) AT=1696.000000p
.measure tran M_n58 FIND V(n58) AT=2198.000000p
.measure tran C_n58 FIND V(n58) AT=1696.000000p
.measure tran M_n59 FIND V(n59) AT=2198.000000p
.measure tran C_n59 FIND V(n59) AT=1696.000000p
.measure tran M_n60 FIND V(n60) AT=2198.000000p
.measure tran C_n60 FIND V(n60) AT=1696.000000p
.measure tran M_n61 FIND V(n61) AT=2198.000000p
.measure tran C_n61 FIND V(n61) AT=1696.000000p
.measure tran M_n62 FIND V(n62) AT=2198.000000p
.measure tran C_n62 FIND V(n62) AT=1696.000000p
.measure tran M_n63 FIND V(n63) AT=2198.000000p
.measure tran C_n63 FIND V(n63) AT=1696.000000p
.measure tran M_n64 FIND V(n64) AT=2198.000000p
.measure tran C_n64 FIND V(n64) AT=1696.000000p
.measure tran M_n65 FIND V(n65) AT=2198.000000p
.measure tran C_n65 FIND V(n65) AT=1696.000000p
.measure tran M_n66 FIND V(n66) AT=2198.000000p
.measure tran C_n66 FIND V(n66) AT=1696.000000p
.measure tran M_n67 FIND V(n67) AT=2198.000000p
.measure tran C_n67 FIND V(n67) AT=1696.000000p
.measure tran M_n68 FIND V(n68) AT=2198.000000p
.measure tran C_n68 FIND V(n68) AT=1696.000000p
.measure tran M_n69 FIND V(n69) AT=2198.000000p
.measure tran C_n69 FIND V(n69) AT=1696.000000p
.measure tran M_n70 FIND V(n70) AT=2198.000000p
.measure tran C_n70 FIND V(n70) AT=1696.000000p
.measure tran M_n71 FIND V(n71) AT=2198.000000p
.measure tran C_n71 FIND V(n71) AT=1696.000000p
.measure tran M_n72 FIND V(n72) AT=2198.000000p
.measure tran C_n72 FIND V(n72) AT=1696.000000p
.measure tran M_n73 FIND V(n73) AT=2198.000000p
.measure tran C_n73 FIND V(n73) AT=1696.000000p
.measure tran M_n74 FIND V(n74) AT=2198.000000p
.measure tran C_n74 FIND V(n74) AT=1696.000000p
.measure tran M_n75 FIND V(n75) AT=2198.000000p
.measure tran C_n75 FIND V(n75) AT=1696.000000p
.measure tran M_n76 FIND V(n76) AT=2198.000000p
.measure tran C_n76 FIND V(n76) AT=1696.000000p
.measure tran M_n77 FIND V(n77) AT=2198.000000p
.measure tran C_n77 FIND V(n77) AT=1696.000000p
.measure tran M_n78 FIND V(n78) AT=2198.000000p
.measure tran C_n78 FIND V(n78) AT=1696.000000p
.measure tran M_n79 FIND V(n79) AT=2198.000000p
.measure tran C_n79 FIND V(n79) AT=1696.000000p
.measure tran M_n80 FIND V(n80) AT=2198.000000p
.measure tran C_n80 FIND V(n80) AT=1696.000000p
.measure tran M_n81 FIND V(n81) AT=2198.000000p
.measure tran C_n81 FIND V(n81) AT=1696.000000p
.measure tran M_n82 FIND V(n82) AT=2198.000000p
.measure tran C_n82 FIND V(n82) AT=1696.000000p
.measure tran M_n83 FIND V(n83) AT=2198.000000p
.measure tran C_n83 FIND V(n83) AT=1696.000000p
.measure tran M_n84 FIND V(n84) AT=2198.000000p
.measure tran C_n84 FIND V(n84) AT=1696.000000p
.measure tran M_n85 FIND V(n85) AT=2198.000000p
.measure tran C_n85 FIND V(n85) AT=1696.000000p
.measure tran M_n86 FIND V(n86) AT=2198.000000p
.measure tran C_n86 FIND V(n86) AT=1696.000000p
.measure tran M_n87 FIND V(n87) AT=2198.000000p
.measure tran C_n87 FIND V(n87) AT=1696.000000p
.measure tran M_n88 FIND V(n88) AT=2198.000000p
.measure tran C_n88 FIND V(n88) AT=1696.000000p
.measure tran M_n89 FIND V(n89) AT=2198.000000p
.measure tran C_n89 FIND V(n89) AT=1696.000000p
.measure tran M_n90 FIND V(n90) AT=2198.000000p
.measure tran C_n90 FIND V(n90) AT=1696.000000p
.measure tran M_n91 FIND V(n91) AT=2198.000000p
.measure tran C_n91 FIND V(n91) AT=1696.000000p
.measure tran M_n92 FIND V(n92) AT=2198.000000p
.measure tran C_n92 FIND V(n92) AT=1696.000000p
.measure tran M_n93 FIND V(n93) AT=2198.000000p
.measure tran C_n93 FIND V(n93) AT=1696.000000p
.measure tran M_n94 FIND V(n94) AT=2198.000000p
.measure tran C_n94 FIND V(n94) AT=1696.000000p
.measure tran M_n95 FIND V(n95) AT=2198.000000p
.measure tran C_n95 FIND V(n95) AT=1696.000000p
.measure tran M_n96 FIND V(n96) AT=2198.000000p
.measure tran C_n96 FIND V(n96) AT=1696.000000p
.measure tran M_n97 FIND V(n97) AT=2198.000000p
.measure tran C_n97 FIND V(n97) AT=1696.000000p
.measure tran M_n98 FIND V(n98) AT=2198.000000p
.measure tran C_n98 FIND V(n98) AT=1696.000000p
.measure tran M_n99 FIND V(n99) AT=2198.000000p
.measure tran C_n99 FIND V(n99) AT=1696.000000p
.measure tran M_n100 FIND V(n100) AT=2198.000000p
.measure tran C_n100 FIND V(n100) AT=1696.000000p
.measure tran M_n101 FIND V(n101) AT=2198.000000p
.measure tran C_n101 FIND V(n101) AT=1696.000000p
.measure tran M_n102 FIND V(n102) AT=2198.000000p
.measure tran C_n102 FIND V(n102) AT=1696.000000p
.measure tran M_n103 FIND V(n103) AT=2198.000000p
.measure tran C_n103 FIND V(n103) AT=1696.000000p
.measure tran M_n104 FIND V(n104) AT=2198.000000p
.measure tran C_n104 FIND V(n104) AT=1696.000000p
.measure tran M_n105 FIND V(n105) AT=2198.000000p
.measure tran C_n105 FIND V(n105) AT=1696.000000p
.measure tran M_n106 FIND V(n106) AT=2198.000000p
.measure tran C_n106 FIND V(n106) AT=1696.000000p
.measure tran M_n107 FIND V(n107) AT=2198.000000p
.measure tran C_n107 FIND V(n107) AT=1696.000000p
.measure tran M_n108 FIND V(n108) AT=2198.000000p
.measure tran C_n108 FIND V(n108) AT=1696.000000p
.measure tran M_n109 FIND V(n109) AT=2198.000000p
.measure tran C_n109 FIND V(n109) AT=1696.000000p
.measure tran M_n110 FIND V(n110) AT=2198.000000p
.measure tran C_n110 FIND V(n110) AT=1696.000000p
.measure tran M_n111 FIND V(n111) AT=2198.000000p
.measure tran C_n111 FIND V(n111) AT=1696.000000p
.measure tran M_n112 FIND V(n112) AT=2198.000000p
.measure tran C_n112 FIND V(n112) AT=1696.000000p
.measure tran M_n113 FIND V(n113) AT=2198.000000p
.measure tran C_n113 FIND V(n113) AT=1696.000000p
.measure tran M_n114 FIND V(n114) AT=2198.000000p
.measure tran C_n114 FIND V(n114) AT=1696.000000p
.measure tran M_n115 FIND V(n115) AT=2198.000000p
.measure tran C_n115 FIND V(n115) AT=1696.000000p
.measure tran M_n116 FIND V(n116) AT=2198.000000p
.measure tran C_n116 FIND V(n116) AT=1696.000000p
.measure tran M_n117 FIND V(n117) AT=2198.000000p
.measure tran C_n117 FIND V(n117) AT=1696.000000p
.measure tran M_n118 FIND V(n118) AT=2198.000000p
.measure tran C_n118 FIND V(n118) AT=1696.000000p
.measure tran M_n119 FIND V(n119) AT=2198.000000p
.measure tran C_n119 FIND V(n119) AT=1696.000000p
.measure tran M_n120 FIND V(n120) AT=2198.000000p
.measure tran C_n120 FIND V(n120) AT=1696.000000p
.measure tran M_n121 FIND V(n121) AT=2198.000000p
.measure tran C_n121 FIND V(n121) AT=1696.000000p
.measure tran M_n122 FIND V(n122) AT=2198.000000p
.measure tran C_n122 FIND V(n122) AT=1696.000000p
.measure tran M_n123 FIND V(n123) AT=2198.000000p
.measure tran C_n123 FIND V(n123) AT=1696.000000p
.measure tran M_n124 FIND V(n124) AT=2198.000000p
.measure tran C_n124 FIND V(n124) AT=1696.000000p
.measure tran M_n125 FIND V(n125) AT=2198.000000p
.measure tran C_n125 FIND V(n125) AT=1696.000000p
.measure tran M_n126 FIND V(n126) AT=2198.000000p
.measure tran C_n126 FIND V(n126) AT=1696.000000p
.measure tran M_n127 FIND V(n127) AT=2198.000000p
.measure tran C_n127 FIND V(n127) AT=1696.000000p
.print tran V(vdd) I(VDD) V(xqvdd) V(n0) V(n1) V(n2) V(n3) V(n4) V(n5) V(n6) V(n7) V(n8) V(n9) V(n10) V(n11) V(n12) V(n13) V(n14) V(n15) V(n16) V(n17) V(n18) V(n19) V(n20) V(n21) V(n22) V(n23) V(n24) V(n25) V(n26) V(n27) V(n28) V(n29) V(n30) V(n31) V(n32) V(n33) V(n34) V(n35) V(n36) V(n37) V(n38) V(n39) V(n40) V(n41) V(n42) V(n43) V(n44) V(n45) V(n46) V(n47) V(n48) V(n49) V(n50) V(n51) V(n52) V(n53) V(n54) V(n55) V(n56) V(n57) V(n58) V(n59) V(n60) V(n61) V(n62) V(n63) V(n64) V(n65) V(n66) V(n67) V(n68) V(n69) V(n70) V(n71) V(n72) V(n73) V(n74) V(n75) V(n76) V(n77) V(n78) V(n79) V(n80) V(n81) V(n82) V(n83) V(n84) V(n85) V(n86) V(n87) V(n88) V(n89) V(n90) V(n91) V(n92) V(n93) V(n94) V(n95) V(n96) V(n97) V(n98) V(n99) V(n100) V(n101) V(n102) V(n103) V(n104) V(n105) V(n106) V(n107) V(n108) V(n109) V(n110) V(n111) V(n112) V(n113) V(n114) V(n115) V(n116) V(n117) V(n118) V(n119) V(n120) V(n121) V(n122) V(n123) V(n124) V(n125) V(n126) V(n127)
.end
