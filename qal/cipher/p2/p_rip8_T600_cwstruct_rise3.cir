.hdl "/usr/local/share/xyce/verilog-a/psp103/psp103.va"
.include "/usr/local/src/kestrel/sim/models/sg13g2_psp103_tt.lib"
.include "/usr/local/src/stat-sim/qal/sg13lv_compat.sp"
.OPTIONS TIMEINT METHOD=GEAR RELTOL=1e-6 ABSTOL=1e-15 CHGTOL=1e-17
.include "/usr/local/src/IHP-Open-PDK/ihp-sg13g2/libs.ref/sg13g2_stdcell/spice/sg13g2_stdcell.spice"
VHI vhi 0 1.5
VMG1 gn1 0 0
VS_s_a0 s_a0 0 1.65
VS_s_a1 s_a1 0 1.65
VS_s_a2 s_a2 0 1.65
VS_s_a3 s_a3 0 1.65
VS_s_a4 s_a4 0 1.65
VS_s_a5 s_a5 0 1.65
VS_s_a6 s_a6 0 0
VS_s_a7 s_a7 0 0
VS_s_b0 s_b0 0 1.65
VS_s_b1 s_b1 0 0
VS_s_b2 s_b2 0 0
VS_s_b3 s_b3 0 0
VS_s_b4 s_b4 0 0
VS_s_b5 s_b5 0 0
VS_s_b6 s_b6 0 1.65
VS_s_b7 s_b7 0 1.65
XXOR21_0 o1_0 s_a0 s_b0 rail1 gn1 sg13g2_xor2_1
CL1_0 o1_0 gn1 2f
CW1_0 o1_0 gn1 0.360000f
XAND21_1 o1_1 s_a0 s_b0 rail1 gn1 sg13g2_and2_1
CL1_1 o1_1 gn1 2f
CW1_1 o1_1 gn1 0.360000f
XXOR21_2 o1_2 s_a1 s_b1 rail1 gn1 sg13g2_xor2_1
CL1_2 o1_2 gn1 2f
CW1_2 o1_2 gn1 0.360000f
XAND21_3 o1_3 s_a1 s_b1 rail1 gn1 sg13g2_and2_1
CL1_3 o1_3 gn1 2f
CW1_3 o1_3 gn1 0.360000f
XXOR21_4 o1_4 s_a2 s_b2 rail1 gn1 sg13g2_xor2_1
CL1_4 o1_4 gn1 2f
CW1_4 o1_4 gn1 0.360000f
XAND21_5 o1_5 s_a2 s_b2 rail1 gn1 sg13g2_and2_1
CL1_5 o1_5 gn1 2f
CW1_5 o1_5 gn1 0.360000f
XXOR21_6 o1_6 s_a3 s_b3 rail1 gn1 sg13g2_xor2_1
CL1_6 o1_6 gn1 2f
CW1_6 o1_6 gn1 0.360000f
XAND21_7 o1_7 s_a3 s_b3 rail1 gn1 sg13g2_and2_1
CL1_7 o1_7 gn1 2f
CW1_7 o1_7 gn1 0.360000f
XXOR21_8 o1_8 s_a4 s_b4 rail1 gn1 sg13g2_xor2_1
CL1_8 o1_8 gn1 2f
CW1_8 o1_8 gn1 0.360000f
XAND21_9 o1_9 s_a4 s_b4 rail1 gn1 sg13g2_and2_1
CL1_9 o1_9 gn1 2f
CW1_9 o1_9 gn1 0.360000f
XXOR21_10 o1_10 s_a5 s_b5 rail1 gn1 sg13g2_xor2_1
CL1_10 o1_10 gn1 2f
CW1_10 o1_10 gn1 0.360000f
XAND21_11 o1_11 s_a5 s_b5 rail1 gn1 sg13g2_and2_1
CL1_11 o1_11 gn1 2f
CW1_11 o1_11 gn1 0.360000f
XXOR21_12 o1_12 s_a6 s_b6 rail1 gn1 sg13g2_xor2_1
CL1_12 o1_12 gn1 2f
CW1_12 o1_12 gn1 0.360000f
XAND21_13 o1_13 s_a6 s_b6 rail1 gn1 sg13g2_and2_1
CL1_13 o1_13 gn1 2f
CW1_13 o1_13 gn1 0.360000f
XXOR21_14 o1_14 s_a7 s_b7 rail1 gn1 sg13g2_xor2_1
CL1_14 o1_14 gn1 2f
CW1_14 o1_14 gn1 0.360000f
VMG2 gn2 0 0
XINV2_0 o2_0 o1_0 rail2 gn2 sg13g2_inv_1
CL2_0 o2_0 gn2 2f
CW2_0 o2_0 gn2 0.360000f
XINV2_1 o2_1 o1_3 rail2 gn2 sg13g2_inv_1
CL2_1 o2_1 gn2 2f
CW2_1 o2_1 gn2 0.360000f
XINV2_2 o2_2 o1_2 rail2 gn2 sg13g2_inv_1
CL2_2 o2_2 gn2 2f
CW2_2 o2_2 gn2 0.360000f
XINV2_3 o2_3 o1_2 rail2 gn2 sg13g2_inv_1
CL2_3 o2_3 gn2 2f
CW2_3 o2_3 gn2 0.360000f
XINV2_4 o2_4 o1_5 rail2 gn2 sg13g2_inv_1
CL2_4 o2_4 gn2 2f
CW2_4 o2_4 gn2 0.360000f
XINV2_5 o2_5 o1_4 rail2 gn2 sg13g2_inv_1
CL2_5 o2_5 gn2 2f
CW2_5 o2_5 gn2 0.360000f
XINV2_6 o2_6 o1_4 rail2 gn2 sg13g2_inv_1
CL2_6 o2_6 gn2 2f
CW2_6 o2_6 gn2 0.360000f
XINV2_7 o2_7 o1_7 rail2 gn2 sg13g2_inv_1
CL2_7 o2_7 gn2 2f
CW2_7 o2_7 gn2 0.360000f
XINV2_8 o2_8 o1_6 rail2 gn2 sg13g2_inv_1
CL2_8 o2_8 gn2 2f
CW2_8 o2_8 gn2 0.360000f
XINV2_9 o2_9 o1_6 rail2 gn2 sg13g2_inv_1
CL2_9 o2_9 gn2 2f
CW2_9 o2_9 gn2 0.360000f
XINV2_10 o2_10 o1_9 rail2 gn2 sg13g2_inv_1
CL2_10 o2_10 gn2 2f
CW2_10 o2_10 gn2 0.360000f
XINV2_11 o2_11 o1_8 rail2 gn2 sg13g2_inv_1
CL2_11 o2_11 gn2 2f
CW2_11 o2_11 gn2 0.360000f
XINV2_12 o2_12 o1_8 rail2 gn2 sg13g2_inv_1
CL2_12 o2_12 gn2 2f
CW2_12 o2_12 gn2 0.360000f
XINV2_13 o2_13 o1_11 rail2 gn2 sg13g2_inv_1
CL2_13 o2_13 gn2 2f
CW2_13 o2_13 gn2 0.360000f
XINV2_14 o2_14 o1_10 rail2 gn2 sg13g2_inv_1
CL2_14 o2_14 gn2 2f
CW2_14 o2_14 gn2 0.360000f
XINV2_15 o2_15 o1_10 rail2 gn2 sg13g2_inv_1
CL2_15 o2_15 gn2 2f
CW2_15 o2_15 gn2 0.360000f
XINV2_16 o2_16 o1_13 rail2 gn2 sg13g2_inv_1
CL2_16 o2_16 gn2 2f
CW2_16 o2_16 gn2 0.360000f
XINV2_17 o2_17 o1_12 rail2 gn2 sg13g2_inv_1
CL2_17 o2_17 gn2 2f
CW2_17 o2_17 gn2 0.360000f
XINV2_18 o2_18 o1_12 rail2 gn2 sg13g2_inv_1
CL2_18 o2_18 gn2 2f
CW2_18 o2_18 gn2 0.360000f
XINV2_19 o2_19 o1_14 rail2 gn2 sg13g2_inv_1
CL2_19 o2_19 gn2 2f
CW2_19 o2_19 gn2 0.360000f
XINV2_20 o2_20 o1_1 rail2 gn2 sg13g2_inv_1
CL2_20 o2_20 gn2 2f
CW2_20 o2_20 gn2 0.360000f
VMG3 gn3 0 0
XINV3_0 o3_0 o2_0 rail3 gn3 sg13g2_inv_1
CL3_0 o3_0 gn3 2f
CW3_0 o3_0 gn3 0.360000f
XINV3_1 o3_1 o2_3 rail3 gn3 sg13g2_inv_1
CL3_1 o3_1 gn3 2f
CW3_1 o3_1 gn3 0.360000f
XINV3_2 o3_2 o2_4 rail3 gn3 sg13g2_inv_1
CL3_2 o3_2 gn3 2f
CW3_2 o3_2 gn3 0.360000f
XINV3_3 o3_3 o2_5 rail3 gn3 sg13g2_inv_1
CL3_3 o3_3 gn3 2f
CW3_3 o3_3 gn3 0.360000f
XINV3_4 o3_4 o2_6 rail3 gn3 sg13g2_inv_1
CL3_4 o3_4 gn3 2f
CW3_4 o3_4 gn3 0.360000f
XINV3_5 o3_5 o2_7 rail3 gn3 sg13g2_inv_1
CL3_5 o3_5 gn3 2f
CW3_5 o3_5 gn3 0.360000f
XINV3_6 o3_6 o2_8 rail3 gn3 sg13g2_inv_1
CL3_6 o3_6 gn3 2f
CW3_6 o3_6 gn3 0.360000f
XINV3_7 o3_7 o2_9 rail3 gn3 sg13g2_inv_1
CL3_7 o3_7 gn3 2f
CW3_7 o3_7 gn3 0.360000f
XINV3_8 o3_8 o2_10 rail3 gn3 sg13g2_inv_1
CL3_8 o3_8 gn3 2f
CW3_8 o3_8 gn3 0.360000f
XINV3_9 o3_9 o2_11 rail3 gn3 sg13g2_inv_1
CL3_9 o3_9 gn3 2f
CW3_9 o3_9 gn3 0.360000f
XINV3_10 o3_10 o2_12 rail3 gn3 sg13g2_inv_1
CL3_10 o3_10 gn3 2f
CW3_10 o3_10 gn3 0.360000f
XINV3_11 o3_11 o2_13 rail3 gn3 sg13g2_inv_1
CL3_11 o3_11 gn3 2f
CW3_11 o3_11 gn3 0.360000f
XINV3_12 o3_12 o2_14 rail3 gn3 sg13g2_inv_1
CL3_12 o3_12 gn3 2f
CW3_12 o3_12 gn3 0.360000f
XINV3_13 o3_13 o2_15 rail3 gn3 sg13g2_inv_1
CL3_13 o3_13 gn3 2f
CW3_13 o3_13 gn3 0.360000f
XINV3_14 o3_14 o2_16 rail3 gn3 sg13g2_inv_1
CL3_14 o3_14 gn3 2f
CW3_14 o3_14 gn3 0.360000f
XINV3_15 o3_15 o2_17 rail3 gn3 sg13g2_inv_1
CL3_15 o3_15 gn3 2f
CW3_15 o3_15 gn3 0.360000f
XINV3_16 o3_16 o2_18 rail3 gn3 sg13g2_inv_1
CL3_16 o3_16 gn3 2f
CW3_16 o3_16 gn3 0.360000f
XINV3_17 o3_17 o2_19 rail3 gn3 sg13g2_inv_1
CL3_17 o3_17 gn3 2f
CW3_17 o3_17 gn3 0.360000f
XINV3_18 o3_18 o2_20 rail3 gn3 sg13g2_inv_1
CL3_18 o3_18 gn3 2f
CW3_18 o3_18 gn3 0.360000f
XO21AI3_19 o3_19 o2_2 o2_20 o2_1 rail3 gn3 sg13g2_o21ai_1
CL3_19 o3_19 gn3 2f
CW3_19 o3_19 gn3 0.360000f
VMG4 gn4 0 0
XINV4_0 o4_0 o3_0 rail4 gn4 sg13g2_inv_1
CL4_0 o4_0 gn4 2f
CW4_0 o4_0 gn4 0.360000f
XINV4_1 o4_1 o3_1 rail4 gn4 sg13g2_inv_1
CL4_1 o4_1 gn4 2f
CW4_1 o4_1 gn4 0.360000f
XINV4_2 o4_2 o3_4 rail4 gn4 sg13g2_inv_1
CL4_2 o4_2 gn4 2f
CW4_2 o4_2 gn4 0.360000f
XINV4_3 o4_3 o3_5 rail4 gn4 sg13g2_inv_1
CL4_3 o4_3 gn4 2f
CW4_3 o4_3 gn4 0.360000f
XINV4_4 o4_4 o3_6 rail4 gn4 sg13g2_inv_1
CL4_4 o4_4 gn4 2f
CW4_4 o4_4 gn4 0.360000f
XINV4_5 o4_5 o3_7 rail4 gn4 sg13g2_inv_1
CL4_5 o4_5 gn4 2f
CW4_5 o4_5 gn4 0.360000f
XINV4_6 o4_6 o3_8 rail4 gn4 sg13g2_inv_1
CL4_6 o4_6 gn4 2f
CW4_6 o4_6 gn4 0.360000f
XINV4_7 o4_7 o3_9 rail4 gn4 sg13g2_inv_1
CL4_7 o4_7 gn4 2f
CW4_7 o4_7 gn4 0.360000f
XINV4_8 o4_8 o3_10 rail4 gn4 sg13g2_inv_1
CL4_8 o4_8 gn4 2f
CW4_8 o4_8 gn4 0.360000f
XINV4_9 o4_9 o3_11 rail4 gn4 sg13g2_inv_1
CL4_9 o4_9 gn4 2f
CW4_9 o4_9 gn4 0.360000f
XINV4_10 o4_10 o3_12 rail4 gn4 sg13g2_inv_1
CL4_10 o4_10 gn4 2f
CW4_10 o4_10 gn4 0.360000f
XINV4_11 o4_11 o3_13 rail4 gn4 sg13g2_inv_1
CL4_11 o4_11 gn4 2f
CW4_11 o4_11 gn4 0.360000f
XINV4_12 o4_12 o3_14 rail4 gn4 sg13g2_inv_1
CL4_12 o4_12 gn4 2f
CW4_12 o4_12 gn4 0.360000f
XINV4_13 o4_13 o3_15 rail4 gn4 sg13g2_inv_1
CL4_13 o4_13 gn4 2f
CW4_13 o4_13 gn4 0.360000f
XINV4_14 o4_14 o3_16 rail4 gn4 sg13g2_inv_1
CL4_14 o4_14 gn4 2f
CW4_14 o4_14 gn4 0.360000f
XINV4_15 o4_15 o3_17 rail4 gn4 sg13g2_inv_1
CL4_15 o4_15 gn4 2f
CW4_15 o4_15 gn4 0.360000f
XINV4_16 o4_16 o3_18 rail4 gn4 sg13g2_inv_1
CL4_16 o4_16 gn4 2f
CW4_16 o4_16 gn4 0.360000f
XINV4_17 o4_17 o3_19 rail4 gn4 sg13g2_inv_1
CL4_17 o4_17 gn4 2f
CW4_17 o4_17 gn4 0.360000f
XA21OI4_18 o4_18 o3_3 o3_19 o3_2 rail4 gn4 sg13g2_a21oi_1
CL4_18 o4_18 gn4 2f
CW4_18 o4_18 gn4 0.360000f
VMG5 gn5 0 0
XINV5_0 o5_0 o4_0 rail5 gn5 sg13g2_inv_1
CL5_0 o5_0 gn5 2f
CW5_0 o5_0 gn5 0.360000f
XINV5_1 o5_1 o4_1 rail5 gn5 sg13g2_inv_1
CL5_1 o5_1 gn5 2f
CW5_1 o5_1 gn5 0.360000f
XINV5_2 o5_2 o4_2 rail5 gn5 sg13g2_inv_1
CL5_2 o5_2 gn5 2f
CW5_2 o5_2 gn5 0.360000f
XINV5_3 o5_3 o4_5 rail5 gn5 sg13g2_inv_1
CL5_3 o5_3 gn5 2f
CW5_3 o5_3 gn5 0.360000f
XINV5_4 o5_4 o4_6 rail5 gn5 sg13g2_inv_1
CL5_4 o5_4 gn5 2f
CW5_4 o5_4 gn5 0.360000f
XINV5_5 o5_5 o4_7 rail5 gn5 sg13g2_inv_1
CL5_5 o5_5 gn5 2f
CW5_5 o5_5 gn5 0.360000f
XINV5_6 o5_6 o4_8 rail5 gn5 sg13g2_inv_1
CL5_6 o5_6 gn5 2f
CW5_6 o5_6 gn5 0.360000f
XINV5_7 o5_7 o4_9 rail5 gn5 sg13g2_inv_1
CL5_7 o5_7 gn5 2f
CW5_7 o5_7 gn5 0.360000f
XINV5_8 o5_8 o4_10 rail5 gn5 sg13g2_inv_1
CL5_8 o5_8 gn5 2f
CW5_8 o5_8 gn5 0.360000f
XINV5_9 o5_9 o4_11 rail5 gn5 sg13g2_inv_1
CL5_9 o5_9 gn5 2f
CW5_9 o5_9 gn5 0.360000f
XINV5_10 o5_10 o4_12 rail5 gn5 sg13g2_inv_1
CL5_10 o5_10 gn5 2f
CW5_10 o5_10 gn5 0.360000f
XINV5_11 o5_11 o4_13 rail5 gn5 sg13g2_inv_1
CL5_11 o5_11 gn5 2f
CW5_11 o5_11 gn5 0.360000f
XINV5_12 o5_12 o4_14 rail5 gn5 sg13g2_inv_1
CL5_12 o5_12 gn5 2f
CW5_12 o5_12 gn5 0.360000f
XINV5_13 o5_13 o4_15 rail5 gn5 sg13g2_inv_1
CL5_13 o5_13 gn5 2f
CW5_13 o5_13 gn5 0.360000f
XINV5_14 o5_14 o4_16 rail5 gn5 sg13g2_inv_1
CL5_14 o5_14 gn5 2f
CW5_14 o5_14 gn5 0.360000f
XINV5_15 o5_15 o4_17 rail5 gn5 sg13g2_inv_1
CL5_15 o5_15 gn5 2f
CW5_15 o5_15 gn5 0.360000f
XINV5_16 o5_16 o4_18 rail5 gn5 sg13g2_inv_1
CL5_16 o5_16 gn5 2f
CW5_16 o5_16 gn5 0.360000f
XO21AI5_17 o5_17 o4_4 o4_18 o4_3 rail5 gn5 sg13g2_o21ai_1
CL5_17 o5_17 gn5 2f
CW5_17 o5_17 gn5 0.360000f
VMG6 gn6 0 0
XINV6_0 o6_0 o5_0 rail6 gn6 sg13g2_inv_1
CL6_0 o6_0 gn6 2f
CW6_0 o6_0 gn6 0.360000f
XINV6_1 o6_1 o5_1 rail6 gn6 sg13g2_inv_1
CL6_1 o6_1 gn6 2f
CW6_1 o6_1 gn6 0.360000f
XINV6_2 o6_2 o5_2 rail6 gn6 sg13g2_inv_1
CL6_2 o6_2 gn6 2f
CW6_2 o6_2 gn6 0.360000f
XINV6_3 o6_3 o5_3 rail6 gn6 sg13g2_inv_1
CL6_3 o6_3 gn6 2f
CW6_3 o6_3 gn6 0.360000f
XINV6_4 o6_4 o5_6 rail6 gn6 sg13g2_inv_1
CL6_4 o6_4 gn6 2f
CW6_4 o6_4 gn6 0.360000f
XINV6_5 o6_5 o5_7 rail6 gn6 sg13g2_inv_1
CL6_5 o6_5 gn6 2f
CW6_5 o6_5 gn6 0.360000f
XINV6_6 o6_6 o5_8 rail6 gn6 sg13g2_inv_1
CL6_6 o6_6 gn6 2f
CW6_6 o6_6 gn6 0.360000f
XINV6_7 o6_7 o5_9 rail6 gn6 sg13g2_inv_1
CL6_7 o6_7 gn6 2f
CW6_7 o6_7 gn6 0.360000f
XINV6_8 o6_8 o5_10 rail6 gn6 sg13g2_inv_1
CL6_8 o6_8 gn6 2f
CW6_8 o6_8 gn6 0.360000f
XINV6_9 o6_9 o5_11 rail6 gn6 sg13g2_inv_1
CL6_9 o6_9 gn6 2f
CW6_9 o6_9 gn6 0.360000f
XINV6_10 o6_10 o5_12 rail6 gn6 sg13g2_inv_1
CL6_10 o6_10 gn6 2f
CW6_10 o6_10 gn6 0.360000f
XINV6_11 o6_11 o5_13 rail6 gn6 sg13g2_inv_1
CL6_11 o6_11 gn6 2f
CW6_11 o6_11 gn6 0.360000f
XINV6_12 o6_12 o5_14 rail6 gn6 sg13g2_inv_1
CL6_12 o6_12 gn6 2f
CW6_12 o6_12 gn6 0.360000f
XINV6_13 o6_13 o5_15 rail6 gn6 sg13g2_inv_1
CL6_13 o6_13 gn6 2f
CW6_13 o6_13 gn6 0.360000f
XINV6_14 o6_14 o5_16 rail6 gn6 sg13g2_inv_1
CL6_14 o6_14 gn6 2f
CW6_14 o6_14 gn6 0.360000f
XINV6_15 o6_15 o5_17 rail6 gn6 sg13g2_inv_1
CL6_15 o6_15 gn6 2f
CW6_15 o6_15 gn6 0.360000f
XA21OI6_16 o6_16 o5_5 o5_17 o5_4 rail6 gn6 sg13g2_a21oi_1
CL6_16 o6_16 gn6 2f
CW6_16 o6_16 gn6 0.360000f
VMG7 gn7 0 0
XINV7_0 o7_0 o6_0 rail7 gn7 sg13g2_inv_1
CL7_0 o7_0 gn7 2f
CW7_0 o7_0 gn7 0.360000f
XINV7_1 o7_1 o6_1 rail7 gn7 sg13g2_inv_1
CL7_1 o7_1 gn7 2f
CW7_1 o7_1 gn7 0.360000f
XINV7_2 o7_2 o6_2 rail7 gn7 sg13g2_inv_1
CL7_2 o7_2 gn7 2f
CW7_2 o7_2 gn7 0.360000f
XINV7_3 o7_3 o6_3 rail7 gn7 sg13g2_inv_1
CL7_3 o7_3 gn7 2f
CW7_3 o7_3 gn7 0.360000f
XINV7_4 o7_4 o6_4 rail7 gn7 sg13g2_inv_1
CL7_4 o7_4 gn7 2f
CW7_4 o7_4 gn7 0.360000f
XINV7_5 o7_5 o6_7 rail7 gn7 sg13g2_inv_1
CL7_5 o7_5 gn7 2f
CW7_5 o7_5 gn7 0.360000f
XINV7_6 o7_6 o6_8 rail7 gn7 sg13g2_inv_1
CL7_6 o7_6 gn7 2f
CW7_6 o7_6 gn7 0.360000f
XINV7_7 o7_7 o6_9 rail7 gn7 sg13g2_inv_1
CL7_7 o7_7 gn7 2f
CW7_7 o7_7 gn7 0.360000f
XINV7_8 o7_8 o6_10 rail7 gn7 sg13g2_inv_1
CL7_8 o7_8 gn7 2f
CW7_8 o7_8 gn7 0.360000f
XINV7_9 o7_9 o6_11 rail7 gn7 sg13g2_inv_1
CL7_9 o7_9 gn7 2f
CW7_9 o7_9 gn7 0.360000f
XINV7_10 o7_10 o6_12 rail7 gn7 sg13g2_inv_1
CL7_10 o7_10 gn7 2f
CW7_10 o7_10 gn7 0.360000f
XINV7_11 o7_11 o6_13 rail7 gn7 sg13g2_inv_1
CL7_11 o7_11 gn7 2f
CW7_11 o7_11 gn7 0.360000f
XINV7_12 o7_12 o6_14 rail7 gn7 sg13g2_inv_1
CL7_12 o7_12 gn7 2f
CW7_12 o7_12 gn7 0.360000f
XINV7_13 o7_13 o6_15 rail7 gn7 sg13g2_inv_1
CL7_13 o7_13 gn7 2f
CW7_13 o7_13 gn7 0.360000f
XINV7_14 o7_14 o6_16 rail7 gn7 sg13g2_inv_1
CL7_14 o7_14 gn7 2f
CW7_14 o7_14 gn7 0.360000f
XO21AI7_15 o7_15 o6_6 o6_16 o6_5 rail7 gn7 sg13g2_o21ai_1
CL7_15 o7_15 gn7 2f
CW7_15 o7_15 gn7 0.360000f
VMG8 gn8 0 0
XINV8_0 o8_0 o7_0 rail8 gn8 sg13g2_inv_1
CL8_0 o8_0 gn8 2f
CW8_0 o8_0 gn8 0.360000f
XINV8_1 o8_1 o7_1 rail8 gn8 sg13g2_inv_1
CL8_1 o8_1 gn8 2f
CW8_1 o8_1 gn8 0.360000f
XINV8_2 o8_2 o7_2 rail8 gn8 sg13g2_inv_1
CL8_2 o8_2 gn8 2f
CW8_2 o8_2 gn8 0.360000f
XINV8_3 o8_3 o7_3 rail8 gn8 sg13g2_inv_1
CL8_3 o8_3 gn8 2f
CW8_3 o8_3 gn8 0.360000f
XINV8_4 o8_4 o7_4 rail8 gn8 sg13g2_inv_1
CL8_4 o8_4 gn8 2f
CW8_4 o8_4 gn8 0.360000f
XINV8_5 o8_5 o7_5 rail8 gn8 sg13g2_inv_1
CL8_5 o8_5 gn8 2f
CW8_5 o8_5 gn8 0.360000f
XINV8_6 o8_6 o7_8 rail8 gn8 sg13g2_inv_1
CL8_6 o8_6 gn8 2f
CW8_6 o8_6 gn8 0.360000f
XINV8_7 o8_7 o7_9 rail8 gn8 sg13g2_inv_1
CL8_7 o8_7 gn8 2f
CW8_7 o8_7 gn8 0.360000f
XINV8_8 o8_8 o7_10 rail8 gn8 sg13g2_inv_1
CL8_8 o8_8 gn8 2f
CW8_8 o8_8 gn8 0.360000f
XINV8_9 o8_9 o7_11 rail8 gn8 sg13g2_inv_1
CL8_9 o8_9 gn8 2f
CW8_9 o8_9 gn8 0.360000f
XINV8_10 o8_10 o7_12 rail8 gn8 sg13g2_inv_1
CL8_10 o8_10 gn8 2f
CW8_10 o8_10 gn8 0.360000f
XINV8_11 o8_11 o7_13 rail8 gn8 sg13g2_inv_1
CL8_11 o8_11 gn8 2f
CW8_11 o8_11 gn8 0.360000f
XINV8_12 o8_12 o7_14 rail8 gn8 sg13g2_inv_1
CL8_12 o8_12 gn8 2f
CW8_12 o8_12 gn8 0.360000f
XINV8_13 o8_13 o7_15 rail8 gn8 sg13g2_inv_1
CL8_13 o8_13 gn8 2f
CW8_13 o8_13 gn8 0.360000f
XA21OI8_14 o8_14 o7_7 o7_15 o7_6 rail8 gn8 sg13g2_a21oi_1
CL8_14 o8_14 gn8 2f
CW8_14 o8_14 gn8 0.360000f
VMG9 gn9 0 0
XINV9_0 o9_0 o8_0 rail9 gn9 sg13g2_inv_1
CL9_0 o9_0 gn9 2f
CW9_0 o9_0 gn9 0.360000f
XINV9_1 o9_1 o8_1 rail9 gn9 sg13g2_inv_1
CL9_1 o9_1 gn9 2f
CW9_1 o9_1 gn9 0.360000f
XINV9_2 o9_2 o8_2 rail9 gn9 sg13g2_inv_1
CL9_2 o9_2 gn9 2f
CW9_2 o9_2 gn9 0.360000f
XINV9_3 o9_3 o8_3 rail9 gn9 sg13g2_inv_1
CL9_3 o9_3 gn9 2f
CW9_3 o9_3 gn9 0.360000f
XINV9_4 o9_4 o8_4 rail9 gn9 sg13g2_inv_1
CL9_4 o9_4 gn9 2f
CW9_4 o9_4 gn9 0.360000f
XINV9_5 o9_5 o8_5 rail9 gn9 sg13g2_inv_1
CL9_5 o9_5 gn9 2f
CW9_5 o9_5 gn9 0.360000f
XINV9_6 o9_6 o8_6 rail9 gn9 sg13g2_inv_1
CL9_6 o9_6 gn9 2f
CW9_6 o9_6 gn9 0.360000f
XINV9_7 o9_7 o8_7 rail9 gn9 sg13g2_inv_1
CL9_7 o9_7 gn9 2f
CW9_7 o9_7 gn9 0.360000f
XINV9_8 o9_8 o8_8 rail9 gn9 sg13g2_inv_1
CL9_8 o9_8 gn9 2f
CW9_8 o9_8 gn9 0.360000f
XINV9_9 o9_9 o8_9 rail9 gn9 sg13g2_inv_1
CL9_9 o9_9 gn9 2f
CW9_9 o9_9 gn9 0.360000f
XINV9_10 o9_10 o8_10 rail9 gn9 sg13g2_inv_1
CL9_10 o9_10 gn9 2f
CW9_10 o9_10 gn9 0.360000f
XINV9_11 o9_11 o8_11 rail9 gn9 sg13g2_inv_1
CL9_11 o9_11 gn9 2f
CW9_11 o9_11 gn9 0.360000f
XINV9_12 o9_12 o8_12 rail9 gn9 sg13g2_inv_1
CL9_12 o9_12 gn9 2f
CW9_12 o9_12 gn9 0.360000f
XINV9_13 o9_13 o8_13 rail9 gn9 sg13g2_inv_1
CL9_13 o9_13 gn9 2f
CW9_13 o9_13 gn9 0.360000f
XINV9_14 o9_14 o8_14 rail9 gn9 sg13g2_inv_1
CL9_14 o9_14 gn9 2f
CW9_14 o9_14 gn9 0.360000f
VMG10 gn10 0 0
XINV10_0 o10_0 o9_0 rail10 gn10 sg13g2_inv_1
CL10_0 o10_0 gn10 2f
CW10_0 o10_0 gn10 0.360000f
XXOR210_1 o10_1 o9_1 o9_8 rail10 gn10 sg13g2_xor2_1
CL10_1 o10_1 gn10 2f
CW10_1 o10_1 gn10 0.360000f
XXOR210_2 o10_2 o9_2 o9_9 rail10 gn10 sg13g2_xor2_1
CL10_2 o10_2 gn10 2f
CW10_2 o10_2 gn10 0.360000f
XXOR210_3 o10_3 o9_3 o9_10 rail10 gn10 sg13g2_xor2_1
CL10_3 o10_3 gn10 2f
CW10_3 o10_3 gn10 0.360000f
XXOR210_4 o10_4 o9_4 o9_11 rail10 gn10 sg13g2_xor2_1
CL10_4 o10_4 gn10 2f
CW10_4 o10_4 gn10 0.360000f
XXOR210_5 o10_5 o9_5 o9_12 rail10 gn10 sg13g2_xor2_1
CL10_5 o10_5 gn10 2f
CW10_5 o10_5 gn10 0.360000f
XXOR210_6 o10_6 o9_6 o9_13 rail10 gn10 sg13g2_xor2_1
CL10_6 o10_6 gn10 2f
CW10_6 o10_6 gn10 0.360000f
XXOR210_7 o10_7 o9_7 o9_14 rail10 gn10 sg13g2_xor2_1
CL10_7 o10_7 gn10 2f
CW10_7 o10_7 gn10 0.360000f
CT1 tnk1 0 1877.4f
L1 tnk1 mid1 15n
R1 mid1 sw1 10
XSWN1 sw1 gt1 rail1 0 sg13_lv_nmos w=20u l=0.13u
XSWP1 sw1 gtp1 rail1 vhi sg13_lv_pmos w=40u l=0.13u
XPK1 sw1 pk1 tnk1 tnk1 sg13_lv_nmos w=4u l=0.13u
CT2 tnk2 0 1020.05f
L2 tnk2 mid2 15n
R2 mid2 sw2 10
XSWN2 sw2 gt2 rail2 0 sg13_lv_nmos w=20u l=0.13u
XSWP2 sw2 gtp2 rail2 vhi sg13_lv_pmos w=40u l=0.13u
XPK2 sw2 pk2 tnk2 tnk2 sg13_lv_nmos w=4u l=0.13u
CT3 tnk3 0 1021.42f
L3 tnk3 mid3 15n
R3 mid3 sw3 10
XSWN3 sw3 gt3 rail3 0 sg13_lv_nmos w=20u l=0.13u
XSWP3 sw3 gtp3 rail3 vhi sg13_lv_pmos w=40u l=0.13u
XPK3 sw3 pk3 tnk3 tnk3 sg13_lv_nmos w=4u l=0.13u
CT4 tnk4 0 972.849f
L4 tnk4 mid4 15n
R4 mid4 sw4 10
XSWN4 sw4 gt4 rail4 0 sg13_lv_nmos w=14.1421u l=0.13u
XSWP4 sw4 gtp4 rail4 vhi sg13_lv_pmos w=28.2843u l=0.13u
XPK4 sw4 pk4 tnk4 tnk4 sg13_lv_nmos w=2.82843u l=0.13u
CT5 tnk5 0 924.275f
L5 tnk5 mid5 15n
R5 mid5 sw5 10
XSWN5 sw5 gt5 rail5 0 sg13_lv_nmos w=14.1421u l=0.13u
XSWP5 sw5 gtp5 rail5 vhi sg13_lv_pmos w=28.2843u l=0.13u
XPK5 sw5 pk5 tnk5 tnk5 sg13_lv_nmos w=2.82843u l=0.13u
CT6 tnk6 0 875.701f
L6 tnk6 mid6 15n
R6 mid6 sw6 10
XSWN6 sw6 gt6 rail6 0 sg13_lv_nmos w=14.1421u l=0.13u
XSWP6 sw6 gtp6 rail6 vhi sg13_lv_pmos w=28.2843u l=0.13u
XPK6 sw6 pk6 tnk6 tnk6 sg13_lv_nmos w=2.82843u l=0.13u
CT7 tnk7 0 827.128f
L7 tnk7 mid7 15n
R7 mid7 sw7 10
XSWN7 sw7 gt7 rail7 0 sg13_lv_nmos w=14.1421u l=0.13u
XSWP7 sw7 gtp7 rail7 vhi sg13_lv_pmos w=28.2843u l=0.13u
XPK7 sw7 pk7 tnk7 tnk7 sg13_lv_nmos w=2.82843u l=0.13u
CT8 tnk8 0 778.554f
L8 tnk8 mid8 15n
R8 mid8 sw8 10
XSWN8 sw8 gt8 rail8 0 sg13_lv_nmos w=14.1421u l=0.13u
XSWP8 sw8 gtp8 rail8 vhi sg13_lv_pmos w=28.2843u l=0.13u
XPK8 sw8 pk8 tnk8 tnk8 sg13_lv_nmos w=2.82843u l=0.13u
CT9 tnk9 0 728.606f
L9 tnk9 mid9 15n
R9 mid9 sw9 10
XSWN9 sw9 gt9 rail9 0 sg13_lv_nmos w=14.1421u l=0.13u
XSWP9 sw9 gtp9 rail9 vhi sg13_lv_pmos w=28.2843u l=0.13u
XPK9 sw9 pk9 tnk9 tnk9 sg13_lv_nmos w=2.82843u l=0.13u
CT10 tnk10 0 1087.85f
L10 tnk10 mid10 15n
R10 mid10 sw10 10
XSWN10 sw10 gt10 rail10 0 sg13_lv_nmos w=20u l=0.13u
XSWP10 sw10 gtp10 rail10 vhi sg13_lv_pmos w=40u l=0.13u
XPK10 sw10 pk10 tnk10 tnk10 sg13_lv_nmos w=4u l=0.13u
VGT1 gt1 0 PWL(0 0 198p 0 200p 1.5 414.958p 1.5 416.958p 0)
VGTP1 gtp1 0 PWL(0 1.5 198p 1.5 200p 0 414.958p 0 416.958p 1.5)
VPK1 pk1 0 PWL(0 1.5 198p 1.5 200p 0 414.958p 0 416.958p 1.5)
VGT2 gt2 0 PWL(0 0 798p 0 800p 1.5 982.502p 1.5 984.502p 0)
VGTP2 gtp2 0 PWL(0 1.5 798p 1.5 800p 0 982.502p 0 984.502p 1.5)
VPK2 pk2 0 PWL(0 1.5 798p 1.5 800p 0 982.502p 0 984.502p 1.5)
VGT3 gt3 0 PWL(0 0 1398p 0 1400p 1.5 34262p 1.5)
VGTP3 gtp3 0 PWL(0 1.5 1398p 1.5 1400p 0 34262p 0)
VPK3 pk3 0 PWL(0 1.5 1398p 1.5 1400p 0 34262p 0)
VGT4 gt4 0 0
VGTP4 gtp4 0 1.5
VPK4 pk4 0 1.5
VGT5 gt5 0 0
VGTP5 gtp5 0 1.5
VPK5 pk5 0 1.5
VGT6 gt6 0 0
VGTP6 gtp6 0 1.5
VPK6 pk6 0 1.5
VGT7 gt7 0 0
VGTP7 gtp7 0 1.5
VPK7 pk7 0 1.5
VGT8 gt8 0 0
VGTP8 gtp8 0 1.5
VPK8 pk8 0 1.5
VGT9 gt9 0 0
VGTP9 gtp9 0 1.5
VPK9 pk9 0 1.5
VGT10 gt10 0 0
VGTP10 gtp10 0 1.5
VPK10 pk10 0 1.5
.ic V(tnk1)=0.9075 V(rail1)=0 V(sw1)=0.9075 V(tnk2)=0.9075 V(rail2)=0 V(sw2)=0.9075 V(tnk3)=0.9075 V(rail3)=0 V(sw3)=0.9075 V(tnk4)=0.9075 V(rail4)=0 V(sw4)=0.9075 V(tnk5)=0.9075 V(rail5)=0 V(sw5)=0.9075 V(tnk6)=0.9075 V(rail6)=0 V(sw6)=0.9075 V(tnk7)=0.9075 V(rail7)=0 V(sw7)=0.9075 V(tnk8)=0.9075 V(rail8)=0 V(sw8)=0.9075 V(tnk9)=0.9075 V(rail9)=0 V(sw9)=0.9075 V(tnk10)=0.9075 V(rail10)=0 V(sw10)=0.9075
.tran 0.1p 1620.71p 0 0.25p
.print tran I(L1) I(L2) I(L3) I(L4) I(L5) I(L6) I(L7) I(L8) I(L9) I(L10) V(rail1) V(rail2) V(rail3) V(rail4) V(rail5) V(rail6) V(rail7) V(rail8) V(rail9) V(rail10) V(tnk1) V(tnk2) V(tnk3) V(tnk4) V(tnk5) V(tnk6) V(tnk7) V(tnk8) V(tnk9) V(tnk10)
.end
