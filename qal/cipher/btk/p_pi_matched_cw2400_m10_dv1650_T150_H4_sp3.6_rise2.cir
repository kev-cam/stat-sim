.hdl "/usr/local/share/xyce/verilog-a/psp103/psp103.va"
.include "/usr/local/src/kestrel/sim/models/sg13g2_psp103_tt.lib"
.include "/usr/local/src/stat-sim/qal/sg13lv_compat.sp"
.OPTIONS TIMEINT METHOD=GEAR RELTOL=1e-6 ABSTOL=1e-15 CHGTOL=1e-17
VHI vhi 0 1.5
VMG1 gn1 0 0
VI1_0 in1_0 0 1.65
VI1_1 in1_1 0 1.65
VI1_2 in1_2 0 1.65
VI1_3 in1_3 0 0
VI1_4 in1_4 0 1.65
VI1_5 in1_5 0 0
VI1_6 in1_6 0 0
VI1_7 in1_7 0 1.65
XP1_0 o1_0 in1_0 rail1 rail1 sg13_lv_pmos w=1.12u l=0.13u
XN1_0 o1_0 in1_0 gn1 gn1 sg13_lv_nmos w=0.74u l=0.13u
CL1_0 o1_0 gn1 2f
XP1_1 o1_1 in1_1 rail1 rail1 sg13_lv_pmos w=1.12u l=0.13u
XN1_1 o1_1 in1_1 gn1 gn1 sg13_lv_nmos w=0.74u l=0.13u
CL1_1 o1_1 gn1 2f
XP1_2 o1_2 in1_2 rail1 rail1 sg13_lv_pmos w=1.12u l=0.13u
XN1_2 o1_2 in1_2 gn1 gn1 sg13_lv_nmos w=0.74u l=0.13u
CL1_2 o1_2 gn1 2f
XP1_3 o1_3 in1_3 rail1 rail1 sg13_lv_pmos w=1.12u l=0.13u
XN1_3 o1_3 in1_3 gn1 gn1 sg13_lv_nmos w=0.74u l=0.13u
CL1_3 o1_3 gn1 2f
XP1_4 o1_4 in1_4 rail1 rail1 sg13_lv_pmos w=1.12u l=0.13u
XN1_4 o1_4 in1_4 gn1 gn1 sg13_lv_nmos w=0.74u l=0.13u
CL1_4 o1_4 gn1 2f
XP1_5 o1_5 in1_5 rail1 rail1 sg13_lv_pmos w=1.12u l=0.13u
XN1_5 o1_5 in1_5 gn1 gn1 sg13_lv_nmos w=0.74u l=0.13u
CL1_5 o1_5 gn1 2f
XP1_6 o1_6 in1_6 rail1 rail1 sg13_lv_pmos w=1.12u l=0.13u
XN1_6 o1_6 in1_6 gn1 gn1 sg13_lv_nmos w=0.74u l=0.13u
CL1_6 o1_6 gn1 2f
XP1_7 o1_7 in1_7 rail1 rail1 sg13_lv_pmos w=1.12u l=0.13u
XN1_7 o1_7 in1_7 gn1 gn1 sg13_lv_nmos w=0.74u l=0.13u
CL1_7 o1_7 gn1 2f
VMG2 gn2 0 0
XP2_0 o2_0 o1_0 rail2 rail2 sg13_lv_pmos w=1.12u l=0.13u
XN2_0 o2_0 o1_0 gn2 gn2 sg13_lv_nmos w=0.74u l=0.13u
CL2_0 o2_0 gn2 2f
XP2_1 o2_1 o1_1 rail2 rail2 sg13_lv_pmos w=1.12u l=0.13u
XN2_1 o2_1 o1_1 gn2 gn2 sg13_lv_nmos w=0.74u l=0.13u
CL2_1 o2_1 gn2 2f
XP2_2 o2_2 o1_2 rail2 rail2 sg13_lv_pmos w=1.12u l=0.13u
XN2_2 o2_2 o1_2 gn2 gn2 sg13_lv_nmos w=0.74u l=0.13u
CL2_2 o2_2 gn2 2f
XP2_3 o2_3 o1_3 rail2 rail2 sg13_lv_pmos w=1.12u l=0.13u
XN2_3 o2_3 o1_3 gn2 gn2 sg13_lv_nmos w=0.74u l=0.13u
CL2_3 o2_3 gn2 2f
XP2_4 o2_4 o1_4 rail2 rail2 sg13_lv_pmos w=1.12u l=0.13u
XN2_4 o2_4 o1_4 gn2 gn2 sg13_lv_nmos w=0.74u l=0.13u
CL2_4 o2_4 gn2 2f
XP2_5 o2_5 o1_5 rail2 rail2 sg13_lv_pmos w=1.12u l=0.13u
XN2_5 o2_5 o1_5 gn2 gn2 sg13_lv_nmos w=0.74u l=0.13u
CL2_5 o2_5 gn2 2f
XP2_6 o2_6 o1_6 rail2 rail2 sg13_lv_pmos w=1.12u l=0.13u
XN2_6 o2_6 o1_6 gn2 gn2 sg13_lv_nmos w=0.74u l=0.13u
CL2_6 o2_6 gn2 2f
XP2_7 o2_7 o1_7 rail2 rail2 sg13_lv_pmos w=1.12u l=0.13u
XN2_7 o2_7 o1_7 gn2 gn2 sg13_lv_nmos w=0.74u l=0.13u
CL2_7 o2_7 gn2 2f
VMG3 gn3 0 0
XP3_0 o3_0 o2_0 rail3 rail3 sg13_lv_pmos w=1.12u l=0.13u
XN3_0 o3_0 o2_0 gn3 gn3 sg13_lv_nmos w=0.74u l=0.13u
CL3_0 o3_0 gn3 2f
XP3_1 o3_1 o2_1 rail3 rail3 sg13_lv_pmos w=1.12u l=0.13u
XN3_1 o3_1 o2_1 gn3 gn3 sg13_lv_nmos w=0.74u l=0.13u
CL3_1 o3_1 gn3 2f
XP3_2 o3_2 o2_2 rail3 rail3 sg13_lv_pmos w=1.12u l=0.13u
XN3_2 o3_2 o2_2 gn3 gn3 sg13_lv_nmos w=0.74u l=0.13u
CL3_2 o3_2 gn3 2f
XP3_3 o3_3 o2_3 rail3 rail3 sg13_lv_pmos w=1.12u l=0.13u
XN3_3 o3_3 o2_3 gn3 gn3 sg13_lv_nmos w=0.74u l=0.13u
CL3_3 o3_3 gn3 2f
XP3_4 o3_4 o2_4 rail3 rail3 sg13_lv_pmos w=1.12u l=0.13u
XN3_4 o3_4 o2_4 gn3 gn3 sg13_lv_nmos w=0.74u l=0.13u
CL3_4 o3_4 gn3 2f
XP3_5 o3_5 o2_5 rail3 rail3 sg13_lv_pmos w=1.12u l=0.13u
XN3_5 o3_5 o2_5 gn3 gn3 sg13_lv_nmos w=0.74u l=0.13u
CL3_5 o3_5 gn3 2f
XP3_6 o3_6 o2_6 rail3 rail3 sg13_lv_pmos w=1.12u l=0.13u
XN3_6 o3_6 o2_6 gn3 gn3 sg13_lv_nmos w=0.74u l=0.13u
CL3_6 o3_6 gn3 2f
XP3_7 o3_7 o2_7 rail3 rail3 sg13_lv_pmos w=1.12u l=0.13u
XN3_7 o3_7 o2_7 gn3 gn3 sg13_lv_nmos w=0.74u l=0.13u
CL3_7 o3_7 gn3 2f
VMG4 gn4 0 0
XP4_0 o4_0 o3_0 rail4 rail4 sg13_lv_pmos w=1.12u l=0.13u
XN4_0 o4_0 o3_0 gn4 gn4 sg13_lv_nmos w=0.74u l=0.13u
CL4_0 o4_0 gn4 2f
XP4_1 o4_1 o3_1 rail4 rail4 sg13_lv_pmos w=1.12u l=0.13u
XN4_1 o4_1 o3_1 gn4 gn4 sg13_lv_nmos w=0.74u l=0.13u
CL4_1 o4_1 gn4 2f
XP4_2 o4_2 o3_2 rail4 rail4 sg13_lv_pmos w=1.12u l=0.13u
XN4_2 o4_2 o3_2 gn4 gn4 sg13_lv_nmos w=0.74u l=0.13u
CL4_2 o4_2 gn4 2f
XP4_3 o4_3 o3_3 rail4 rail4 sg13_lv_pmos w=1.12u l=0.13u
XN4_3 o4_3 o3_3 gn4 gn4 sg13_lv_nmos w=0.74u l=0.13u
CL4_3 o4_3 gn4 2f
XP4_4 o4_4 o3_4 rail4 rail4 sg13_lv_pmos w=1.12u l=0.13u
XN4_4 o4_4 o3_4 gn4 gn4 sg13_lv_nmos w=0.74u l=0.13u
CL4_4 o4_4 gn4 2f
XP4_5 o4_5 o3_5 rail4 rail4 sg13_lv_pmos w=1.12u l=0.13u
XN4_5 o4_5 o3_5 gn4 gn4 sg13_lv_nmos w=0.74u l=0.13u
CL4_5 o4_5 gn4 2f
XP4_6 o4_6 o3_6 rail4 rail4 sg13_lv_pmos w=1.12u l=0.13u
XN4_6 o4_6 o3_6 gn4 gn4 sg13_lv_nmos w=0.74u l=0.13u
CL4_6 o4_6 gn4 2f
XP4_7 o4_7 o3_7 rail4 rail4 sg13_lv_pmos w=1.12u l=0.13u
XN4_7 o4_7 o3_7 gn4 gn4 sg13_lv_nmos w=0.74u l=0.13u
CL4_7 o4_7 gn4 2f
CW1_00 o1_0 gn1 0.400000f
RW1_01 o1_0 w1_0a 2.746667
CW1_01 w1_0a gn1 0.800000f
RW1_02 w1_0a w1_0b 2.746667
CW1_02 w1_0b gn1 0.800000f
RW1_03 w1_0b w1_0c 2.746667
CW1_03 w1_0c gn1 0.400000f
CW1_10 o1_1 gn1 0.400000f
RW1_11 o1_1 w1_1a 2.746667
CW1_11 w1_1a gn1 0.800000f
RW1_12 w1_1a w1_1b 2.746667
CW1_12 w1_1b gn1 0.800000f
RW1_13 w1_1b w1_1c 2.746667
CW1_13 w1_1c gn1 0.400000f
CW1_20 o1_2 gn1 0.400000f
RW1_21 o1_2 w1_2a 2.746667
CW1_21 w1_2a gn1 0.800000f
RW1_22 w1_2a w1_2b 2.746667
CW1_22 w1_2b gn1 0.800000f
RW1_23 w1_2b w1_2c 2.746667
CW1_23 w1_2c gn1 0.400000f
CW1_30 o1_3 gn1 0.400000f
RW1_31 o1_3 w1_3a 2.746667
CW1_31 w1_3a gn1 0.800000f
RW1_32 w1_3a w1_3b 2.746667
CW1_32 w1_3b gn1 0.800000f
RW1_33 w1_3b w1_3c 2.746667
CW1_33 w1_3c gn1 0.400000f
CW1_40 o1_4 gn1 0.400000f
RW1_41 o1_4 w1_4a 2.746667
CW1_41 w1_4a gn1 0.800000f
RW1_42 w1_4a w1_4b 2.746667
CW1_42 w1_4b gn1 0.800000f
RW1_43 w1_4b w1_4c 2.746667
CW1_43 w1_4c gn1 0.400000f
CW1_50 o1_5 gn1 0.400000f
RW1_51 o1_5 w1_5a 2.746667
CW1_51 w1_5a gn1 0.800000f
RW1_52 w1_5a w1_5b 2.746667
CW1_52 w1_5b gn1 0.800000f
RW1_53 w1_5b w1_5c 2.746667
CW1_53 w1_5c gn1 0.400000f
CW1_60 o1_6 gn1 0.400000f
RW1_61 o1_6 w1_6a 2.746667
CW1_61 w1_6a gn1 0.800000f
RW1_62 w1_6a w1_6b 2.746667
CW1_62 w1_6b gn1 0.800000f
RW1_63 w1_6b w1_6c 2.746667
CW1_63 w1_6c gn1 0.400000f
CW1_70 o1_7 gn1 0.400000f
RW1_71 o1_7 w1_7a 2.746667
CW1_71 w1_7a gn1 0.800000f
RW1_72 w1_7a w1_7b 2.746667
CW1_72 w1_7b gn1 0.800000f
RW1_73 w1_7b w1_7c 2.746667
CW1_73 w1_7c gn1 0.400000f
CW2_00 o2_0 gn2 0.400000f
RW2_01 o2_0 w2_0a 2.746667
CW2_01 w2_0a gn2 0.800000f
RW2_02 w2_0a w2_0b 2.746667
CW2_02 w2_0b gn2 0.800000f
RW2_03 w2_0b w2_0c 2.746667
CW2_03 w2_0c gn2 0.400000f
CW2_10 o2_1 gn2 0.400000f
RW2_11 o2_1 w2_1a 2.746667
CW2_11 w2_1a gn2 0.800000f
RW2_12 w2_1a w2_1b 2.746667
CW2_12 w2_1b gn2 0.800000f
RW2_13 w2_1b w2_1c 2.746667
CW2_13 w2_1c gn2 0.400000f
CW2_20 o2_2 gn2 0.400000f
RW2_21 o2_2 w2_2a 2.746667
CW2_21 w2_2a gn2 0.800000f
RW2_22 w2_2a w2_2b 2.746667
CW2_22 w2_2b gn2 0.800000f
RW2_23 w2_2b w2_2c 2.746667
CW2_23 w2_2c gn2 0.400000f
CW2_30 o2_3 gn2 0.400000f
RW2_31 o2_3 w2_3a 2.746667
CW2_31 w2_3a gn2 0.800000f
RW2_32 w2_3a w2_3b 2.746667
CW2_32 w2_3b gn2 0.800000f
RW2_33 w2_3b w2_3c 2.746667
CW2_33 w2_3c gn2 0.400000f
CW2_40 o2_4 gn2 0.400000f
RW2_41 o2_4 w2_4a 2.746667
CW2_41 w2_4a gn2 0.800000f
RW2_42 w2_4a w2_4b 2.746667
CW2_42 w2_4b gn2 0.800000f
RW2_43 w2_4b w2_4c 2.746667
CW2_43 w2_4c gn2 0.400000f
CW2_50 o2_5 gn2 0.400000f
RW2_51 o2_5 w2_5a 2.746667
CW2_51 w2_5a gn2 0.800000f
RW2_52 w2_5a w2_5b 2.746667
CW2_52 w2_5b gn2 0.800000f
RW2_53 w2_5b w2_5c 2.746667
CW2_53 w2_5c gn2 0.400000f
CW2_60 o2_6 gn2 0.400000f
RW2_61 o2_6 w2_6a 2.746667
CW2_61 w2_6a gn2 0.800000f
RW2_62 w2_6a w2_6b 2.746667
CW2_62 w2_6b gn2 0.800000f
RW2_63 w2_6b w2_6c 2.746667
CW2_63 w2_6c gn2 0.400000f
CW2_70 o2_7 gn2 0.400000f
RW2_71 o2_7 w2_7a 2.746667
CW2_71 w2_7a gn2 0.800000f
RW2_72 w2_7a w2_7b 2.746667
CW2_72 w2_7b gn2 0.800000f
RW2_73 w2_7b w2_7c 2.746667
CW2_73 w2_7c gn2 0.400000f
CW3_00 o3_0 gn3 0.400000f
RW3_01 o3_0 w3_0a 2.746667
CW3_01 w3_0a gn3 0.800000f
RW3_02 w3_0a w3_0b 2.746667
CW3_02 w3_0b gn3 0.800000f
RW3_03 w3_0b w3_0c 2.746667
CW3_03 w3_0c gn3 0.400000f
CW3_10 o3_1 gn3 0.400000f
RW3_11 o3_1 w3_1a 2.746667
CW3_11 w3_1a gn3 0.800000f
RW3_12 w3_1a w3_1b 2.746667
CW3_12 w3_1b gn3 0.800000f
RW3_13 w3_1b w3_1c 2.746667
CW3_13 w3_1c gn3 0.400000f
CW3_20 o3_2 gn3 0.400000f
RW3_21 o3_2 w3_2a 2.746667
CW3_21 w3_2a gn3 0.800000f
RW3_22 w3_2a w3_2b 2.746667
CW3_22 w3_2b gn3 0.800000f
RW3_23 w3_2b w3_2c 2.746667
CW3_23 w3_2c gn3 0.400000f
CW3_30 o3_3 gn3 0.400000f
RW3_31 o3_3 w3_3a 2.746667
CW3_31 w3_3a gn3 0.800000f
RW3_32 w3_3a w3_3b 2.746667
CW3_32 w3_3b gn3 0.800000f
RW3_33 w3_3b w3_3c 2.746667
CW3_33 w3_3c gn3 0.400000f
CW3_40 o3_4 gn3 0.400000f
RW3_41 o3_4 w3_4a 2.746667
CW3_41 w3_4a gn3 0.800000f
RW3_42 w3_4a w3_4b 2.746667
CW3_42 w3_4b gn3 0.800000f
RW3_43 w3_4b w3_4c 2.746667
CW3_43 w3_4c gn3 0.400000f
CW3_50 o3_5 gn3 0.400000f
RW3_51 o3_5 w3_5a 2.746667
CW3_51 w3_5a gn3 0.800000f
RW3_52 w3_5a w3_5b 2.746667
CW3_52 w3_5b gn3 0.800000f
RW3_53 w3_5b w3_5c 2.746667
CW3_53 w3_5c gn3 0.400000f
CW3_60 o3_6 gn3 0.400000f
RW3_61 o3_6 w3_6a 2.746667
CW3_61 w3_6a gn3 0.800000f
RW3_62 w3_6a w3_6b 2.746667
CW3_62 w3_6b gn3 0.800000f
RW3_63 w3_6b w3_6c 2.746667
CW3_63 w3_6c gn3 0.400000f
CW3_70 o3_7 gn3 0.400000f
RW3_71 o3_7 w3_7a 2.746667
CW3_71 w3_7a gn3 0.800000f
RW3_72 w3_7a w3_7b 2.746667
CW3_72 w3_7b gn3 0.800000f
RW3_73 w3_7b w3_7c 2.746667
CW3_73 w3_7c gn3 0.400000f
CW4_00 o4_0 gn4 0.400000f
RW4_01 o4_0 w4_0a 2.746667
CW4_01 w4_0a gn4 0.800000f
RW4_02 w4_0a w4_0b 2.746667
CW4_02 w4_0b gn4 0.800000f
RW4_03 w4_0b w4_0c 2.746667
CW4_03 w4_0c gn4 0.400000f
CW4_10 o4_1 gn4 0.400000f
RW4_11 o4_1 w4_1a 2.746667
CW4_11 w4_1a gn4 0.800000f
RW4_12 w4_1a w4_1b 2.746667
CW4_12 w4_1b gn4 0.800000f
RW4_13 w4_1b w4_1c 2.746667
CW4_13 w4_1c gn4 0.400000f
CW4_20 o4_2 gn4 0.400000f
RW4_21 o4_2 w4_2a 2.746667
CW4_21 w4_2a gn4 0.800000f
RW4_22 w4_2a w4_2b 2.746667
CW4_22 w4_2b gn4 0.800000f
RW4_23 w4_2b w4_2c 2.746667
CW4_23 w4_2c gn4 0.400000f
CW4_30 o4_3 gn4 0.400000f
RW4_31 o4_3 w4_3a 2.746667
CW4_31 w4_3a gn4 0.800000f
RW4_32 w4_3a w4_3b 2.746667
CW4_32 w4_3b gn4 0.800000f
RW4_33 w4_3b w4_3c 2.746667
CW4_33 w4_3c gn4 0.400000f
CW4_40 o4_4 gn4 0.400000f
RW4_41 o4_4 w4_4a 2.746667
CW4_41 w4_4a gn4 0.800000f
RW4_42 w4_4a w4_4b 2.746667
CW4_42 w4_4b gn4 0.800000f
RW4_43 w4_4b w4_4c 2.746667
CW4_43 w4_4c gn4 0.400000f
CW4_50 o4_5 gn4 0.400000f
RW4_51 o4_5 w4_5a 2.746667
CW4_51 w4_5a gn4 0.800000f
RW4_52 w4_5a w4_5b 2.746667
CW4_52 w4_5b gn4 0.800000f
RW4_53 w4_5b w4_5c 2.746667
CW4_53 w4_5c gn4 0.400000f
CW4_60 o4_6 gn4 0.400000f
RW4_61 o4_6 w4_6a 2.746667
CW4_61 w4_6a gn4 0.800000f
RW4_62 w4_6a w4_6b 2.746667
CW4_62 w4_6b gn4 0.800000f
RW4_63 w4_6b w4_6c 2.746667
CW4_63 w4_6c gn4 0.400000f
CW4_70 o4_7 gn4 0.400000f
RW4_71 o4_7 w4_7a 2.746667
CW4_71 w4_7a gn4 0.800000f
RW4_72 w4_7a w4_7b 2.746667
CW4_72 w4_7b gn4 0.800000f
RW4_73 w4_7b w4_7c 2.746667
CW4_73 w4_7c gn4 0.400000f
CT1 tnk1 0 431.79f
L1 tnk1 mid1 15n
R1 mid1 sw1 10
XSWN1 sw1 gt1 rail1 0 sg13_lv_nmos w=10u l=0.13u
XSWP1 sw1 gtp1 rail1 vhi sg13_lv_pmos w=20u l=0.13u
XPK1 sw1 pk1 tnk1 tnk1 sg13_lv_nmos w=2u l=0.13u
CT2 tnk2 0 479.79f
L2 tnk2 mid2 15n
R2 mid2 sw2 10
XSWN2 sw2 gt2 rail2 0 sg13_lv_nmos w=10u l=0.13u
XSWP2 sw2 gtp2 rail2 vhi sg13_lv_pmos w=20u l=0.13u
XPK2 sw2 pk2 tnk2 tnk2 sg13_lv_nmos w=2u l=0.13u
CT3 tnk3 0 431.79f
L3 tnk3 mid3 15n
R3 mid3 sw3 10
XSWN3 sw3 gt3 rail3 0 sg13_lv_nmos w=10u l=0.13u
XSWP3 sw3 gtp3 rail3 vhi sg13_lv_pmos w=20u l=0.13u
XPK3 sw3 pk3 tnk3 tnk3 sg13_lv_nmos w=2u l=0.13u
CT4 tnk4 0 479.79f
L4 tnk4 mid4 15n
R4 mid4 sw4 10
XSWN4 sw4 gt4 rail4 0 sg13_lv_nmos w=10u l=0.13u
XSWP4 sw4 gtp4 rail4 vhi sg13_lv_pmos w=20u l=0.13u
XPK4 sw4 pk4 tnk4 tnk4 sg13_lv_nmos w=2u l=0.13u
VGT1 gt1 0 PWL(0 0 198p 0 200p 1.5 328.471p 1.5 330.471p 0)
VGTP1 gtp1 0 PWL(0 1.5 198p 1.5 200p 0 328.471p 0 330.471p 1.5)
VPK1 pk1 0 PWL(0 1.5 198p 1.5 200p 0 328.471p 0 330.471p 1.5)
VGT2 gt2 0 PWL(0 0 348p 0 350p 1.5 7261.98p 1.5)
VGTP2 gtp2 0 PWL(0 1.5 348p 1.5 350p 0 7261.98p 0)
VPK2 pk2 0 PWL(0 1.5 348p 1.5 350p 0 7261.98p 0)
VGT3 gt3 0 0
VGTP3 gtp3 0 1.5
VPK3 pk3 0 1.5
VGT4 gt4 0 0
VGTP4 gtp4 0 1.5
VPK4 pk4 0 1.5
.ic V(tnk1)=0.9075 V(rail1)=0 V(sw1)=0.9075 V(tnk2)=0.9075 V(rail2)=0 V(sw2)=0.9075 V(tnk3)=0.9075 V(rail3)=0 V(sw3)=0.9075 V(tnk4)=0.9075 V(rail4)=0 V(sw4)=0.9075
.tran 0.1p 585.782p 0 0.25p
.print tran I(L1) I(L2) I(L3) I(L4) V(rail1) V(rail2) V(rail3) V(rail4) V(tnk1) V(tnk2) V(tnk3) V(tnk4)
.end
