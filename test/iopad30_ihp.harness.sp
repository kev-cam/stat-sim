* hot-spot Xyce testbench -- real IHP sg13g2_IOPadOut30mA output driver
* generated by test/iopad30_ihp_tb.py; drives the extracted parasitics so the
* per-segment EM currents come from the transient (not an assigned budget).

* --- IO + core supplies (feed the extracted supply-net roots) ---
Viovdd iovdd 0 3.3
Viovss iovss 0 0
Vvdd vdd 0 1.2
Vvss vss 0 0

* --- output push-pull driver (Xyce-native MOS, sized to ~30 mA into the load).
*     Moderate W + soft input edges keep Xyce's timestep from collapsing. ---
.model PDRV PMOS (LEVEL=1 VTO=-0.7 KP=50u LAMBDA=0.05)
.model NDRV NMOS (LEVEL=1 VTO=0.7 KP=120u LAMBDA=0.05)
Mpu drv_o_p din iovdd_13 iovdd_13 PDRV W=800u L=0.45u
Mpd drv_o_n din iovss_9 iovss_9 NDRV W=400u L=0.45u
* metal junctions: driver drains -> pad (the split the extractor made at the FETs).
* 1 ohm (not milli-ohm) -- a sub-ohm junction makes a fs-scale RC with the wire
* caps and forces Xyce into pathologically tiny timesteps.
Rjp drv_o_p_3 pad 1
Rjn drv_o_n_3 pad 1

* --- core-side input toggling the output (100 MHz, soft 1 ns edges) ---
Vin din 0 PULSE(0 3.3 0 1n 1n 4n 10n)

* --- external load on the bond pad (drives ~30 mA when high) ---
Rload pad_13 0 110
Cload pad_13 0 1p

* --- keep undriven extracted nets from floating (ESD ring, guard, taps) ---
Rbl_iovss_gr iovss_gr 0 1g
Rbl_guard guard 0 1g
Rbl_iovdd_esd iovdd_esd 0 1g
Rbl_c2p_in c2p_in 0 1g
Rbl_nI3 nI3 0 1g
Rbl_nI4 nI4 0 1g
Rbl_nI5 nI5 0 1g
Rbl_nI6 nI6 0 1g
Rbl_nI7 nI7 0 1g
Rbl_nI8 nI8 0 1g

* bound the .prn cadence (fixed 40p output) + loosen/cap the integrator so a
* switching edge can't collapse the timestep or write a huge file.
.options OUTPUT INITIAL_INTERVAL=40p
.options TIMEINT method=trap reltol=1e-3 abstol=1e-7 delmax=100p
.tran 40p 20n
